* NGSPICE file created from photon_e05g.ext - technology: sky130A

.subckt photon_e05g DNW K EA EK GUARD CA CK
X0 CA CK sky130_fd_pr__diode_pd2nw_05v5 perim=4.8e+06 area=1.4e+12
D0 GUARD K sky130_fd_pr__model__parasitic__diode_ps2dn area=9
X1 EA EK sky130_fd_pr__diode_pd2nw_05v5 perim=4.8e+06 area=1.4e+12
.ends
