* NGSPICE file created from photon_fd_l10.ext - technology: sky130A

.subckt photon_fd_l10 DNW K A
D0 A K sky130_fd_pr__model__parasitic__diode_ps2dn area=30
.ends
