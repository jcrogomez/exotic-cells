* NGSPICE file created from efld_consR_L2.ext - technology: sky130A

.subckt efld_consR_L2 A B
R0 A B sky130_fd_pr__res_generic_l1 w=0.17 l=1.34
.ends
