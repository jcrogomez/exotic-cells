* NGSPICE file created from efld_consR_M1.ext - technology: sky130A

.subckt efld_consR_M1 A B
R0 A B sky130_fd_pr__res_generic_m1 w=0.14 l=10
.ends
