* NGSPICE file created from efld01_C.ext - technology: sky130A

.subckt efld01_C A B
R0 A B sky130_fd_pr__res_generic_m1 w=0.14 l=2.56
.ends
