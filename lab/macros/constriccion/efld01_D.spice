* NGSPICE file created from efld01_D.ext - technology: sky130A

.subckt efld01_D A B
R0 A B sky130_fd_pr__res_generic_m1 w=0.14 l=2.24
.ends
