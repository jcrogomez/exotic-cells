* NGSPICE file created from efld01c_M1.ext - technology: sky130A

.subckt efld01c_M1 A0 A1 A2 A3 A4 A5 A6 A7 A8 B0 B1 B2 B3 B4 B5 B6 B7 B8
R0 B4 B3 sky130_fd_pr__res_generic_m1 w=1.2 l=0.2
R1 A2 A1 sky130_fd_pr__res_generic_m1 w=1.2 l=0.2
R2 B7 B6 sky130_fd_pr__res_generic_m1 w=1.2 l=0.2
R3 A5 A4 sky130_fd_pr__res_generic_m1 w=1.2 l=0.2
R4 A1 A0 sky130_fd_pr__res_generic_m1 w=1.2 l=0.2
R5 A8 B8 sky130_fd_pr__res_generic_m1 w=0.14 l=10
R6 A8 A7 sky130_fd_pr__res_generic_m1 w=1.2 l=0.2
R7 B3 B2 sky130_fd_pr__res_generic_m1 w=1.2 l=0.2
R8 B6 B5 sky130_fd_pr__res_generic_m1 w=1.2 l=0.2
R9 A4 A3 sky130_fd_pr__res_generic_m1 w=1.2 l=0.2
R10 A7 A6 sky130_fd_pr__res_generic_m1 w=1.2 l=0.2
R11 B2 B1 sky130_fd_pr__res_generic_m1 w=1.2 l=0.2
R12 B1 B0 sky130_fd_pr__res_generic_m1 w=1.2 l=0.2
R13 B5 B4 sky130_fd_pr__res_generic_m1 w=1.2 l=0.2
R14 A3 A2 sky130_fd_pr__res_generic_m1 w=1.2 l=0.2
R15 B8 B7 sky130_fd_pr__res_generic_m1 w=1.2 l=0.2
R16 A6 A5 sky130_fd_pr__res_generic_m1 w=1.2 l=0.2
.ends
