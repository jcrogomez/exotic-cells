* NGSPICE file created from misfit_tcell.ext - technology: sky130A

.subckt misfit_tcell PRE XA XB VGND VPWR
X0 XB.t1 a_2934_297.t2 VPWR.t9 VPWR.t8 sky130_fd_pr__pfet_01v8 ad=0.58 pd=3.16 as=0.58 ps=3.16 w=1 l=0.5
X1 a_2934_297.t1 a_n4720_214.t2 VPWR.t5 VPWR.t4 sky130_fd_pr__pfet_01v8 ad=0.58 pd=3.16 as=0.58 ps=3.16 w=1 l=0.5
X2 XA.t1 a_n2320_n2676.t2 VGND.t18 VGND.t17 sky130_fd_pr__nfet_01v8 ad=0.377 pd=2.46 as=0.377 ps=2.46 w=0.65 l=0.5
X3 VGND.t16 a_n2320_n2676.t3 VGND.t15 VGND.t14 sky130_fd_pr__nfet_01v8 ad=6 pd=25 as=0 ps=0 w=12 l=12
X4 VGND.t3 a_n4720_214.t3 a_2934_297.t0 VGND.t2 sky130_fd_pr__nfet_01v8 ad=0.21 pd=1.84 as=0.21 ps=1.84 w=0.42 l=24
X5 a_n4720_214.t1 PRE.t0 VGND.t5 VGND.t4 sky130_fd_pr__nfet_01v8 ad=0.377 pd=2.46 as=0.377 ps=2.46 w=0.65 l=0.5
X6 a_n4720_214.t0 PRE.t1 VPWR.t3 VPWR.t2 sky130_fd_pr__pfet_01v8 ad=0.58 pd=3.16 as=0.58 ps=3.16 w=1 l=0.5
X7 XB.t0 a_2934_297.t3 VGND.t10 VGND.t9 sky130_fd_pr__nfet_01v8 ad=0.377 pd=2.46 as=0.377 ps=2.46 w=0.65 l=0.5
X8 a_n2320_n2676.t0 a_n4720_214.t4 VGND.t1 VGND.t0 sky130_fd_pr__nfet_01v8 ad=0.21 pd=1.84 as=0.21 ps=1.84 w=0.42 l=24
X9 XA.t0 a_n2320_n2676.t4 VPWR.t1 VPWR.t0 sky130_fd_pr__pfet_01v8 ad=0.58 pd=3.16 as=0.58 ps=3.16 w=1 l=0.5
X10 a_n2320_n2676.t1 a_n4720_214.t5 VPWR.t7 VPWR.t6 sky130_fd_pr__pfet_01v8 ad=0.58 pd=3.16 as=0.58 ps=3.16 w=1 l=0.5
X11 VGND.t13 a_2934_297.t4 VGND.t12 VGND.t11 sky130_fd_pr__nfet_01v8 ad=6 pd=25 as=0 ps=0 w=12 l=12
X12 VGND.t8 a_2934_297.t5 VGND.t7 VGND.t6 sky130_fd_pr__nfet_01v8 ad=6 pd=25 as=0 ps=0 w=12 l=12
R0 a_2934_297.n0 a_2934_297.t5 773.433
R1 a_2934_297.n2 a_2934_297.t1 385.695
R2 a_2934_297.n3 a_2934_297.n0 335.942
R3 a_2934_297.n2 a_2934_297.n1 268.695
R4 a_2934_297.t0 a_2934_297.n3 264.154
R5 a_2934_297.n0 a_2934_297.t4 176.101
R6 a_2934_297.n1 a_2934_297.t2 79.0485
R7 a_2934_297.n1 a_2934_297.t3 58.3225
R8 a_2934_297.n3 a_2934_297.n2 11.2616
R9 VPWR.n34 VPWR.t8 1331.78
R10 VPWR.n35 VPWR.t4 1331.78
R11 VPWR.n36 VPWR.t0 1331.78
R12 VPWR.n37 VPWR.t6 1331.78
R13 VPWR.n20 VPWR.t8 1085.02
R14 VPWR.t4 VPWR.n34 846.418
R15 VPWR.t0 VPWR.n35 846.418
R16 VPWR.t6 VPWR.n36 846.418
R17 VPWR.n37 VPWR.t2 846.418
R18 VPWR.n39 VPWR.t3 416.952
R19 VPWR.n14 VPWR.t7 406.81
R20 VPWR.n8 VPWR.t1 406.81
R21 VPWR.n2 VPWR.t5 406.81
R22 VPWR.n19 VPWR.t9 406.81
R23 VPWR.n34 VPWR.n33 226.067
R24 VPWR.n35 VPWR.n5 226.067
R25 VPWR.n36 VPWR.n11 226.067
R26 VPWR.n38 VPWR.n37 226.067
R27 VPWR.n20 VPWR.n19 36.5671
R28 VPWR.n23 VPWR.n22 34.6358
R29 VPWR.n24 VPWR.n23 34.6358
R30 VPWR.n24 VPWR.n16 34.6358
R31 VPWR.n32 VPWR.n17 34.6358
R32 VPWR.n28 VPWR.n17 34.6358
R33 VPWR.n28 VPWR.n27 34.6358
R34 VPWR.n68 VPWR.n67 34.6358
R35 VPWR.n67 VPWR.n66 34.6358
R36 VPWR.n66 VPWR.n3 34.6358
R37 VPWR.n62 VPWR.n61 34.6358
R38 VPWR.n61 VPWR.n60 34.6358
R39 VPWR.n60 VPWR.n6 34.6358
R40 VPWR.n56 VPWR.n55 34.6358
R41 VPWR.n55 VPWR.n54 34.6358
R42 VPWR.n54 VPWR.n9 34.6358
R43 VPWR.n50 VPWR.n49 34.6358
R44 VPWR.n49 VPWR.n48 34.6358
R45 VPWR.n48 VPWR.n12 34.6358
R46 VPWR.n44 VPWR.n43 34.6358
R47 VPWR.n43 VPWR.n42 34.6358
R48 VPWR.n42 VPWR.n15 34.6358
R49 VPWR.n27 VPWR.n2 28.9887
R50 VPWR.n8 VPWR.n6 28.9887
R51 VPWR.n14 VPWR.n12 28.9887
R52 VPWR.n39 VPWR.n38 28.6695
R53 VPWR.n33 VPWR.n32 21.0829
R54 VPWR.n62 VPWR.n5 21.0829
R55 VPWR.n50 VPWR.n11 21.0829
R56 VPWR.n33 VPWR.n16 13.5534
R57 VPWR.n5 VPWR.n3 13.5534
R58 VPWR.n11 VPWR.n9 13.5534
R59 VPWR.n38 VPWR.n15 13.5534
R60 VPWR VPWR.n70 11.4885
R61 VPWR.n22 VPWR.n21 9.3005
R62 VPWR.n23 VPWR.n18 9.3005
R63 VPWR.n25 VPWR.n24 9.3005
R64 VPWR.n26 VPWR.n16 9.3005
R65 VPWR.n32 VPWR.n31 9.3005
R66 VPWR.n30 VPWR.n17 9.3005
R67 VPWR.n29 VPWR.n28 9.3005
R68 VPWR.n27 VPWR.n0 9.3005
R69 VPWR.n69 VPWR.n68 9.3005
R70 VPWR.n67 VPWR.n1 9.3005
R71 VPWR.n66 VPWR.n65 9.3005
R72 VPWR.n64 VPWR.n3 9.3005
R73 VPWR.n63 VPWR.n62 9.3005
R74 VPWR.n61 VPWR.n4 9.3005
R75 VPWR.n60 VPWR.n59 9.3005
R76 VPWR.n58 VPWR.n6 9.3005
R77 VPWR.n57 VPWR.n56 9.3005
R78 VPWR.n55 VPWR.n7 9.3005
R79 VPWR.n54 VPWR.n53 9.3005
R80 VPWR.n52 VPWR.n9 9.3005
R81 VPWR.n51 VPWR.n50 9.3005
R82 VPWR.n49 VPWR.n10 9.3005
R83 VPWR.n48 VPWR.n47 9.3005
R84 VPWR.n46 VPWR.n12 9.3005
R85 VPWR.n45 VPWR.n44 9.3005
R86 VPWR.n43 VPWR.n13 9.3005
R87 VPWR.n42 VPWR.n41 9.3005
R88 VPWR.n40 VPWR.n15 9.3005
R89 VPWR.n22 VPWR.n19 5.64756
R90 VPWR.n68 VPWR.n2 5.64756
R91 VPWR.n56 VPWR.n8 5.64756
R92 VPWR.n44 VPWR.n14 5.64756
R93 VPWR.n21 VPWR.n20 0.169397
R94 VPWR.n40 VPWR.n39 0.161117
R95 VPWR.n21 VPWR.n18 0.120292
R96 VPWR.n25 VPWR.n18 0.120292
R97 VPWR.n26 VPWR.n25 0.120292
R98 VPWR.n31 VPWR.n26 0.120292
R99 VPWR.n31 VPWR.n30 0.120292
R100 VPWR.n30 VPWR.n29 0.120292
R101 VPWR.n29 VPWR.n0 0.120292
R102 VPWR.n69 VPWR.n1 0.120292
R103 VPWR.n65 VPWR.n1 0.120292
R104 VPWR.n65 VPWR.n64 0.120292
R105 VPWR.n64 VPWR.n63 0.120292
R106 VPWR.n63 VPWR.n4 0.120292
R107 VPWR.n59 VPWR.n4 0.120292
R108 VPWR.n59 VPWR.n58 0.120292
R109 VPWR.n58 VPWR.n57 0.120292
R110 VPWR.n57 VPWR.n7 0.120292
R111 VPWR.n53 VPWR.n7 0.120292
R112 VPWR.n53 VPWR.n52 0.120292
R113 VPWR.n52 VPWR.n51 0.120292
R114 VPWR.n51 VPWR.n10 0.120292
R115 VPWR.n47 VPWR.n10 0.120292
R116 VPWR.n47 VPWR.n46 0.120292
R117 VPWR.n46 VPWR.n45 0.120292
R118 VPWR.n45 VPWR.n13 0.120292
R119 VPWR.n41 VPWR.n13 0.120292
R120 VPWR.n41 VPWR.n40 0.120292
R121 VPWR.n70 VPWR.n0 0.102062
R122 VPWR.n70 VPWR.n69 0.0187292
R123 XB.n0 XB.t1 420.363
R124 XB.n0 XB.t0 297.185
R125 XB XB.n0 15.0303
R126 a_n4720_214.n0 a_n4720_214.t3 1214.42
R127 a_n4720_214.n2 a_n4720_214.t4 1212.32
R128 a_n4720_214.t0 a_n4720_214.n3 462.151
R129 a_n4720_214.n0 a_n4720_214.t2 347.726
R130 a_n4720_214.n1 a_n4720_214.t5 347.726
R131 a_n4720_214.n3 a_n4720_214.t1 255.397
R132 a_n4720_214.n3 a_n4720_214.n2 9.3005
R133 a_n4720_214.n1 a_n4720_214.n0 3.06717
R134 a_n4720_214.n2 a_n4720_214.n1 0.83175
R135 a_n2320_n2676.n2 a_n2320_n2676.t3 512.043
R136 a_n2320_n2676.n1 a_n2320_n2676.t1 384.863
R137 a_n2320_n2676.n1 a_n2320_n2676.n0 269.526
R138 a_n2320_n2676.t0 a_n2320_n2676.n2 264.154
R139 a_n2320_n2676.n0 a_n2320_n2676.t4 79.0485
R140 a_n2320_n2676.n0 a_n2320_n2676.t2 58.3225
R141 a_n2320_n2676.n2 a_n2320_n2676.n1 12.222
R142 VGND.n89 VGND.n88 31904.2
R143 VGND.t0 VGND.n93 4002.98
R144 VGND.n11 VGND.n10 1536.15
R145 VGND.n98 VGND.n90 1221.2
R146 VGND.n21 VGND.n7 1221.2
R147 VGND.n45 VGND.n38 1205.01
R148 VGND.n59 VGND.n32 1205.01
R149 VGND.n72 VGND.n27 1205.01
R150 VGND.n87 VGND.n86 1205.01
R151 VGND.n37 VGND.n5 1205.01
R152 VGND.n96 VGND.n95 1170
R153 VGND.n94 VGND.n91 1170
R154 VGND.n12 VGND.n11 1170
R155 VGND.n16 VGND.n15 1170
R156 VGND.n17 VGND.n8 1170
R157 VGND.n19 VGND.n18 1170
R158 VGND.n93 VGND.n92 1109.99
R159 VGND.n32 VGND.n27 991.246
R160 VGND.n38 VGND.n37 991.246
R161 VGND.t2 VGND.n16 966.587
R162 VGND.n95 VGND.n90 752.265
R163 VGND.t14 VGND.n94 752.265
R164 VGND.n11 VGND.t6 752.265
R165 VGND.t11 VGND.n17 752.265
R166 VGND.n18 VGND.n7 752.265
R167 VGND.n95 VGND.t14 747.98
R168 VGND.n16 VGND.t6 747.98
R169 VGND.n18 VGND.t11 747.98
R170 VGND.n98 VGND.n97 640.428
R171 VGND.n21 VGND.n20 640.428
R172 VGND.n10 VGND.n9 612.073
R173 VGND.n27 VGND.t9 606.062
R174 VGND.n38 VGND.t17 606.062
R175 VGND.n94 VGND.t0 533.659
R176 VGND.n17 VGND.t2 533.659
R177 VGND.n89 VGND.t4 422.897
R178 VGND.n87 VGND.t9 385.185
R179 VGND.t17 VGND.n32 385.185
R180 VGND.n37 VGND.t4 385.185
R181 VGND.n96 VGND.n91 298.668
R182 VGND.n19 VGND.n8 298.668
R183 VGND.n15 VGND.n12 298.668
R184 VGND.n79 VGND.t10 288.149
R185 VGND.n52 VGND.t18 288.149
R186 VGND.n99 VGND.t5 288.149
R187 VGND.n88 VGND.n87 285.522
R188 VGND.n93 VGND.t1 263.572
R189 VGND.n10 VGND.t3 263.572
R190 VGND.n9 VGND.t7 184.733
R191 VGND.n92 VGND.t16 113.481
R192 VGND.n97 VGND.t15 113.481
R193 VGND.n20 VGND.t13 113.481
R194 VGND.n13 VGND.t12 113.481
R195 VGND.n14 VGND.t8 113.481
R196 VGND.n97 VGND.n96 111.787
R197 VGND.n20 VGND.n19 111.787
R198 VGND.n15 VGND.n14 111.787
R199 VGND.n92 VGND.n91 110.933
R200 VGND.n13 VGND.n8 110.933
R201 VGND.n90 VGND.n89 87.8719
R202 VGND.n88 VGND.n7 87.8719
R203 VGND.n22 VGND.n21 57.3158
R204 VGND.n100 VGND.n98 57.3158
R205 VGND.n14 VGND.n13 47.7872
R206 VGND.n85 VGND.n23 34.6358
R207 VGND.n81 VGND.n23 34.6358
R208 VGND.n81 VGND.n80 34.6358
R209 VGND.n78 VGND.n25 34.6358
R210 VGND.n74 VGND.n25 34.6358
R211 VGND.n74 VGND.n73 34.6358
R212 VGND.n71 VGND.n28 34.6358
R213 VGND.n67 VGND.n28 34.6358
R214 VGND.n67 VGND.n66 34.6358
R215 VGND.n66 VGND.n65 34.6358
R216 VGND.n65 VGND.n30 34.6358
R217 VGND.n61 VGND.n30 34.6358
R218 VGND.n61 VGND.n60 34.6358
R219 VGND.n58 VGND.n33 34.6358
R220 VGND.n54 VGND.n33 34.6358
R221 VGND.n54 VGND.n53 34.6358
R222 VGND.n51 VGND.n35 34.6358
R223 VGND.n47 VGND.n35 34.6358
R224 VGND.n47 VGND.n46 34.6358
R225 VGND.n44 VGND.n39 34.6358
R226 VGND.n40 VGND.n39 34.6358
R227 VGND.n40 VGND.n2 34.6358
R228 VGND.n111 VGND.n2 34.6358
R229 VGND.n111 VGND.n110 34.6358
R230 VGND.n110 VGND.n109 34.6358
R231 VGND.n109 VGND.n3 34.6358
R232 VGND.n105 VGND.n104 34.6358
R233 VGND.n104 VGND.n103 34.6358
R234 VGND.n103 VGND.n6 34.6358
R235 VGND.n80 VGND.n79 28.9887
R236 VGND.n53 VGND.n52 28.9887
R237 VGND.n99 VGND.n6 28.9887
R238 VGND.n12 VGND.n9 25.6005
R239 VGND.n86 VGND.n85 21.0829
R240 VGND.n72 VGND.n71 21.0829
R241 VGND.n59 VGND.n58 21.0829
R242 VGND.n45 VGND.n44 21.0829
R243 VGND.n105 VGND.n5 21.0829
R244 VGND.n86 VGND.n22 19.591
R245 VGND.n73 VGND.n72 13.5534
R246 VGND.n60 VGND.n59 13.5534
R247 VGND.n46 VGND.n45 13.5534
R248 VGND.n5 VGND.n3 13.5534
R249 VGND.n100 VGND.n99 11.6851
R250 VGND VGND.n113 11.4086
R251 VGND.n85 VGND.n84 9.3005
R252 VGND.n83 VGND.n23 9.3005
R253 VGND.n82 VGND.n81 9.3005
R254 VGND.n80 VGND.n24 9.3005
R255 VGND.n78 VGND.n77 9.3005
R256 VGND.n76 VGND.n25 9.3005
R257 VGND.n75 VGND.n74 9.3005
R258 VGND.n73 VGND.n26 9.3005
R259 VGND.n71 VGND.n70 9.3005
R260 VGND.n69 VGND.n28 9.3005
R261 VGND.n68 VGND.n67 9.3005
R262 VGND.n66 VGND.n29 9.3005
R263 VGND.n65 VGND.n64 9.3005
R264 VGND.n63 VGND.n30 9.3005
R265 VGND.n62 VGND.n61 9.3005
R266 VGND.n60 VGND.n31 9.3005
R267 VGND.n58 VGND.n57 9.3005
R268 VGND.n56 VGND.n33 9.3005
R269 VGND.n55 VGND.n54 9.3005
R270 VGND.n53 VGND.n34 9.3005
R271 VGND.n51 VGND.n50 9.3005
R272 VGND.n49 VGND.n35 9.3005
R273 VGND.n48 VGND.n47 9.3005
R274 VGND.n46 VGND.n36 9.3005
R275 VGND.n44 VGND.n43 9.3005
R276 VGND.n42 VGND.n39 9.3005
R277 VGND.n41 VGND.n40 9.3005
R278 VGND.n2 VGND.n0 9.3005
R279 VGND.n112 VGND.n111 9.3005
R280 VGND.n110 VGND.n1 9.3005
R281 VGND.n109 VGND.n108 9.3005
R282 VGND.n107 VGND.n3 9.3005
R283 VGND.n106 VGND.n105 9.3005
R284 VGND.n104 VGND.n4 9.3005
R285 VGND.n103 VGND.n102 9.3005
R286 VGND.n101 VGND.n6 9.3005
R287 VGND.n79 VGND.n78 5.64756
R288 VGND.n52 VGND.n51 5.64756
R289 VGND.n84 VGND.n22 1.7627
R290 VGND.n101 VGND.n100 1.7627
R291 VGND.n84 VGND.n83 0.120292
R292 VGND.n83 VGND.n82 0.120292
R293 VGND.n82 VGND.n24 0.120292
R294 VGND.n77 VGND.n24 0.120292
R295 VGND.n77 VGND.n76 0.120292
R296 VGND.n76 VGND.n75 0.120292
R297 VGND.n75 VGND.n26 0.120292
R298 VGND.n70 VGND.n26 0.120292
R299 VGND.n70 VGND.n69 0.120292
R300 VGND.n69 VGND.n68 0.120292
R301 VGND.n68 VGND.n29 0.120292
R302 VGND.n64 VGND.n29 0.120292
R303 VGND.n64 VGND.n63 0.120292
R304 VGND.n63 VGND.n62 0.120292
R305 VGND.n62 VGND.n31 0.120292
R306 VGND.n57 VGND.n31 0.120292
R307 VGND.n57 VGND.n56 0.120292
R308 VGND.n56 VGND.n55 0.120292
R309 VGND.n55 VGND.n34 0.120292
R310 VGND.n50 VGND.n34 0.120292
R311 VGND.n50 VGND.n49 0.120292
R312 VGND.n49 VGND.n48 0.120292
R313 VGND.n48 VGND.n36 0.120292
R314 VGND.n43 VGND.n36 0.120292
R315 VGND.n43 VGND.n42 0.120292
R316 VGND.n42 VGND.n41 0.120292
R317 VGND.n41 VGND.n0 0.120292
R318 VGND.n112 VGND.n1 0.120292
R319 VGND.n108 VGND.n1 0.120292
R320 VGND.n108 VGND.n107 0.120292
R321 VGND.n107 VGND.n106 0.120292
R322 VGND.n106 VGND.n4 0.120292
R323 VGND.n102 VGND.n4 0.120292
R324 VGND.n102 VGND.n101 0.120292
R325 VGND.n113 VGND.n112 0.0734167
R326 VGND.n113 VGND.n0 0.047375
R327 XA.n0 XA.t0 420.363
R328 XA.n0 XA.t1 297.185
R329 XA XA.n0 15.0303
R330 PRE PRE.n0 274.24
R331 PRE.n0 PRE.t1 79.0485
R332 PRE.n0 PRE.t0 58.3225
C0 VPWR XB 0.26645f
C1 VPWR XA 0.33771f
C2 PRE XA 0
C3 PRE VPWR 0.28618f
C4 XA XB 0.02718f
C5 XB VGND 0.3759f
C6 XA VGND 0.35539f
C7 PRE VGND 0.7671f
C8 VPWR VGND 6.34449f
.ends
