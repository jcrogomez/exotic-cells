* NGSPICE file created from tt_um_misfit01b.ext - technology: sky130A

.subckt misfit_inv_m4 A Y VGND VPWR
X0 Y A VPWR VPWR sky130_fd_pr__pfet_01v8 ad=0.58 pd=3.16 as=0.58 ps=3.16 w=1 l=0.5
X1 Y A VGND VGND sky130_fd_pr__nfet_01v8 ad=0.377 pd=2.46 as=0.377 ps=2.46 w=0.65 l=0.5
C0 A VPWR 0.20345f
C1 Y VPWR 0.4922f
C2 Y A 0.0378f
C3 Y VGND 0.57936f
C4 A VGND 0.73029f
C5 VPWR VGND 3.04484f
.ends

.subckt sky130_fd_sc_hd__decap_3 VPWR VGND VPB VNB
X0 VPWR VGND VPWR VPB sky130_fd_pr__pfet_01v8_hvt ad=0.2262 pd=2.26 as=0.4524 ps=4.52 w=0.87 l=0.59
X1 VGND VPWR VGND VNB sky130_fd_pr__nfet_01v8 ad=0.143 pd=1.62 as=0.286 ps=3.24 w=0.55 l=0.59
C0 VPWR VPB 0.0625f
C1 VGND VPB 0.07966f
C2 VGND VPWR 0.353f
C3 VPWR VNB 0.46997f
C4 VGND VNB 0.42732f
C5 VPB VNB 0.33898f
.ends

.subckt sky130_fd_sc_hd__conb_1 LO HI VPB VNB VGND VPWR
X0 VPWR HI sky130_fd_pr__res_generic_po w=0.48 l=0.045
X1 LO VGND sky130_fd_pr__res_generic_po w=0.48 l=0.045
C0 LO VGND 0.06047f
C1 VPWR VPB 0.15785f
C2 HI VGND 0.2068f
C3 HI LO 0.06827f
C4 VPWR VGND 0.03175f
C5 VGND VPB 0.00479f
C6 VPWR LO 0.2409f
C7 LO VPB 0.13388f
C8 VPWR HI 0.07264f
C9 HI VPB 0.00473f
C10 VGND VNB 0.40596f
C11 LO VNB 0.1658f
C12 HI VNB 0.24957f
C13 VPWR VNB 0.29709f
C14 VPB VNB 0.33898f
.ends

.subckt sky130_fd_sc_hd__buf_2 VPWR VGND X A VPB VNB a_27_47#
X0 VPWR a_27_47# X VPB sky130_fd_pr__pfet_01v8_hvt ad=0.265 pd=2.53 as=0.135 ps=1.27 w=1 l=0.15
X1 X a_27_47# VPWR VPB sky130_fd_pr__pfet_01v8_hvt ad=0.135 pd=1.27 as=0.149 ps=1.325 w=1 l=0.15
X2 VPWR A a_27_47# VPB sky130_fd_pr__pfet_01v8_hvt ad=0.149 pd=1.325 as=0.1664 ps=1.8 w=0.64 l=0.15
X3 X a_27_47# VGND VNB sky130_fd_pr__nfet_01v8 ad=0.08775 pd=0.92 as=0.097 ps=0.975 w=0.65 l=0.15
X4 VGND a_27_47# X VNB sky130_fd_pr__nfet_01v8 ad=0.17225 pd=1.83 as=0.08775 ps=0.92 w=0.65 l=0.15
X5 VGND A a_27_47# VNB sky130_fd_pr__nfet_01v8 ad=0.097 pd=0.975 as=0.1092 ps=1.36 w=0.42 l=0.15
C0 X VGND 0.11126f
C1 a_27_47# VGND 0.12719f
C2 VPB VGND 0.00642f
C3 VPWR VGND 0.05175f
C4 a_27_47# X 0.14879f
C5 VPB X 0.00443f
C6 a_27_47# VPB 0.07497f
C7 A VGND 0.01989f
C8 VPWR X 0.16899f
C9 a_27_47# VPWR 0.1533f
C10 VPB VPWR 0.05279f
C11 A X 0.00306f
C12 a_27_47# A 0.15787f
C13 VPB A 0.06973f
C14 A VPWR 0.02211f
C15 VGND VNB 0.28418f
C16 X VNB 0.0215f
C17 VPWR VNB 0.24963f
C18 A VNB 0.18747f
C19 VPB VNB 0.42757f
C20 a_27_47# VNB 0.28447f
.ends

.subckt sky130_fd_sc_hd__clkbuf_16 VNB VPB VGND VPWR A X a_110_47#
X0 VPWR A a_110_47# VPB sky130_fd_pr__pfet_01v8_hvt ad=0.14 pd=1.28 as=0.14 ps=1.28 w=1 l=0.15
X1 VPWR a_110_47# X VPB sky130_fd_pr__pfet_01v8_hvt ad=0.14 pd=1.28 as=0.14 ps=1.28 w=1 l=0.15
X2 X a_110_47# VPWR VPB sky130_fd_pr__pfet_01v8_hvt ad=0.14 pd=1.28 as=0.14 ps=1.28 w=1 l=0.15
X3 X a_110_47# VPWR VPB sky130_fd_pr__pfet_01v8_hvt ad=0.14 pd=1.28 as=0.14 ps=1.28 w=1 l=0.15
X4 VPWR a_110_47# X VPB sky130_fd_pr__pfet_01v8_hvt ad=0.14 pd=1.28 as=0.14 ps=1.28 w=1 l=0.15
X5 VPWR a_110_47# X VPB sky130_fd_pr__pfet_01v8_hvt ad=0.265 pd=2.53 as=0.14 ps=1.28 w=1 l=0.15
X6 a_110_47# A VPWR VPB sky130_fd_pr__pfet_01v8_hvt ad=0.14 pd=1.28 as=0.265 ps=2.53 w=1 l=0.15
X7 a_110_47# A VGND VNB sky130_fd_pr__nfet_01v8 ad=0.0588 pd=0.7 as=0.0588 ps=0.7 w=0.42 l=0.15
X8 VGND a_110_47# X VNB sky130_fd_pr__nfet_01v8 ad=0.0588 pd=0.7 as=0.0588 ps=0.7 w=0.42 l=0.15
X9 X a_110_47# VGND VNB sky130_fd_pr__nfet_01v8 ad=0.0588 pd=0.7 as=0.0588 ps=0.7 w=0.42 l=0.15
X10 VGND a_110_47# X VNB sky130_fd_pr__nfet_01v8 ad=0.0588 pd=0.7 as=0.0588 ps=0.7 w=0.42 l=0.15
X11 a_110_47# A VPWR VPB sky130_fd_pr__pfet_01v8_hvt ad=0.14 pd=1.28 as=0.14 ps=1.28 w=1 l=0.15
X12 VGND A a_110_47# VNB sky130_fd_pr__nfet_01v8 ad=0.0588 pd=0.7 as=0.0588 ps=0.7 w=0.42 l=0.15
X13 VGND a_110_47# X VNB sky130_fd_pr__nfet_01v8 ad=0.05775 pd=0.695 as=0.0588 ps=0.7 w=0.42 l=0.15
X14 VPWR a_110_47# X VPB sky130_fd_pr__pfet_01v8_hvt ad=0.14 pd=1.28 as=0.14 ps=1.28 w=1 l=0.15
X15 X a_110_47# VPWR VPB sky130_fd_pr__pfet_01v8_hvt ad=0.14 pd=1.28 as=0.14 ps=1.28 w=1 l=0.15
X16 VGND A a_110_47# VNB sky130_fd_pr__nfet_01v8 ad=0.0588 pd=0.7 as=0.0588 ps=0.7 w=0.42 l=0.15
X17 VGND a_110_47# X VNB sky130_fd_pr__nfet_01v8 ad=0.1113 pd=1.37 as=0.0588 ps=0.7 w=0.42 l=0.15
X18 VPWR a_110_47# X VPB sky130_fd_pr__pfet_01v8_hvt ad=0.1375 pd=1.275 as=0.14 ps=1.28 w=1 l=0.15
X19 VGND a_110_47# X VNB sky130_fd_pr__nfet_01v8 ad=0.0588 pd=0.7 as=0.0588 ps=0.7 w=0.42 l=0.15
X20 X a_110_47# VPWR VPB sky130_fd_pr__pfet_01v8_hvt ad=0.14 pd=1.28 as=0.1375 ps=1.275 w=1 l=0.15
X21 a_110_47# A VGND VNB sky130_fd_pr__nfet_01v8 ad=0.0588 pd=0.7 as=0.1113 ps=1.37 w=0.42 l=0.15
X22 VPWR A a_110_47# VPB sky130_fd_pr__pfet_01v8_hvt ad=0.14 pd=1.28 as=0.14 ps=1.28 w=1 l=0.15
X23 VPWR a_110_47# X VPB sky130_fd_pr__pfet_01v8_hvt ad=0.14 pd=1.28 as=0.14 ps=1.28 w=1 l=0.15
X24 VPWR a_110_47# X VPB sky130_fd_pr__pfet_01v8_hvt ad=0.14 pd=1.28 as=0.14 ps=1.28 w=1 l=0.15
X25 VGND a_110_47# X VNB sky130_fd_pr__nfet_01v8 ad=0.0588 pd=0.7 as=0.0588 ps=0.7 w=0.42 l=0.15
X26 X a_110_47# VPWR VPB sky130_fd_pr__pfet_01v8_hvt ad=0.14 pd=1.28 as=0.14 ps=1.28 w=1 l=0.15
X27 VGND a_110_47# X VNB sky130_fd_pr__nfet_01v8 ad=0.0588 pd=0.7 as=0.0588 ps=0.7 w=0.42 l=0.15
X28 VGND a_110_47# X VNB sky130_fd_pr__nfet_01v8 ad=0.0588 pd=0.7 as=0.0588 ps=0.7 w=0.42 l=0.15
X29 X a_110_47# VGND VNB sky130_fd_pr__nfet_01v8 ad=0.0588 pd=0.7 as=0.0588 ps=0.7 w=0.42 l=0.15
X30 X a_110_47# VPWR VPB sky130_fd_pr__pfet_01v8_hvt ad=0.14 pd=1.28 as=0.14 ps=1.28 w=1 l=0.15
X31 X a_110_47# VPWR VPB sky130_fd_pr__pfet_01v8_hvt ad=0.14 pd=1.28 as=0.14 ps=1.28 w=1 l=0.15
X32 X a_110_47# VGND VNB sky130_fd_pr__nfet_01v8 ad=0.0588 pd=0.7 as=0.0588 ps=0.7 w=0.42 l=0.15
X33 VPWR a_110_47# X VPB sky130_fd_pr__pfet_01v8_hvt ad=0.14 pd=1.28 as=0.14 ps=1.28 w=1 l=0.15
X34 X a_110_47# VPWR VPB sky130_fd_pr__pfet_01v8_hvt ad=0.14 pd=1.28 as=0.14 ps=1.28 w=1 l=0.15
X35 X a_110_47# VGND VNB sky130_fd_pr__nfet_01v8 ad=0.0588 pd=0.7 as=0.0588 ps=0.7 w=0.42 l=0.15
X36 X a_110_47# VGND VNB sky130_fd_pr__nfet_01v8 ad=0.0588 pd=0.7 as=0.0588 ps=0.7 w=0.42 l=0.15
X37 X a_110_47# VGND VNB sky130_fd_pr__nfet_01v8 ad=0.0588 pd=0.7 as=0.0588 ps=0.7 w=0.42 l=0.15
X38 X a_110_47# VGND VNB sky130_fd_pr__nfet_01v8 ad=0.0588 pd=0.7 as=0.0588 ps=0.7 w=0.42 l=0.15
X39 X a_110_47# VGND VNB sky130_fd_pr__nfet_01v8 ad=0.0588 pd=0.7 as=0.05775 ps=0.695 w=0.42 l=0.15
C0 X VGND 0.97688f
C1 a_110_47# VGND 0.51239f
C2 VPB VGND 0.01139f
C3 VPWR VGND 0.18736f
C4 a_110_47# X 1.62234f
C5 VPB X 0.03148f
C6 a_110_47# VPB 0.52756f
C7 A VGND 0.11535f
C8 VPWR X 1.36494f
C9 a_110_47# VPWR 0.66998f
C10 VPB VPWR 0.18386f
C11 A X 0.00292f
C12 a_110_47# A 0.30658f
C13 VPB A 0.1334f
C14 A VPWR 0.11164f
C15 VGND VNB 1.01442f
C16 X VNB 0.11058f
C17 VPWR VNB 0.83479f
C18 A VNB 0.49473f
C19 VPB VNB 1.84511f
C20 a_110_47# VNB 1.73295f
.ends

.subckt sky130_fd_sc_hd__clkdlybuf4s25_1 VNB VPB VPWR VGND A X a_244_47# a_355_47#
+ a_27_47#
X0 a_244_47# a_27_47# VPWR VPB sky130_fd_pr__pfet_01v8_hvt ad=0.2173 pd=2.17 as=0.19265 ps=1.415 w=0.82 l=0.25
X1 VPWR a_244_47# a_355_47# VPB sky130_fd_pr__pfet_01v8_hvt ad=0.2726 pd=1.61 as=0.2173 ps=2.17 w=0.82 l=0.25
X2 X a_355_47# VPWR VPB sky130_fd_pr__pfet_01v8_hvt ad=0.495 pd=2.99 as=0.2726 ps=1.61 w=1 l=0.15
X3 VPWR A a_27_47# VPB sky130_fd_pr__pfet_01v8_hvt ad=0.19265 pd=1.415 as=0.27 ps=2.54 w=1 l=0.15
X4 VGND A a_27_47# VNB sky130_fd_pr__nfet_01v8 ad=0.1228 pd=1.065 as=0.1134 ps=1.38 w=0.42 l=0.15
X5 VGND a_244_47# a_355_47# VNB sky130_fd_pr__nfet_01v8 ad=0.1856 pd=1.26 as=0.17225 ps=1.83 w=0.65 l=0.25
X6 X a_355_47# VGND VNB sky130_fd_pr__nfet_01v8 ad=0.2079 pd=1.83 as=0.1856 ps=1.26 w=0.42 l=0.15
X7 a_244_47# a_27_47# VGND VNB sky130_fd_pr__nfet_01v8 ad=0.17225 pd=1.83 as=0.1228 ps=1.065 w=0.65 l=0.25
C0 A VPWR 0.0192f
C1 a_27_47# VPWR 0.17434f
C2 X a_244_47# 0.00177f
C3 a_355_47# VPWR 0.17034f
C4 VPWR VGND 0.07512f
C5 VPB VPWR 0.0794f
C6 a_27_47# A 0.17892f
C7 VPWR a_244_47# 0.13579f
C8 a_355_47# A 0.00204f
C9 a_27_47# a_355_47# 0
C10 A VGND 0.01777f
C11 a_27_47# VGND 0.14438f
C12 VPB A 0.03819f
C13 a_27_47# VPB 0.07658f
C14 VPWR X 0.13105f
C15 A a_244_47# 0.00176f
C16 a_27_47# a_244_47# 0.11296f
C17 a_355_47# VGND 0.14681f
C18 a_355_47# VPB 0.0483f
C19 VPB VGND 0.00752f
C20 a_355_47# a_244_47# 0.34134f
C21 VGND a_244_47# 0.11435f
C22 VPB a_244_47# 0.09475f
C23 a_355_47# X 0.08925f
C24 VGND X 0.10639f
C25 VPB X 0.01394f
C26 VGND VNB 0.43903f
C27 X VNB 0.10191f
C28 VPWR VNB 0.36486f
C29 A VNB 0.16789f
C30 VPB VNB 0.78196f
C31 a_355_47# VNB 0.16237f
C32 a_244_47# VNB 0.18969f
C33 a_27_47# VNB 0.22821f
.ends

.subckt sky130_fd_sc_hd__dfrtp_2 VGND VPWR VPB VNB CLK D RESET_B Q a_1462_47# a_543_47#
+ a_651_413# a_193_47# a_805_47# a_448_47# a_639_47# a_1283_21# a_761_289# a_1108_47#
+ a_1217_47# a_1270_413# a_27_47#
X0 a_805_47# a_761_289# a_639_47# VNB sky130_fd_pr__nfet_01v8 ad=0.0441 pd=0.63 as=0.1401 ps=1.1 w=0.42 l=0.15
X1 a_1217_47# a_27_47# a_1108_47# VNB sky130_fd_pr__special_nfet_01v8 ad=0.0669 pd=0.75 as=0.0711 ps=0.755 w=0.36 l=0.15
X2 VGND a_1283_21# Q VNB sky130_fd_pr__nfet_01v8 ad=0.169 pd=1.82 as=0.08775 ps=0.92 w=0.65 l=0.15
X3 a_1283_21# a_1108_47# a_1462_47# VNB sky130_fd_pr__nfet_01v8 ad=0.1092 pd=1.36 as=0.06405 ps=0.725 w=0.42 l=0.15
X4 a_651_413# a_27_47# a_543_47# VPB sky130_fd_pr__pfet_01v8_hvt ad=0.1155 pd=0.97 as=0.07245 ps=0.765 w=0.42 l=0.15
X5 VPWR a_1283_21# Q VPB sky130_fd_pr__pfet_01v8_hvt ad=0.26 pd=2.52 as=0.135 ps=1.27 w=1 l=0.15
X6 a_1108_47# a_193_47# a_761_289# VNB sky130_fd_pr__special_nfet_01v8 ad=0.0711 pd=0.755 as=0.0999 ps=0.985 w=0.36 l=0.15
X7 VGND RESET_B a_805_47# VNB sky130_fd_pr__nfet_01v8 ad=0.1346 pd=1.15 as=0.0441 ps=0.63 w=0.42 l=0.15
X8 Q a_1283_21# VPWR VPB sky130_fd_pr__pfet_01v8_hvt ad=0.135 pd=1.27 as=0.3012 ps=2.66 w=1 l=0.15
X9 VPWR CLK a_27_47# VPB sky130_fd_pr__pfet_01v8_hvt ad=0.0864 pd=0.91 as=0.1664 ps=1.8 w=0.64 l=0.15
X10 a_448_47# D VPWR VPB sky130_fd_pr__pfet_01v8_hvt ad=0.0651 pd=0.73 as=0.1092 ps=1.36 w=0.42 l=0.15
X11 a_761_289# a_543_47# VGND VNB sky130_fd_pr__nfet_01v8 ad=0.0999 pd=0.985 as=0.1346 ps=1.15 w=0.64 l=0.15
X12 a_193_47# a_27_47# VGND VNB sky130_fd_pr__nfet_01v8 ad=0.1092 pd=1.36 as=0.0567 ps=0.69 w=0.42 l=0.15
X13 a_1108_47# a_27_47# a_761_289# VPB sky130_fd_pr__pfet_01v8_hvt ad=0.0588 pd=0.7 as=0.12915 ps=1.185 w=0.42 l=0.15
X14 a_1462_47# RESET_B VGND VNB sky130_fd_pr__nfet_01v8 ad=0.06405 pd=0.725 as=0.12495 ps=1.015 w=0.42 l=0.15
X15 a_543_47# a_27_47# a_448_47# VNB sky130_fd_pr__special_nfet_01v8 ad=0.0594 pd=0.69 as=0.066 ps=0.745 w=0.36 l=0.15
X16 a_543_47# a_193_47# a_448_47# VPB sky130_fd_pr__pfet_01v8_hvt ad=0.07245 pd=0.765 as=0.0651 ps=0.73 w=0.42 l=0.15
X17 a_448_47# D VGND VNB sky130_fd_pr__nfet_01v8 ad=0.066 pd=0.745 as=0.2205 ps=1.89 w=0.42 l=0.15
X18 VPWR a_1283_21# a_1270_413# VPB sky130_fd_pr__pfet_01v8_hvt ad=0.0819 pd=0.81 as=0.0567 ps=0.69 w=0.42 l=0.15
X19 VPWR a_1108_47# a_1283_21# VPB sky130_fd_pr__pfet_01v8_hvt ad=0.1134 pd=1.38 as=0.0567 ps=0.69 w=0.42 l=0.15
X20 a_1270_413# a_193_47# a_1108_47# VPB sky130_fd_pr__pfet_01v8_hvt ad=0.0567 pd=0.69 as=0.0588 ps=0.7 w=0.42 l=0.15
X21 a_193_47# a_27_47# VPWR VPB sky130_fd_pr__pfet_01v8_hvt ad=0.1664 pd=1.8 as=0.0864 ps=0.91 w=0.64 l=0.15
X22 a_1283_21# RESET_B VPWR VPB sky130_fd_pr__pfet_01v8_hvt ad=0.0567 pd=0.69 as=0.0819 ps=0.81 w=0.42 l=0.15
X23 VPWR a_761_289# a_651_413# VPB sky130_fd_pr__pfet_01v8_hvt ad=0.07035 pd=0.755 as=0.1155 ps=0.97 w=0.42 l=0.15
X24 Q a_1283_21# VGND VNB sky130_fd_pr__nfet_01v8 ad=0.08775 pd=0.92 as=0.2087 ps=2.02 w=0.65 l=0.15
X25 a_639_47# a_193_47# a_543_47# VNB sky130_fd_pr__special_nfet_01v8 ad=0.1401 pd=1.1 as=0.0594 ps=0.69 w=0.36 l=0.15
X26 VGND a_1283_21# a_1217_47# VNB sky130_fd_pr__nfet_01v8 ad=0.12495 pd=1.015 as=0.0669 ps=0.75 w=0.42 l=0.15
X27 a_651_413# RESET_B VPWR VPB sky130_fd_pr__pfet_01v8_hvt ad=0.1092 pd=1.36 as=0.07035 ps=0.755 w=0.42 l=0.15
X28 VGND CLK a_27_47# VNB sky130_fd_pr__nfet_01v8 ad=0.0567 pd=0.69 as=0.1092 ps=1.36 w=0.42 l=0.15
X29 a_761_289# a_543_47# VPWR VPB sky130_fd_pr__pfet_01v8_hvt ad=0.12915 pd=1.185 as=0.2184 ps=2.2 w=0.84 l=0.15
C0 a_1283_21# a_1108_47# 0.23366f
C1 a_448_47# VPB 0.01414f
C2 a_1108_47# VGND 0.14813f
C3 a_761_289# a_27_47# 0.07009f
C4 a_543_47# VPB 0.09579f
C5 a_1217_47# a_27_47# 0
C6 a_193_47# CLK 0
C7 a_1283_21# RESET_B 0.27892f
C8 RESET_B VGND 0.28803f
C9 a_651_413# RESET_B 0.0122f
C10 VPB a_27_47# 0.26188f
C11 a_1108_47# Q 0
C12 a_543_47# a_805_47# 0.00171f
C13 a_193_47# D 0.21795f
C14 a_1283_21# VPWR 0.22975f
C15 a_193_47# a_1108_47# 0.12532f
C16 VPWR VGND 0.07191f
C17 RESET_B Q 0
C18 a_651_413# VPWR 0.12856f
C19 CLK a_27_47# 0.2336f
C20 a_448_47# D 0.15563f
C21 a_543_47# D 0
C22 a_761_289# a_1270_413# 0
C23 a_761_289# a_1217_47# 0
C24 a_193_47# RESET_B 0.0269f
C25 a_543_47# a_1108_47# 0
C26 a_1283_21# VGND 0.25943f
C27 VPWR Q 0.16936f
C28 a_639_47# RESET_B 0
C29 a_761_289# VPB 0.09942f
C30 D a_27_47# 0.13285f
C31 a_448_47# RESET_B 0
C32 a_1108_47# a_27_47# 0.10236f
C33 a_543_47# RESET_B 0.15327f
C34 a_193_47# VPWR 0.39596f
C35 a_1283_21# Q 0.0963f
C36 a_761_289# a_805_47# 0
C37 VGND Q 0.10966f
C38 RESET_B a_27_47# 0.29634f
C39 a_448_47# VPWR 0.06814f
C40 a_543_47# VPWR 0.10029f
C41 a_193_47# a_1283_21# 0.04251f
C42 a_193_47# VGND 0.06306f
C43 a_651_413# a_193_47# 0.03462f
C44 VPB CLK 0.06934f
C45 a_1462_47# RESET_B 0.00288f
C46 a_639_47# VGND 0.00863f
C47 VPWR a_27_47# 0.1523f
C48 a_448_47# VGND 0.0661f
C49 a_761_289# a_1108_47# 0.05116f
C50 a_543_47# VGND 0.12293f
C51 a_651_413# a_543_47# 0.05722f
C52 a_1108_47# a_1270_413# 0.00645f
C53 a_1108_47# a_1217_47# 0.00742f
C54 a_193_47# Q 0
C55 VPB D 0.13757f
C56 a_1283_21# a_27_47# 0.04359f
C57 a_761_289# RESET_B 0.16611f
C58 a_1108_47# VPB 0.11463f
C59 VGND a_27_47# 0.25397f
C60 a_651_413# a_27_47# 0
C61 RESET_B a_1270_413# 0
C62 a_1217_47# RESET_B 0
C63 a_1283_21# a_1462_47# 0.0074f
C64 a_193_47# a_639_47# 0
C65 VPB RESET_B 0.13848f
C66 a_1462_47# VGND 0.00221f
C67 a_193_47# a_448_47# 0.06418f
C68 a_761_289# VPWR 0.10497f
C69 Q a_27_47# 0
C70 a_193_47# a_543_47# 0.2298f
C71 VPWR a_1270_413# 0
C72 a_448_47# a_639_47# 0
C73 a_543_47# a_639_47# 0.01379f
C74 a_543_47# a_448_47# 0.04983f
C75 a_805_47# RESET_B 0.00316f
C76 a_193_47# a_27_47# 0.90645f
C77 VPB VPWR 0.2337f
C78 CLK RESET_B 0
C79 a_761_289# VGND 0.07338f
C80 a_651_413# a_761_289# 0.09774f
C81 a_639_47# a_27_47# 0.00188f
C82 a_1217_47# VGND 0
C83 a_448_47# a_27_47# 0.09313f
C84 a_543_47# a_27_47# 0.11535f
C85 a_1283_21# VPB 0.16811f
C86 D RESET_B 0
C87 CLK VPWR 0.01741f
C88 VPB VGND 0.01215f
C89 a_651_413# VPB 0.01354f
C90 a_1108_47# RESET_B 0.2366f
C91 a_805_47# VGND 0.00579f
C92 a_193_47# a_761_289# 0.18639f
C93 CLK VGND 0.01721f
C94 VPB Q 0.00555f
C95 D VPWR 0.08119f
C96 a_193_47# a_1270_413# 0
C97 a_193_47# a_1217_47# 0
C98 a_1108_47# VPWR 0.17379f
C99 a_761_289# a_639_47# 0
C100 a_761_289# a_543_47# 0.20964f
C101 a_193_47# VPB 0.17091f
C102 D VGND 0.05161f
C103 RESET_B VPWR 0.06519f
C104 Q VNB 0.02956f
C105 VGND VNB 1.09584f
C106 VPWR VNB 0.90228f
C107 RESET_B VNB 0.26285f
C108 D VNB 0.15989f
C109 CLK VNB 0.19525f
C110 VPB VNB 1.9337f
C111 a_651_413# VNB 0.00469f
C112 a_448_47# VNB 0.0139f
C113 a_1108_47# VNB 0.13732f
C114 a_1283_21# VNB 0.38926f
C115 a_543_47# VNB 0.15787f
C116 a_761_289# VNB 0.12085f
C117 a_193_47# VNB 0.27321f
C118 a_27_47# VNB 0.49575f
.ends

.subckt misfit01_core clk ena inv_a inv_y ui_in[1] ui_in[2] ui_in[3] ui_in[4] ui_in[5]
+ ui_in[6] ui_in[7] uio_in[0] uio_in[1] uio_in[2] uio_in[3] uio_in[4] uio_in[5] uio_in[6]
+ uio_in[7] uio_oe[1] uio_oe[3] uio_oe[4] uio_oe[6] uio_out[1] uio_out[4] uio_out[6]
+ uio_out[7] uo_out[1] uo_out[3] uo_out[4] uo_out[6] ui_in[0] uo_out[0] uio_oe[0]
+ uio_out[3] uio_out[0] uio_oe[5] uo_out[5] uio_oe[2] uo_out[7] uo_out[2] uio_out[5]
+ uio_out[2] rst_n uio_oe[7] VPWR VGND
XFILLER_22_177 VPWR VGND VPWR VGND sky130_fd_sc_hd__decap_3
XFILLER_22_144 VPWR VGND VPWR VGND sky130_fd_sc_hd__decap_3
XFILLER_22_133 VPWR VGND VPWR VGND sky130_fd_sc_hd__decap_3
XFILLER_22_100 VPWR VGND VPWR VGND sky130_fd_sc_hd__decap_3
XFILLER_13_122 VPWR VGND VPWR VGND sky130_fd_sc_hd__decap_3
XFILLER_13_199 VPWR VGND VPWR VGND sky130_fd_sc_hd__decap_3
XFILLER_13_155 VPWR VGND VPWR VGND sky130_fd_sc_hd__decap_3
XFILLER_9_137 VPWR VGND VPWR VGND sky130_fd_sc_hd__decap_3
XFILLER_3_45 VPWR VGND VPWR VGND sky130_fd_sc_hd__decap_3
XFILLER_3_12 VPWR VGND VPWR VGND sky130_fd_sc_hd__decap_3
XFILLER_5_332 VPWR VGND VPWR VGND sky130_fd_sc_hd__decap_3
XFILLER_3_78 VPWR VGND VPWR VGND sky130_fd_sc_hd__decap_3
XFILLER_8_192 VPWR VGND VPWR VGND sky130_fd_sc_hd__decap_3
XFILLER_6_118 VPWR VGND VPWR VGND sky130_fd_sc_hd__decap_3
XFILLER_10_103 VPWR VGND VPWR VGND sky130_fd_sc_hd__decap_3
XFILLER_10_136 VPWR VGND VPWR VGND sky130_fd_sc_hd__decap_3
XFILLER_10_147 VPWR VGND VPWR VGND sky130_fd_sc_hd__decap_3
XFILLER_12_21 VPWR VGND VPWR VGND sky130_fd_sc_hd__decap_3
XFILLER_12_32 VPWR VGND VPWR VGND sky130_fd_sc_hd__decap_3
XFILLER_2_324 VPWR VGND VPWR VGND sky130_fd_sc_hd__decap_3
XFILLER_12_65 VPWR VGND VPWR VGND sky130_fd_sc_hd__decap_3
XFILLER_18_236 VPWR VGND VPWR VGND sky130_fd_sc_hd__decap_3
XFILLER_18_203 VPWR VGND VPWR VGND sky130_fd_sc_hd__decap_3
XFILLER_5_140 VPWR VGND VPWR VGND sky130_fd_sc_hd__decap_3
XFILLER_5_184 VPWR VGND VPWR VGND sky130_fd_sc_hd__decap_3
XFILLER_15_228 VPWR VGND VPWR VGND sky130_fd_sc_hd__decap_3
XFILLER_15_217 VPWR VGND VPWR VGND sky130_fd_sc_hd__decap_3
XFILLER_23_64 VPWR VGND VPWR VGND sky130_fd_sc_hd__decap_3
XFILLER_23_53 VPWR VGND VPWR VGND sky130_fd_sc_hd__decap_3
XFILLER_2_165 VPWR VGND VPWR VGND sky130_fd_sc_hd__decap_3
XFILLER_2_121 VPWR VGND VPWR VGND sky130_fd_sc_hd__decap_3
XFILLER_17_9 VPWR VGND VPWR VGND sky130_fd_sc_hd__decap_3
XFILLER_0_24 VPWR VGND VPWR VGND sky130_fd_sc_hd__decap_3
XFILLER_0_35 VPWR VGND VPWR VGND sky130_fd_sc_hd__decap_3
XFILLER_0_57 VPWR VGND VPWR VGND sky130_fd_sc_hd__decap_3
XFILLER_0_68 VPWR VGND VPWR VGND sky130_fd_sc_hd__decap_3
XFILLER_14_283 VPWR VGND VPWR VGND sky130_fd_sc_hd__decap_3
XFILLER_9_33 VPWR VGND VPWR VGND sky130_fd_sc_hd__decap_3
XFILLER_9_66 VPWR VGND VPWR VGND sky130_fd_sc_hd__decap_3
XFILLER_9_99 VPWR VGND VPWR VGND sky130_fd_sc_hd__decap_3
XFILLER_12_209 VPWR VGND VPWR VGND sky130_fd_sc_hd__decap_3
XFILLER_20_286 VPWR VGND VPWR VGND sky130_fd_sc_hd__decap_3
XFILLER_20_253 VPWR VGND VPWR VGND sky130_fd_sc_hd__decap_3
XFILLER_20_242 VPWR VGND VPWR VGND sky130_fd_sc_hd__decap_3
XFILLER_18_97 VPWR VGND VPWR VGND sky130_fd_sc_hd__decap_3
XFILLER_18_53 VPWR VGND VPWR VGND sky130_fd_sc_hd__decap_3
XFILLER_7_202 VPWR VGND VPWR VGND sky130_fd_sc_hd__decap_3
XFILLER_11_220 VPWR VGND VPWR VGND sky130_fd_sc_hd__decap_3
XFILLER_11_231 VPWR VGND VPWR VGND sky130_fd_sc_hd__decap_3
XFILLER_11_264 VPWR VGND VPWR VGND sky130_fd_sc_hd__decap_3
XFILLER_7_246 VPWR VGND VPWR VGND sky130_fd_sc_hd__decap_3
XFILLER_19_320 VPWR VGND VPWR VGND sky130_fd_sc_hd__decap_3
XFILLER_15_6 VPWR VGND VPWR VGND sky130_fd_sc_hd__decap_3
XPHY_EDGE_ROW_12_Left_36 VPWR VGND VPWR VGND sky130_fd_sc_hd__decap_3
XFILLER_20_65 VPWR VGND VPWR VGND sky130_fd_sc_hd__decap_3
XFILLER_20_32 VPWR VGND VPWR VGND sky130_fd_sc_hd__decap_3
XFILLER_20_21 VPWR VGND VPWR VGND sky130_fd_sc_hd__decap_3
XFILLER_4_227 VPWR VGND VPWR VGND sky130_fd_sc_hd__decap_3
XFILLER_16_312 VPWR VGND VPWR VGND sky130_fd_sc_hd__decap_3
XFILLER_16_301 VPWR VGND VPWR VGND sky130_fd_sc_hd__decap_3
XFILLER_6_12 VPWR VGND VPWR VGND sky130_fd_sc_hd__decap_3
XFILLER_3_293 VPWR VGND VPWR VGND sky130_fd_sc_hd__decap_3
XFILLER_6_56 VPWR VGND VPWR VGND sky130_fd_sc_hd__decap_3
XFILLER_19_172 VPWR VGND VPWR VGND sky130_fd_sc_hd__decap_3
XFILLER_19_161 VPWR VGND VPWR VGND sky130_fd_sc_hd__decap_3
XFILLER_13_3 VPWR VGND VPWR VGND sky130_fd_sc_hd__decap_3
XFILLER_22_315 VPWR VGND VPWR VGND sky130_fd_sc_hd__decap_3
XFILLER_1_208 VPWR VGND VPWR VGND sky130_fd_sc_hd__decap_3
XFILLER_15_21 VPWR VGND VPWR VGND sky130_fd_sc_hd__decap_3
XFILLER_15_87 VPWR VGND VPWR VGND sky130_fd_sc_hd__decap_3
XFILLER_13_326 VPWR VGND VPWR VGND sky130_fd_sc_hd__decap_3
XFILLER_9_308 VPWR VGND VPWR VGND sky130_fd_sc_hd__decap_3
XFILLER_0_296 VPWR VGND VPWR VGND sky130_fd_sc_hd__decap_3
XFILLER_0_274 VPWR VGND VPWR VGND sky130_fd_sc_hd__decap_3
XFILLER_16_197 VPWR VGND VPWR VGND sky130_fd_sc_hd__decap_3
XFILLER_16_186 VPWR VGND VPWR VGND sky130_fd_sc_hd__decap_3
XFILLER_16_153 VPWR VGND VPWR VGND sky130_fd_sc_hd__decap_3
XFILLER_8_330 VPWR VGND VPWR VGND sky130_fd_sc_hd__decap_3
XFILLER_22_156 VPWR VGND VPWR VGND sky130_fd_sc_hd__decap_3
XFILLER_22_112 VPWR VGND VPWR VGND sky130_fd_sc_hd__decap_3
XFILLER_10_318 VPWR VGND VPWR VGND sky130_fd_sc_hd__decap_3
XFILLER_13_134 VPWR VGND VPWR VGND sky130_fd_sc_hd__decap_3
XFILLER_9_105 VPWR VGND VPWR VGND sky130_fd_sc_hd__decap_3
XFILLER_9_116 VPWR VGND VPWR VGND sky130_fd_sc_hd__decap_3
XFILLER_13_178 VPWR VGND VPWR VGND sky130_fd_sc_hd__decap_3
XFILLER_5_311 VPWR VGND VPWR VGND sky130_fd_sc_hd__decap_3
XFILLER_9_149 VPWR VGND VPWR VGND sky130_fd_sc_hd__decap_3
XFILLER_3_57 VPWR VGND VPWR VGND sky130_fd_sc_hd__decap_3
XFILLER_3_24 VPWR VGND VPWR VGND sky130_fd_sc_hd__decap_3
XFILLER_8_171 VPWR VGND VPWR VGND sky130_fd_sc_hd__decap_3
XFILLER_10_115 VPWR VGND VPWR VGND sky130_fd_sc_hd__decap_3
XFILLER_10_159 VPWR VGND VPWR VGND sky130_fd_sc_hd__decap_3
XFILLER_12_44 VPWR VGND VPWR VGND sky130_fd_sc_hd__decap_3
XFILLER_12_77 VPWR VGND VPWR VGND sky130_fd_sc_hd__decap_3
XFILLER_12_88 VPWR VGND VPWR VGND sky130_fd_sc_hd__decap_3
XPHY_EDGE_ROW_0_Left_24 VPWR VGND VPWR VGND sky130_fd_sc_hd__decap_3
XFILLER_18_259 VPWR VGND VPWR VGND sky130_fd_sc_hd__decap_3
XFILLER_18_248 VPWR VGND VPWR VGND sky130_fd_sc_hd__decap_3
XFILLER_18_215 VPWR VGND VPWR VGND sky130_fd_sc_hd__decap_3
XFILLER_5_152 VPWR VGND VPWR VGND sky130_fd_sc_hd__decap_3
XFILLER_5_196 VPWR VGND VPWR VGND sky130_fd_sc_hd__decap_3
XFILLER_17_281 VPWR VGND VPWR VGND sky130_fd_sc_hd__decap_3
XFILLER_17_270 VPWR VGND VPWR VGND sky130_fd_sc_hd__decap_3
XPHY_EDGE_ROW_12_Right_12 VPWR VGND VPWR VGND sky130_fd_sc_hd__decap_3
XPHY_EDGE_ROW_21_Right_21 VPWR VGND VPWR VGND sky130_fd_sc_hd__decap_3
XFILLER_23_284 VPWR VGND VPWR VGND sky130_fd_sc_hd__decap_3
XFILLER_23_262 VPWR VGND VPWR VGND sky130_fd_sc_hd__decap_3
XFILLER_23_32 VPWR VGND VPWR VGND sky130_fd_sc_hd__decap_3
XFILLER_23_21 VPWR VGND VPWR VGND sky130_fd_sc_hd__decap_3
XFILLER_23_76 VPWR VGND VPWR VGND sky130_fd_sc_hd__decap_3
XFILLER_2_100 VPWR VGND VPWR VGND sky130_fd_sc_hd__decap_3
XFILLER_2_177 VPWR VGND VPWR VGND sky130_fd_sc_hd__decap_3
XFILLER_2_144 VPWR VGND VPWR VGND sky130_fd_sc_hd__decap_3
XFILLER_2_133 VPWR VGND VPWR VGND sky130_fd_sc_hd__decap_3
XFILLER_0_47 VPWR VGND VPWR VGND sky130_fd_sc_hd__decap_3
XFILLER_9_12 VPWR VGND VPWR VGND sky130_fd_sc_hd__decap_3
Xmisfit01_core_4 uio_oe[4] misfit01_core_4/HI VPWR VGND VGND VPWR sky130_fd_sc_hd__conb_1
XFILLER_14_295 VPWR VGND VPWR VGND sky130_fd_sc_hd__decap_3
XFILLER_14_262 VPWR VGND VPWR VGND sky130_fd_sc_hd__decap_3
XFILLER_9_45 VPWR VGND VPWR VGND sky130_fd_sc_hd__decap_3
XFILLER_9_78 VPWR VGND VPWR VGND sky130_fd_sc_hd__decap_3
XFILLER_20_221 VPWR VGND VPWR VGND sky130_fd_sc_hd__decap_3
XFILLER_20_298 VPWR VGND VPWR VGND sky130_fd_sc_hd__decap_3
XFILLER_20_265 VPWR VGND VPWR VGND sky130_fd_sc_hd__decap_3
XFILLER_18_65 VPWR VGND VPWR VGND sky130_fd_sc_hd__decap_3
XFILLER_18_32 VPWR VGND VPWR VGND sky130_fd_sc_hd__decap_3
XFILLER_18_21 VPWR VGND VPWR VGND sky130_fd_sc_hd__decap_3
XFILLER_7_214 VPWR VGND VPWR VGND sky130_fd_sc_hd__decap_3
XFILLER_7_225 VPWR VGND VPWR VGND sky130_fd_sc_hd__decap_3
XFILLER_11_243 VPWR VGND VPWR VGND sky130_fd_sc_hd__decap_3
XFILLER_11_276 VPWR VGND VPWR VGND sky130_fd_sc_hd__decap_3
XFILLER_11_287 VPWR VGND VPWR VGND sky130_fd_sc_hd__decap_3
XFILLER_7_258 VPWR VGND VPWR VGND sky130_fd_sc_hd__decap_3
XFILLER_19_332 VPWR VGND VPWR VGND sky130_fd_sc_hd__decap_3
XFILLER_6_280 VPWR VGND VPWR VGND sky130_fd_sc_hd__decap_3
XFILLER_1_90 VPWR VGND VPWR VGND sky130_fd_sc_hd__decap_3
XFILLER_20_88 VPWR VGND VPWR VGND sky130_fd_sc_hd__decap_3
XFILLER_20_77 VPWR VGND VPWR VGND sky130_fd_sc_hd__decap_3
XFILLER_20_44 VPWR VGND VPWR VGND sky130_fd_sc_hd__decap_3
XFILLER_4_206 VPWR VGND VPWR VGND sky130_fd_sc_hd__decap_3
XFILLER_4_239 VPWR VGND VPWR VGND sky130_fd_sc_hd__decap_3
XFILLER_16_324 VPWR VGND VPWR VGND sky130_fd_sc_hd__decap_3
XFILLER_6_24 VPWR VGND VPWR VGND sky130_fd_sc_hd__decap_3
XFILLER_6_35 VPWR VGND VPWR VGND sky130_fd_sc_hd__decap_3
XFILLER_3_261 VPWR VGND VPWR VGND sky130_fd_sc_hd__decap_3
XFILLER_6_68 VPWR VGND VPWR VGND sky130_fd_sc_hd__decap_3
XFILLER_19_184 VPWR VGND VPWR VGND sky130_fd_sc_hd__decap_3
XFILLER_19_140 VPWR VGND VPWR VGND sky130_fd_sc_hd__decap_3
XFILLER_22_327 VPWR VGND VPWR VGND sky130_fd_sc_hd__decap_3
XPHY_EDGE_ROW_6_Right_6 VPWR VGND VPWR VGND sky130_fd_sc_hd__decap_3
XFILLER_15_66 VPWR VGND VPWR VGND sky130_fd_sc_hd__decap_3
XFILLER_15_33 VPWR VGND VPWR VGND sky130_fd_sc_hd__decap_3
XFILLER_13_305 VPWR VGND VPWR VGND sky130_fd_sc_hd__decap_3
XFILLER_15_99 VPWR VGND VPWR VGND sky130_fd_sc_hd__decap_3
XFILLER_0_253 VPWR VGND VPWR VGND sky130_fd_sc_hd__decap_3
XFILLER_0_231 VPWR VGND VPWR VGND sky130_fd_sc_hd__decap_3
XFILLER_16_121 VPWR VGND VPWR VGND sky130_fd_sc_hd__decap_3
XFILLER_16_165 VPWR VGND VPWR VGND sky130_fd_sc_hd__decap_3
XFILLER_22_124 VPWR VGND VPWR VGND sky130_fd_sc_hd__decap_3
XFILLER_22_168 VPWR VGND VPWR VGND sky130_fd_sc_hd__decap_3
XFILLER_7_9 VPWR VGND VPWR VGND sky130_fd_sc_hd__decap_3
XFILLER_13_146 VPWR VGND VPWR VGND sky130_fd_sc_hd__decap_3
XFILLER_13_113 VPWR VGND VPWR VGND sky130_fd_sc_hd__decap_3
XFILLER_13_102 VPWR VGND VPWR VGND sky130_fd_sc_hd__decap_3
XFILLER_9_128 VPWR VGND VPWR VGND sky130_fd_sc_hd__decap_3
XFILLER_5_323 VPWR VGND VPWR VGND sky130_fd_sc_hd__decap_3
XFILLER_3_36 VPWR VGND VPWR VGND sky130_fd_sc_hd__decap_3
XFILLER_3_69 VPWR VGND VPWR VGND sky130_fd_sc_hd__decap_3
XFILLER_8_150 VPWR VGND VPWR VGND sky130_fd_sc_hd__decap_3
XFILLER_8_183 VPWR VGND VPWR VGND sky130_fd_sc_hd__decap_3
XFILLER_2_304 VPWR VGND VPWR VGND sky130_fd_sc_hd__decap_3
XFILLER_6_109 VPWR VGND VPWR VGND sky130_fd_sc_hd__decap_3
XFILLER_10_127 VPWR VGND VPWR VGND sky130_fd_sc_hd__decap_3
XFILLER_12_12 VPWR VGND VPWR VGND sky130_fd_sc_hd__decap_3
XFILLER_12_56 VPWR VGND VPWR VGND sky130_fd_sc_hd__decap_3
XFILLER_2_315 VPWR VGND VPWR VGND sky130_fd_sc_hd__decap_3
XFILLER_5_6 VPWR VGND VPWR VGND sky130_fd_sc_hd__decap_3
XFILLER_18_227 VPWR VGND VPWR VGND sky130_fd_sc_hd__decap_3
XFILLER_5_131 VPWR VGND VPWR VGND sky130_fd_sc_hd__decap_3
XFILLER_5_164 VPWR VGND VPWR VGND sky130_fd_sc_hd__decap_3
XFILLER_5_175 VPWR VGND VPWR VGND sky130_fd_sc_hd__decap_3
XFILLER_17_293 VPWR VGND VPWR VGND sky130_fd_sc_hd__decap_3
XFILLER_15_208 VPWR VGND VPWR VGND sky130_fd_sc_hd__decap_3
XFILLER_23_274 VPWR VGND VPWR VGND sky130_fd_sc_hd__decap_3
XFILLER_23_88 VPWR VGND VPWR VGND sky130_fd_sc_hd__decap_3
XFILLER_23_44 VPWR VGND VPWR VGND sky130_fd_sc_hd__decap_3
XFILLER_3_3 VPWR VGND VPWR VGND sky130_fd_sc_hd__decap_3
XFILLER_2_156 VPWR VGND VPWR VGND sky130_fd_sc_hd__decap_3
XFILLER_2_112 VPWR VGND VPWR VGND sky130_fd_sc_hd__decap_3
XFILLER_2_189 VPWR VGND VPWR VGND sky130_fd_sc_hd__decap_3
XFILLER_0_15 VPWR VGND VPWR VGND sky130_fd_sc_hd__decap_3
XFILLER_14_274 VPWR VGND VPWR VGND sky130_fd_sc_hd__decap_3
XFILLER_14_230 VPWR VGND VPWR VGND sky130_fd_sc_hd__decap_3
XFILLER_9_24 VPWR VGND VPWR VGND sky130_fd_sc_hd__decap_3
Xmisfit01_core_5 uio_oe[5] misfit01_core_5/HI VPWR VGND VGND VPWR sky130_fd_sc_hd__conb_1
XFILLER_9_57 VPWR VGND VPWR VGND sky130_fd_sc_hd__decap_3
XFILLER_20_233 VPWR VGND VPWR VGND sky130_fd_sc_hd__decap_3
XFILLER_20_200 VPWR VGND VPWR VGND sky130_fd_sc_hd__decap_3
XFILLER_20_277 VPWR VGND VPWR VGND sky130_fd_sc_hd__decap_3
XFILLER_18_44 VPWR VGND VPWR VGND sky130_fd_sc_hd__decap_3
XFILLER_18_88 VPWR VGND VPWR VGND sky130_fd_sc_hd__decap_3
XFILLER_18_77 VPWR VGND VPWR VGND sky130_fd_sc_hd__decap_3
XFILLER_7_237 VPWR VGND VPWR VGND sky130_fd_sc_hd__decap_3
XFILLER_11_211 VPWR VGND VPWR VGND sky130_fd_sc_hd__decap_3
XFILLER_11_255 VPWR VGND VPWR VGND sky130_fd_sc_hd__decap_3
XFILLER_11_299 VPWR VGND VPWR VGND sky130_fd_sc_hd__decap_3
XFILLER_22_9 VPWR VGND VPWR VGND sky130_fd_sc_hd__decap_3
XFILLER_19_311 VPWR VGND VPWR VGND sky130_fd_sc_hd__decap_3
XFILLER_6_292 VPWR VGND VPWR VGND sky130_fd_sc_hd__decap_3
XFILLER_20_56 VPWR VGND VPWR VGND sky130_fd_sc_hd__decap_3
XFILLER_20_12 VPWR VGND VPWR VGND sky130_fd_sc_hd__decap_3
XFILLER_4_218 VPWR VGND VPWR VGND sky130_fd_sc_hd__decap_3
XFILLER_6_47 VPWR VGND VPWR VGND sky130_fd_sc_hd__decap_3
XFILLER_20_6 VPWR VGND VPWR VGND sky130_fd_sc_hd__decap_3
XFILLER_3_240 VPWR VGND VPWR VGND sky130_fd_sc_hd__decap_3
XFILLER_3_273 VPWR VGND VPWR VGND sky130_fd_sc_hd__decap_3
XFILLER_3_284 VPWR VGND VPWR VGND sky130_fd_sc_hd__decap_3
XFILLER_19_196 VPWR VGND VPWR VGND sky130_fd_sc_hd__decap_3
XFILLER_19_152 VPWR VGND VPWR VGND sky130_fd_sc_hd__decap_3
XFILLER_15_78 VPWR VGND VPWR VGND sky130_fd_sc_hd__decap_3
XFILLER_15_45 VPWR VGND VPWR VGND sky130_fd_sc_hd__decap_3
XFILLER_15_12 VPWR VGND VPWR VGND sky130_fd_sc_hd__decap_3
XFILLER_13_317 VPWR VGND VPWR VGND sky130_fd_sc_hd__decap_3
XFILLER_0_287 VPWR VGND VPWR VGND sky130_fd_sc_hd__decap_3
XFILLER_0_265 VPWR VGND VPWR VGND sky130_fd_sc_hd__decap_3
XFILLER_0_243 VPWR VGND VPWR VGND sky130_fd_sc_hd__decap_3
XFILLER_0_221 VPWR VGND VPWR VGND sky130_fd_sc_hd__decap_3
XFILLER_16_144 VPWR VGND VPWR VGND sky130_fd_sc_hd__decap_3
XFILLER_16_133 VPWR VGND VPWR VGND sky130_fd_sc_hd__decap_3
XFILLER_16_100 VPWR VGND VPWR VGND sky130_fd_sc_hd__decap_3
XFILLER_16_177 VPWR VGND VPWR VGND sky130_fd_sc_hd__decap_3
XFILLER_8_321 VPWR VGND VPWR VGND sky130_fd_sc_hd__decap_3
XFILLER_22_147 VPWR VGND VPWR VGND sky130_fd_sc_hd__decap_3
XFILLER_22_136 VPWR VGND VPWR VGND sky130_fd_sc_hd__decap_3
XFILLER_22_103 VPWR VGND VPWR VGND sky130_fd_sc_hd__decap_3
XFILLER_7_90 VPWR VGND VPWR VGND sky130_fd_sc_hd__decap_3
XFILLER_10_309 VPWR VGND VPWR VGND sky130_fd_sc_hd__decap_3
XFILLER_13_169 VPWR VGND VPWR VGND sky130_fd_sc_hd__decap_3
XFILLER_13_158 VPWR VGND VPWR VGND sky130_fd_sc_hd__decap_3
XFILLER_13_125 VPWR VGND VPWR VGND sky130_fd_sc_hd__decap_3
XFILLER_5_302 VPWR VGND VPWR VGND sky130_fd_sc_hd__decap_3
XFILLER_3_48 VPWR VGND VPWR VGND sky130_fd_sc_hd__decap_3
XFILLER_3_15 VPWR VGND VPWR VGND sky130_fd_sc_hd__decap_3
XFILLER_8_162 VPWR VGND VPWR VGND sky130_fd_sc_hd__decap_3
XFILLER_12_180 VPWR VGND VPWR VGND sky130_fd_sc_hd__decap_3
XFILLER_10_106 VPWR VGND VPWR VGND sky130_fd_sc_hd__decap_3
XFILLER_2_327 VPWR VGND VPWR VGND sky130_fd_sc_hd__decap_3
XFILLER_12_24 VPWR VGND VPWR VGND sky130_fd_sc_hd__decap_3
XFILLER_12_35 VPWR VGND VPWR VGND sky130_fd_sc_hd__decap_3
XFILLER_12_68 VPWR VGND VPWR VGND sky130_fd_sc_hd__decap_3
XFILLER_18_206 VPWR VGND VPWR VGND sky130_fd_sc_hd__decap_3
XFILLER_18_239 VPWR VGND VPWR VGND sky130_fd_sc_hd__decap_3
XFILLER_5_143 VPWR VGND VPWR VGND sky130_fd_sc_hd__decap_3
XFILLER_5_187 VPWR VGND VPWR VGND sky130_fd_sc_hd__decap_3
XFILLER_17_261 VPWR VGND VPWR VGND sky130_fd_sc_hd__decap_3
XFILLER_4_80 VPWR VGND VPWR VGND sky130_fd_sc_hd__decap_3
XFILLER_4_91 VPWR VGND VPWR VGND sky130_fd_sc_hd__decap_3
XFILLER_23_253 VPWR VGND VPWR VGND sky130_fd_sc_hd__decap_3
XFILLER_23_12 VPWR VGND VPWR VGND sky130_fd_sc_hd__decap_3
XFILLER_2_168 VPWR VGND VPWR VGND sky130_fd_sc_hd__decap_3
XFILLER_2_124 VPWR VGND VPWR VGND sky130_fd_sc_hd__decap_3
XFILLER_0_38 VPWR VGND VPWR VGND sky130_fd_sc_hd__decap_3
Xmisfit01_core_6 uio_oe[6] misfit01_core_6/HI VPWR VGND VGND VPWR sky130_fd_sc_hd__conb_1
XFILLER_14_286 VPWR VGND VPWR VGND sky130_fd_sc_hd__decap_3
XFILLER_14_253 VPWR VGND VPWR VGND sky130_fd_sc_hd__decap_3
XFILLER_14_242 VPWR VGND VPWR VGND sky130_fd_sc_hd__decap_3
XFILLER_9_36 VPWR VGND VPWR VGND sky130_fd_sc_hd__decap_3
XFILLER_9_69 VPWR VGND VPWR VGND sky130_fd_sc_hd__decap_3
XFILLER_1_190 VPWR VGND VPWR VGND sky130_fd_sc_hd__decap_3
XFILLER_20_289 VPWR VGND VPWR VGND sky130_fd_sc_hd__decap_3
XFILLER_20_256 VPWR VGND VPWR VGND sky130_fd_sc_hd__decap_3
XFILLER_20_245 VPWR VGND VPWR VGND sky130_fd_sc_hd__decap_3
XFILLER_20_212 VPWR VGND VPWR VGND sky130_fd_sc_hd__decap_3
XFILLER_9_290 VPWR VGND VPWR VGND sky130_fd_sc_hd__decap_3
XFILLER_18_56 VPWR VGND VPWR VGND sky130_fd_sc_hd__decap_3
XFILLER_18_12 VPWR VGND VPWR VGND sky130_fd_sc_hd__decap_3
XFILLER_7_205 VPWR VGND VPWR VGND sky130_fd_sc_hd__decap_3
XFILLER_7_249 VPWR VGND VPWR VGND sky130_fd_sc_hd__decap_3
XFILLER_11_234 VPWR VGND VPWR VGND sky130_fd_sc_hd__decap_3
XFILLER_11_267 VPWR VGND VPWR VGND sky130_fd_sc_hd__decap_3
XFILLER_19_323 VPWR VGND VPWR VGND sky130_fd_sc_hd__decap_3
XFILLER_15_9 VPWR VGND VPWR VGND sky130_fd_sc_hd__decap_3
XFILLER_6_271 VPWR VGND VPWR VGND sky130_fd_sc_hd__decap_3
XFILLER_1_81 VPWR VGND VPWR VGND sky130_fd_sc_hd__decap_3
XFILLER_20_24 VPWR VGND VPWR VGND sky130_fd_sc_hd__decap_3
XFILLER_20_68 VPWR VGND VPWR VGND sky130_fd_sc_hd__decap_3
XFILLER_20_35 VPWR VGND VPWR VGND sky130_fd_sc_hd__decap_3
XFILLER_16_315 VPWR VGND VPWR VGND sky130_fd_sc_hd__decap_3
XFILLER_16_304 VPWR VGND VPWR VGND sky130_fd_sc_hd__decap_3
XFILLER_3_252 VPWR VGND VPWR VGND sky130_fd_sc_hd__decap_3
XFILLER_6_15 VPWR VGND VPWR VGND sky130_fd_sc_hd__decap_3
XFILLER_6_59 VPWR VGND VPWR VGND sky130_fd_sc_hd__decap_3
XFILLER_19_131 VPWR VGND VPWR VGND sky130_fd_sc_hd__decap_3
XFILLER_13_6 VPWR VGND VPWR VGND sky130_fd_sc_hd__decap_3
XFILLER_3_296 VPWR VGND VPWR VGND sky130_fd_sc_hd__decap_3
XFILLER_22_318 VPWR VGND VPWR VGND sky130_fd_sc_hd__decap_3
XFILLER_19_175 VPWR VGND VPWR VGND sky130_fd_sc_hd__decap_3
XFILLER_19_164 VPWR VGND VPWR VGND sky130_fd_sc_hd__decap_3
XFILLER_15_57 VPWR VGND VPWR VGND sky130_fd_sc_hd__decap_3
XFILLER_15_24 VPWR VGND VPWR VGND sky130_fd_sc_hd__decap_3
XFILLER_13_329 VPWR VGND VPWR VGND sky130_fd_sc_hd__decap_3
XFILLER_0_299 VPWR VGND VPWR VGND sky130_fd_sc_hd__decap_3
XFILLER_0_277 VPWR VGND VPWR VGND sky130_fd_sc_hd__decap_3
XFILLER_0_200 VPWR VGND VPWR VGND sky130_fd_sc_hd__decap_3
XFILLER_16_189 VPWR VGND VPWR VGND sky130_fd_sc_hd__decap_3
XFILLER_16_156 VPWR VGND VPWR VGND sky130_fd_sc_hd__decap_3
XFILLER_16_112 VPWR VGND VPWR VGND sky130_fd_sc_hd__decap_3
XFILLER_11_3 VPWR VGND VPWR VGND sky130_fd_sc_hd__decap_3
XFILLER_22_159 VPWR VGND VPWR VGND sky130_fd_sc_hd__decap_3
XFILLER_22_115 VPWR VGND VPWR VGND sky130_fd_sc_hd__decap_3
XFILLER_21_181 VPWR VGND VPWR VGND sky130_fd_sc_hd__decap_3
XFILLER_13_137 VPWR VGND VPWR VGND sky130_fd_sc_hd__decap_3
XFILLER_9_108 VPWR VGND VPWR VGND sky130_fd_sc_hd__decap_3
XFILLER_9_119 VPWR VGND VPWR VGND sky130_fd_sc_hd__decap_3
XFILLER_3_27 VPWR VGND VPWR VGND sky130_fd_sc_hd__decap_3
XFILLER_5_314 VPWR VGND VPWR VGND sky130_fd_sc_hd__decap_3
XFILLER_8_130 VPWR VGND VPWR VGND sky130_fd_sc_hd__decap_3
XFILLER_8_141 VPWR VGND VPWR VGND sky130_fd_sc_hd__decap_3
XFILLER_8_174 VPWR VGND VPWR VGND sky130_fd_sc_hd__decap_3
XFILLER_12_192 VPWR VGND VPWR VGND sky130_fd_sc_hd__decap_3
XPHY_EDGE_ROW_19_Left_43 VPWR VGND VPWR VGND sky130_fd_sc_hd__decap_3
XFILLER_10_118 VPWR VGND VPWR VGND sky130_fd_sc_hd__decap_3
XFILLER_12_47 VPWR VGND VPWR VGND sky130_fd_sc_hd__decap_3
XFILLER_18_218 VPWR VGND VPWR VGND sky130_fd_sc_hd__decap_3
XFILLER_5_122 VPWR VGND VPWR VGND sky130_fd_sc_hd__decap_3
XFILLER_5_155 VPWR VGND VPWR VGND sky130_fd_sc_hd__decap_3
XFILLER_5_199 VPWR VGND VPWR VGND sky130_fd_sc_hd__decap_3
XFILLER_17_273 VPWR VGND VPWR VGND sky130_fd_sc_hd__decap_3
XFILLER_17_240 VPWR VGND VPWR VGND sky130_fd_sc_hd__decap_3
XFILLER_17_284 VPWR VGND VPWR VGND sky130_fd_sc_hd__decap_3
XFILLER_23_265 VPWR VGND VPWR VGND sky130_fd_sc_hd__decap_3
XPHY_EDGE_ROW_4_Left_28 VPWR VGND VPWR VGND sky130_fd_sc_hd__decap_3
XFILLER_23_287 VPWR VGND VPWR VGND sky130_fd_sc_hd__decap_3
XFILLER_23_57 VPWR VGND VPWR VGND sky130_fd_sc_hd__decap_3
XFILLER_23_35 VPWR VGND VPWR VGND sky130_fd_sc_hd__decap_3
XFILLER_23_24 VPWR VGND VPWR VGND sky130_fd_sc_hd__decap_3
XFILLER_2_147 VPWR VGND VPWR VGND sky130_fd_sc_hd__decap_3
XFILLER_2_136 VPWR VGND VPWR VGND sky130_fd_sc_hd__decap_3
XFILLER_2_103 VPWR VGND VPWR VGND sky130_fd_sc_hd__decap_3
Xmisfit01_core_7 uio_oe[7] misfit01_core_7/HI VPWR VGND VGND VPWR sky130_fd_sc_hd__conb_1
XFILLER_14_298 VPWR VGND VPWR VGND sky130_fd_sc_hd__decap_3
XFILLER_14_265 VPWR VGND VPWR VGND sky130_fd_sc_hd__decap_3
XFILLER_14_221 VPWR VGND VPWR VGND sky130_fd_sc_hd__decap_3
XFILLER_9_15 VPWR VGND VPWR VGND sky130_fd_sc_hd__decap_3
XFILLER_9_48 VPWR VGND VPWR VGND sky130_fd_sc_hd__decap_3
XFILLER_13_90 VPWR VGND VPWR VGND sky130_fd_sc_hd__decap_3
XFILLER_20_268 VPWR VGND VPWR VGND sky130_fd_sc_hd__decap_3
XFILLER_20_224 VPWR VGND VPWR VGND sky130_fd_sc_hd__decap_3
XFILLER_18_68 VPWR VGND VPWR VGND sky130_fd_sc_hd__decap_3
XFILLER_18_35 VPWR VGND VPWR VGND sky130_fd_sc_hd__decap_3
XFILLER_18_24 VPWR VGND VPWR VGND sky130_fd_sc_hd__decap_3
XFILLER_11_202 VPWR VGND VPWR VGND sky130_fd_sc_hd__decap_3
XFILLER_11_246 VPWR VGND VPWR VGND sky130_fd_sc_hd__decap_3
XFILLER_7_217 VPWR VGND VPWR VGND sky130_fd_sc_hd__decap_3
XFILLER_7_228 VPWR VGND VPWR VGND sky130_fd_sc_hd__decap_3
XFILLER_19_302 VPWR VGND VPWR VGND sky130_fd_sc_hd__decap_3
XFILLER_6_283 VPWR VGND VPWR VGND sky130_fd_sc_hd__decap_3
XFILLER_1_60 VPWR VGND VPWR VGND sky130_fd_sc_hd__decap_3
XFILLER_1_93 VPWR VGND VPWR VGND sky130_fd_sc_hd__decap_3
XFILLER_20_47 VPWR VGND VPWR VGND sky130_fd_sc_hd__decap_3
XFILLER_4_209 VPWR VGND VPWR VGND sky130_fd_sc_hd__decap_3
XFILLER_16_327 VPWR VGND VPWR VGND sky130_fd_sc_hd__decap_3
XPHY_EDGE_ROW_7_Left_31 VPWR VGND VPWR VGND sky130_fd_sc_hd__decap_3
XFILLER_3_220 VPWR VGND VPWR VGND sky130_fd_sc_hd__decap_3
XFILLER_3_231 VPWR VGND VPWR VGND sky130_fd_sc_hd__decap_3
XFILLER_3_264 VPWR VGND VPWR VGND sky130_fd_sc_hd__decap_3
XFILLER_6_38 VPWR VGND VPWR VGND sky130_fd_sc_hd__decap_3
XFILLER_10_80 VPWR VGND VPWR VGND sky130_fd_sc_hd__decap_3
XFILLER_10_91 VPWR VGND VPWR VGND sky130_fd_sc_hd__decap_3
XFILLER_19_143 VPWR VGND VPWR VGND sky130_fd_sc_hd__decap_3
XFILLER_19_187 VPWR VGND VPWR VGND sky130_fd_sc_hd__decap_3
XFILLER_15_69 VPWR VGND VPWR VGND sky130_fd_sc_hd__decap_3
XFILLER_15_36 VPWR VGND VPWR VGND sky130_fd_sc_hd__decap_3
XFILLER_13_308 VPWR VGND VPWR VGND sky130_fd_sc_hd__decap_3
XFILLER_0_212 VPWR VGND VPWR VGND sky130_fd_sc_hd__decap_3
XFILLER_0_256 VPWR VGND VPWR VGND sky130_fd_sc_hd__decap_3
XFILLER_0_234 VPWR VGND VPWR VGND sky130_fd_sc_hd__decap_3
XPHY_EDGE_ROW_19_Right_19 VPWR VGND VPWR VGND sky130_fd_sc_hd__decap_3
XFILLER_16_168 VPWR VGND VPWR VGND sky130_fd_sc_hd__decap_3
XFILLER_16_124 VPWR VGND VPWR VGND sky130_fd_sc_hd__decap_3
XFILLER_12_330 VPWR VGND VPWR VGND sky130_fd_sc_hd__decap_3
XFILLER_8_301 VPWR VGND VPWR VGND sky130_fd_sc_hd__decap_3
XFILLER_8_312 VPWR VGND VPWR VGND sky130_fd_sc_hd__decap_3
XFILLER_21_90 VPWR VGND VPWR VGND sky130_fd_sc_hd__decap_3
XFILLER_22_127 VPWR VGND VPWR VGND sky130_fd_sc_hd__decap_3
XFILLER_15_190 VPWR VGND VPWR VGND sky130_fd_sc_hd__decap_3
XFILLER_7_81 VPWR VGND VPWR VGND sky130_fd_sc_hd__decap_3
XFILLER_13_149 VPWR VGND VPWR VGND sky130_fd_sc_hd__decap_3
XFILLER_13_116 VPWR VGND VPWR VGND sky130_fd_sc_hd__decap_3
XFILLER_13_105 VPWR VGND VPWR VGND sky130_fd_sc_hd__decap_3
XFILLER_5_326 VPWR VGND VPWR VGND sky130_fd_sc_hd__decap_3
XFILLER_3_39 VPWR VGND VPWR VGND sky130_fd_sc_hd__decap_3
XFILLER_12_171 VPWR VGND VPWR VGND sky130_fd_sc_hd__decap_3
XFILLER_8_153 VPWR VGND VPWR VGND sky130_fd_sc_hd__decap_3
XFILLER_8_186 VPWR VGND VPWR VGND sky130_fd_sc_hd__decap_3
XFILLER_8_197 VPWR VGND VPWR VGND sky130_fd_sc_hd__decap_3
XFILLER_12_15 VPWR VGND VPWR VGND sky130_fd_sc_hd__decap_3
XFILLER_12_59 VPWR VGND VPWR VGND sky130_fd_sc_hd__decap_3
XFILLER_2_318 VPWR VGND VPWR VGND sky130_fd_sc_hd__decap_3
XFILLER_5_9 VPWR VGND VPWR VGND sky130_fd_sc_hd__decap_3
XFILLER_5_134 VPWR VGND VPWR VGND sky130_fd_sc_hd__decap_3
XFILLER_5_178 VPWR VGND VPWR VGND sky130_fd_sc_hd__decap_3
XPHY_EDGE_ROW_20_Left_44 VPWR VGND VPWR VGND sky130_fd_sc_hd__decap_3
XFILLER_17_296 VPWR VGND VPWR VGND sky130_fd_sc_hd__decap_3
XFILLER_17_252 VPWR VGND VPWR VGND sky130_fd_sc_hd__decap_3
XFILLER_4_71 VPWR VGND VPWR VGND sky130_fd_sc_hd__decap_3
XFILLER_23_277 VPWR VGND VPWR VGND sky130_fd_sc_hd__decap_3
XFILLER_23_47 VPWR VGND VPWR VGND sky130_fd_sc_hd__decap_3
XFILLER_3_6 VPWR VGND VPWR VGND sky130_fd_sc_hd__decap_3
XFILLER_2_159 VPWR VGND VPWR VGND sky130_fd_sc_hd__decap_3
XFILLER_2_115 VPWR VGND VPWR VGND sky130_fd_sc_hd__decap_3
XFILLER_14_200 VPWR VGND VPWR VGND sky130_fd_sc_hd__decap_3
XFILLER_0_18 VPWR VGND VPWR VGND sky130_fd_sc_hd__decap_3
XFILLER_0_29 VPWR VGND VPWR VGND sky130_fd_sc_hd__decap_3
Xmisfit01_core_8 uio_out[0] misfit01_core_8/HI VPWR VGND VGND VPWR sky130_fd_sc_hd__conb_1
XFILLER_14_277 VPWR VGND VPWR VGND sky130_fd_sc_hd__decap_3
XFILLER_14_233 VPWR VGND VPWR VGND sky130_fd_sc_hd__decap_3
XFILLER_9_27 VPWR VGND VPWR VGND sky130_fd_sc_hd__decap_3
XFILLER_1_181 VPWR VGND VPWR VGND sky130_fd_sc_hd__decap_3
XFILLER_20_203 VPWR VGND VPWR VGND sky130_fd_sc_hd__decap_3
XFILLER_20_236 VPWR VGND VPWR VGND sky130_fd_sc_hd__decap_3
XFILLER_9_270 VPWR VGND VPWR VGND sky130_fd_sc_hd__decap_3
XFILLER_9_281 VPWR VGND VPWR VGND sky130_fd_sc_hd__decap_3
XFILLER_18_47 VPWR VGND VPWR VGND sky130_fd_sc_hd__decap_3
XFILLER_11_214 VPWR VGND VPWR VGND sky130_fd_sc_hd__decap_3
XFILLER_11_225 VPWR VGND VPWR VGND sky130_fd_sc_hd__decap_3
XFILLER_11_258 VPWR VGND VPWR VGND sky130_fd_sc_hd__decap_3
XFILLER_1_3 VPWR VGND VPWR VGND sky130_fd_sc_hd__decap_3
XFILLER_19_314 VPWR VGND VPWR VGND sky130_fd_sc_hd__decap_3
XFILLER_6_262 VPWR VGND VPWR VGND sky130_fd_sc_hd__decap_3
XFILLER_10_280 VPWR VGND VPWR VGND sky130_fd_sc_hd__decap_3
XFILLER_6_295 VPWR VGND VPWR VGND sky130_fd_sc_hd__decap_3
XFILLER_1_72 VPWR VGND VPWR VGND sky130_fd_sc_hd__decap_3
XFILLER_20_59 VPWR VGND VPWR VGND sky130_fd_sc_hd__decap_3
XFILLER_20_15 VPWR VGND VPWR VGND sky130_fd_sc_hd__decap_3
XFILLER_3_243 VPWR VGND VPWR VGND sky130_fd_sc_hd__decap_3
XFILLER_3_276 VPWR VGND VPWR VGND sky130_fd_sc_hd__decap_3
XFILLER_3_287 VPWR VGND VPWR VGND sky130_fd_sc_hd__decap_3
XFILLER_19_199 VPWR VGND VPWR VGND sky130_fd_sc_hd__decap_3
XFILLER_19_155 VPWR VGND VPWR VGND sky130_fd_sc_hd__decap_3
XFILLER_19_122 VPWR VGND VPWR VGND sky130_fd_sc_hd__decap_3
XFILLER_19_90 VPWR VGND VPWR VGND sky130_fd_sc_hd__decap_3
XFILLER_20_9 VPWR VGND VPWR VGND sky130_fd_sc_hd__decap_3
XFILLER_22_309 VPWR VGND VPWR VGND sky130_fd_sc_hd__decap_3
XFILLER_15_48 VPWR VGND VPWR VGND sky130_fd_sc_hd__decap_3
XFILLER_15_15 VPWR VGND VPWR VGND sky130_fd_sc_hd__decap_3
XFILLER_21_320 VPWR VGND VPWR VGND sky130_fd_sc_hd__decap_3
XFILLER_0_246 VPWR VGND VPWR VGND sky130_fd_sc_hd__decap_3
XFILLER_16_103 VPWR VGND VPWR VGND sky130_fd_sc_hd__decap_3
XFILLER_0_268 VPWR VGND VPWR VGND sky130_fd_sc_hd__decap_3
XFILLER_16_147 VPWR VGND VPWR VGND sky130_fd_sc_hd__decap_3
XFILLER_16_136 VPWR VGND VPWR VGND sky130_fd_sc_hd__decap_3
XFILLER_8_324 VPWR VGND VPWR VGND sky130_fd_sc_hd__decap_3
XFILLER_22_106 VPWR VGND VPWR VGND sky130_fd_sc_hd__decap_3
XFILLER_7_60 VPWR VGND VPWR VGND sky130_fd_sc_hd__decap_3
XFILLER_7_93 VPWR VGND VPWR VGND sky130_fd_sc_hd__decap_3
XFILLER_13_128 VPWR VGND VPWR VGND sky130_fd_sc_hd__decap_3
XFILLER_21_172 VPWR VGND VPWR VGND sky130_fd_sc_hd__decap_3
XFILLER_21_161 VPWR VGND VPWR VGND sky130_fd_sc_hd__decap_3
XFILLER_5_305 VPWR VGND VPWR VGND sky130_fd_sc_hd__decap_3
XFILLER_3_18 VPWR VGND VPWR VGND sky130_fd_sc_hd__decap_3
XFILLER_16_91 VPWR VGND VPWR VGND sky130_fd_sc_hd__decap_3
XFILLER_16_80 VPWR VGND VPWR VGND sky130_fd_sc_hd__decap_3
XFILLER_8_121 VPWR VGND VPWR VGND sky130_fd_sc_hd__decap_3
XFILLER_12_150 VPWR VGND VPWR VGND sky130_fd_sc_hd__decap_3
XFILLER_12_183 VPWR VGND VPWR VGND sky130_fd_sc_hd__decap_3
XFILLER_8_165 VPWR VGND VPWR VGND sky130_fd_sc_hd__decap_3
XFILLER_10_109 VPWR VGND VPWR VGND sky130_fd_sc_hd__decap_3
XFILLER_12_38 VPWR VGND VPWR VGND sky130_fd_sc_hd__decap_3
XFILLER_18_209 VPWR VGND VPWR VGND sky130_fd_sc_hd__decap_3
XFILLER_5_102 VPWR VGND VPWR VGND sky130_fd_sc_hd__decap_3
XFILLER_5_113 VPWR VGND VPWR VGND sky130_fd_sc_hd__decap_3
XFILLER_5_146 VPWR VGND VPWR VGND sky130_fd_sc_hd__decap_3
XFILLER_17_264 VPWR VGND VPWR VGND sky130_fd_sc_hd__decap_3
XFILLER_17_231 VPWR VGND VPWR VGND sky130_fd_sc_hd__decap_3
XFILLER_17_220 VPWR VGND VPWR VGND sky130_fd_sc_hd__decap_3
XFILLER_4_50 VPWR VGND VPWR VGND sky130_fd_sc_hd__decap_3
XFILLER_4_94 VPWR VGND VPWR VGND sky130_fd_sc_hd__decap_3
XFILLER_23_256 VPWR VGND VPWR VGND sky130_fd_sc_hd__decap_3
XFILLER_23_15 VPWR VGND VPWR VGND sky130_fd_sc_hd__decap_3
XFILLER_2_127 VPWR VGND VPWR VGND sky130_fd_sc_hd__decap_3
XFILLER_14_256 VPWR VGND VPWR VGND sky130_fd_sc_hd__decap_3
XFILLER_14_245 VPWR VGND VPWR VGND sky130_fd_sc_hd__decap_3
XFILLER_14_212 VPWR VGND VPWR VGND sky130_fd_sc_hd__decap_3
Xmisfit01_core_9 uio_out[1] misfit01_core_9/HI VPWR VGND VGND VPWR sky130_fd_sc_hd__conb_1
XFILLER_14_289 VPWR VGND VPWR VGND sky130_fd_sc_hd__decap_3
XFILLER_13_81 VPWR VGND VPWR VGND sky130_fd_sc_hd__decap_3
XFILLER_9_39 VPWR VGND VPWR VGND sky130_fd_sc_hd__decap_3
XFILLER_1_193 VPWR VGND VPWR VGND sky130_fd_sc_hd__decap_3
XFILLER_20_248 VPWR VGND VPWR VGND sky130_fd_sc_hd__decap_3
XFILLER_20_215 VPWR VGND VPWR VGND sky130_fd_sc_hd__decap_3
XFILLER_20_259 VPWR VGND VPWR VGND sky130_fd_sc_hd__decap_3
XFILLER_9_293 VPWR VGND VPWR VGND sky130_fd_sc_hd__decap_3
XFILLER_18_15 VPWR VGND VPWR VGND sky130_fd_sc_hd__decap_3
XFILLER_18_59 VPWR VGND VPWR VGND sky130_fd_sc_hd__decap_3
XFILLER_7_208 VPWR VGND VPWR VGND sky130_fd_sc_hd__decap_3
XFILLER_11_237 VPWR VGND VPWR VGND sky130_fd_sc_hd__decap_3
XFILLER_19_326 VPWR VGND VPWR VGND sky130_fd_sc_hd__decap_3
XFILLER_6_230 VPWR VGND VPWR VGND sky130_fd_sc_hd__decap_3
XFILLER_6_274 VPWR VGND VPWR VGND sky130_fd_sc_hd__decap_3
XFILLER_10_292 VPWR VGND VPWR VGND sky130_fd_sc_hd__decap_3
XFILLER_1_51 VPWR VGND VPWR VGND sky130_fd_sc_hd__decap_3
XFILLER_1_84 VPWR VGND VPWR VGND sky130_fd_sc_hd__decap_3
XFILLER_20_38 VPWR VGND VPWR VGND sky130_fd_sc_hd__decap_3
XFILLER_16_318 VPWR VGND VPWR VGND sky130_fd_sc_hd__decap_3
XFILLER_3_211 VPWR VGND VPWR VGND sky130_fd_sc_hd__decap_3
XFILLER_6_18 VPWR VGND VPWR VGND sky130_fd_sc_hd__decap_3
XFILLER_6_29 VPWR VGND VPWR VGND sky130_fd_sc_hd__decap_3
XFILLER_3_255 VPWR VGND VPWR VGND sky130_fd_sc_hd__decap_3
XFILLER_3_299 VPWR VGND VPWR VGND sky130_fd_sc_hd__decap_3
XFILLER_10_71 VPWR VGND VPWR VGND sky130_fd_sc_hd__decap_3
XFILLER_19_178 VPWR VGND VPWR VGND sky130_fd_sc_hd__decap_3
XFILLER_19_134 VPWR VGND VPWR VGND sky130_fd_sc_hd__decap_3
XFILLER_13_9 VPWR VGND VPWR VGND sky130_fd_sc_hd__decap_3
XFILLER_15_27 VPWR VGND VPWR VGND sky130_fd_sc_hd__decap_3
XFILLER_21_332 VPWR VGND VPWR VGND sky130_fd_sc_hd__decap_3
XPHY_EDGE_ROW_1_Right_1 VPWR VGND VPWR VGND sky130_fd_sc_hd__decap_3
XFILLER_0_225 VPWR VGND VPWR VGND sky130_fd_sc_hd__decap_3
XFILLER_0_203 VPWR VGND VPWR VGND sky130_fd_sc_hd__decap_3
XFILLER_16_115 VPWR VGND VPWR VGND sky130_fd_sc_hd__decap_3
XFILLER_16_159 VPWR VGND VPWR VGND sky130_fd_sc_hd__decap_3
XFILLER_12_321 VPWR VGND VPWR VGND sky130_fd_sc_hd__decap_3
XFILLER_21_81 VPWR VGND VPWR VGND sky130_fd_sc_hd__decap_3
XFILLER_11_6 VPWR VGND VPWR VGND sky130_fd_sc_hd__decap_3
XFILLER_22_118 VPWR VGND VPWR VGND sky130_fd_sc_hd__decap_3
XFILLER_15_181 VPWR VGND VPWR VGND sky130_fd_sc_hd__decap_3
XFILLER_7_72 VPWR VGND VPWR VGND sky130_fd_sc_hd__decap_3
XFILLER_21_140 VPWR VGND VPWR VGND sky130_fd_sc_hd__decap_3
XFILLER_21_184 VPWR VGND VPWR VGND sky130_fd_sc_hd__decap_3
XFILLER_5_317 VPWR VGND VPWR VGND sky130_fd_sc_hd__decap_3
XFILLER_8_100 VPWR VGND VPWR VGND sky130_fd_sc_hd__decap_3
XFILLER_8_133 VPWR VGND VPWR VGND sky130_fd_sc_hd__decap_3
XFILLER_8_144 VPWR VGND VPWR VGND sky130_fd_sc_hd__decap_3
XFILLER_8_177 VPWR VGND VPWR VGND sky130_fd_sc_hd__decap_3
XFILLER_12_162 VPWR VGND VPWR VGND sky130_fd_sc_hd__decap_3
XFILLER_2_309 VPWR VGND VPWR VGND sky130_fd_sc_hd__decap_3
XFILLER_1_320 VPWR VGND VPWR VGND sky130_fd_sc_hd__decap_3
XFILLER_5_125 VPWR VGND VPWR VGND sky130_fd_sc_hd__decap_3
XFILLER_5_158 VPWR VGND VPWR VGND sky130_fd_sc_hd__decap_3
XFILLER_5_169 VPWR VGND VPWR VGND sky130_fd_sc_hd__decap_3
XFILLER_17_287 VPWR VGND VPWR VGND sky130_fd_sc_hd__decap_3
XFILLER_17_276 VPWR VGND VPWR VGND sky130_fd_sc_hd__decap_3
XFILLER_17_243 VPWR VGND VPWR VGND sky130_fd_sc_hd__decap_3
XFILLER_4_62 VPWR VGND VPWR VGND sky130_fd_sc_hd__decap_3
XFILLER_4_180 VPWR VGND VPWR VGND sky130_fd_sc_hd__decap_3
XFILLER_23_268 VPWR VGND VPWR VGND sky130_fd_sc_hd__decap_3
XFILLER_23_38 VPWR VGND VPWR VGND sky130_fd_sc_hd__decap_3
XFILLER_2_106 VPWR VGND VPWR VGND sky130_fd_sc_hd__decap_3
XFILLER_14_268 VPWR VGND VPWR VGND sky130_fd_sc_hd__decap_3
XFILLER_14_224 VPWR VGND VPWR VGND sky130_fd_sc_hd__decap_3
XFILLER_9_18 VPWR VGND VPWR VGND sky130_fd_sc_hd__decap_3
XFILLER_13_93 VPWR VGND VPWR VGND sky130_fd_sc_hd__decap_3
XFILLER_13_60 VPWR VGND VPWR VGND sky130_fd_sc_hd__decap_3
XFILLER_1_172 VPWR VGND VPWR VGND sky130_fd_sc_hd__decap_3
XFILLER_1_161 VPWR VGND VPWR VGND sky130_fd_sc_hd__decap_3
XFILLER_20_227 VPWR VGND VPWR VGND sky130_fd_sc_hd__decap_3
XFILLER_13_290 VPWR VGND VPWR VGND sky130_fd_sc_hd__decap_3
XFILLER_9_261 VPWR VGND VPWR VGND sky130_fd_sc_hd__decap_3
XFILLER_18_38 VPWR VGND VPWR VGND sky130_fd_sc_hd__decap_3
XFILLER_11_205 VPWR VGND VPWR VGND sky130_fd_sc_hd__decap_3
XFILLER_11_249 VPWR VGND VPWR VGND sky130_fd_sc_hd__decap_3
XFILLER_19_305 VPWR VGND VPWR VGND sky130_fd_sc_hd__decap_3
XFILLER_6_242 VPWR VGND VPWR VGND sky130_fd_sc_hd__decap_3
XFILLER_6_253 VPWR VGND VPWR VGND sky130_fd_sc_hd__decap_3
XFILLER_6_286 VPWR VGND VPWR VGND sky130_fd_sc_hd__decap_3
XFILLER_10_271 VPWR VGND VPWR VGND sky130_fd_sc_hd__decap_3
XFILLER_1_30 VPWR VGND VPWR VGND sky130_fd_sc_hd__decap_3
X_25_ VPWR VGND uo_out[1] _25_/A VPWR VGND _25_/a_27_47# sky130_fd_sc_hd__buf_2
XFILLER_1_63 VPWR VGND VPWR VGND sky130_fd_sc_hd__decap_3
XFILLER_1_96 VPWR VGND VPWR VGND sky130_fd_sc_hd__decap_3
XFILLER_3_234 VPWR VGND VPWR VGND sky130_fd_sc_hd__decap_3
XFILLER_19_113 VPWR VGND VPWR VGND sky130_fd_sc_hd__decap_3
XFILLER_19_102 VPWR VGND VPWR VGND sky130_fd_sc_hd__decap_3
XFILLER_3_267 VPWR VGND VPWR VGND sky130_fd_sc_hd__decap_3
XFILLER_10_50 VPWR VGND VPWR VGND sky130_fd_sc_hd__decap_3
XFILLER_10_94 VPWR VGND VPWR VGND sky130_fd_sc_hd__decap_3
XFILLER_19_146 VPWR VGND VPWR VGND sky130_fd_sc_hd__decap_3
XFILLER_19_81 VPWR VGND VPWR VGND sky130_fd_sc_hd__decap_3
XFILLER_21_311 VPWR VGND VPWR VGND sky130_fd_sc_hd__decap_3
XFILLER_15_39 VPWR VGND VPWR VGND sky130_fd_sc_hd__decap_3
XFILLER_0_259 VPWR VGND VPWR VGND sky130_fd_sc_hd__decap_3
XFILLER_0_237 VPWR VGND VPWR VGND sky130_fd_sc_hd__decap_3
XFILLER_0_215 VPWR VGND VPWR VGND sky130_fd_sc_hd__decap_3
XFILLER_16_127 VPWR VGND VPWR VGND sky130_fd_sc_hd__decap_3
XFILLER_8_304 VPWR VGND VPWR VGND sky130_fd_sc_hd__decap_3
XFILLER_8_315 VPWR VGND VPWR VGND sky130_fd_sc_hd__decap_3
XFILLER_21_93 VPWR VGND VPWR VGND sky130_fd_sc_hd__decap_3
XFILLER_21_60 VPWR VGND VPWR VGND sky130_fd_sc_hd__decap_3
Xclkbuf_0_clk VGND VPWR VGND VPWR clk clkbuf_0_clk/X clkbuf_0_clk/a_110_47# sky130_fd_sc_hd__clkbuf_16
XFILLER_15_193 VPWR VGND VPWR VGND sky130_fd_sc_hd__decap_3
XFILLER_7_51 VPWR VGND VPWR VGND sky130_fd_sc_hd__decap_3
XFILLER_7_84 VPWR VGND VPWR VGND sky130_fd_sc_hd__decap_3
XPHY_EDGE_ROW_15_Right_15 VPWR VGND VPWR VGND sky130_fd_sc_hd__decap_3
XFILLER_21_152 VPWR VGND VPWR VGND sky130_fd_sc_hd__decap_3
XFILLER_13_119 VPWR VGND VPWR VGND sky130_fd_sc_hd__decap_3
XFILLER_13_108 VPWR VGND VPWR VGND sky130_fd_sc_hd__decap_3
XFILLER_5_329 VPWR VGND VPWR VGND sky130_fd_sc_hd__decap_3
XFILLER_16_71 VPWR VGND VPWR VGND sky130_fd_sc_hd__decap_3
XFILLER_8_112 VPWR VGND VPWR VGND sky130_fd_sc_hd__decap_3
XFILLER_8_156 VPWR VGND VPWR VGND sky130_fd_sc_hd__decap_3
XFILLER_8_189 VPWR VGND VPWR VGND sky130_fd_sc_hd__decap_3
XFILLER_12_130 VPWR VGND VPWR VGND sky130_fd_sc_hd__decap_3
XFILLER_12_141 VPWR VGND VPWR VGND sky130_fd_sc_hd__decap_3
XFILLER_12_174 VPWR VGND VPWR VGND sky130_fd_sc_hd__decap_3
XFILLER_12_18 VPWR VGND VPWR VGND sky130_fd_sc_hd__decap_3
XFILLER_12_29 VPWR VGND VPWR VGND sky130_fd_sc_hd__decap_3
XFILLER_5_137 VPWR VGND VPWR VGND sky130_fd_sc_hd__decap_3
XFILLER_1_332 VPWR VGND VPWR VGND sky130_fd_sc_hd__decap_3
XFILLER_17_255 VPWR VGND VPWR VGND sky130_fd_sc_hd__decap_3
XFILLER_17_211 VPWR VGND VPWR VGND sky130_fd_sc_hd__decap_3
XFILLER_17_299 VPWR VGND VPWR VGND sky130_fd_sc_hd__decap_3
XFILLER_4_41 VPWR VGND VPWR VGND sky130_fd_sc_hd__decap_3
XFILLER_4_74 VPWR VGND VPWR VGND sky130_fd_sc_hd__decap_3
XFILLER_4_85 VPWR VGND VPWR VGND sky130_fd_sc_hd__decap_3
XFILLER_4_192 VPWR VGND VPWR VGND sky130_fd_sc_hd__decap_3
XFILLER_23_225 VPWR VGND VPWR VGND sky130_fd_sc_hd__decap_3
XFILLER_3_9 VPWR VGND VPWR VGND sky130_fd_sc_hd__decap_3
XFILLER_2_118 VPWR VGND VPWR VGND sky130_fd_sc_hd__decap_3
XFILLER_14_236 VPWR VGND VPWR VGND sky130_fd_sc_hd__decap_3
XFILLER_14_203 VPWR VGND VPWR VGND sky130_fd_sc_hd__decap_3
XFILLER_22_280 VPWR VGND VPWR VGND sky130_fd_sc_hd__decap_3
XFILLER_13_72 VPWR VGND VPWR VGND sky130_fd_sc_hd__decap_3
XFILLER_1_184 VPWR VGND VPWR VGND sky130_fd_sc_hd__decap_3
XFILLER_1_140 VPWR VGND VPWR VGND sky130_fd_sc_hd__decap_3
XFILLER_20_239 VPWR VGND VPWR VGND sky130_fd_sc_hd__decap_3
XFILLER_20_206 VPWR VGND VPWR VGND sky130_fd_sc_hd__decap_3
XFILLER_9_240 VPWR VGND VPWR VGND sky130_fd_sc_hd__decap_3
XFILLER_9_273 VPWR VGND VPWR VGND sky130_fd_sc_hd__decap_3
XFILLER_9_284 VPWR VGND VPWR VGND sky130_fd_sc_hd__decap_3
XFILLER_11_217 VPWR VGND VPWR VGND sky130_fd_sc_hd__decap_3
XFILLER_11_228 VPWR VGND VPWR VGND sky130_fd_sc_hd__decap_3
XFILLER_1_6 VPWR VGND VPWR VGND sky130_fd_sc_hd__decap_3
XFILLER_19_317 VPWR VGND VPWR VGND sky130_fd_sc_hd__decap_3
XFILLER_6_221 VPWR VGND VPWR VGND sky130_fd_sc_hd__decap_3
XFILLER_6_265 VPWR VGND VPWR VGND sky130_fd_sc_hd__decap_3
XFILLER_6_298 VPWR VGND VPWR VGND sky130_fd_sc_hd__decap_3
XFILLER_10_283 VPWR VGND VPWR VGND sky130_fd_sc_hd__decap_3
X_24_ VPWR VGND uo_out[0] _24_/A VPWR VGND _24_/a_27_47# sky130_fd_sc_hd__buf_2
XFILLER_1_42 VPWR VGND VPWR VGND sky130_fd_sc_hd__decap_3
XFILLER_1_75 VPWR VGND VPWR VGND sky130_fd_sc_hd__decap_3
XFILLER_20_29 VPWR VGND VPWR VGND sky130_fd_sc_hd__decap_3
XFILLER_20_18 VPWR VGND VPWR VGND sky130_fd_sc_hd__decap_3
XFILLER_16_309 VPWR VGND VPWR VGND sky130_fd_sc_hd__decap_3
XFILLER_3_202 VPWR VGND VPWR VGND sky130_fd_sc_hd__decap_3
XFILLER_3_246 VPWR VGND VPWR VGND sky130_fd_sc_hd__decap_3
XFILLER_10_62 VPWR VGND VPWR VGND sky130_fd_sc_hd__decap_3
XFILLER_19_125 VPWR VGND VPWR VGND sky130_fd_sc_hd__decap_3
XFILLER_19_60 VPWR VGND VPWR VGND sky130_fd_sc_hd__decap_3
XFILLER_19_169 VPWR VGND VPWR VGND sky130_fd_sc_hd__decap_3
XFILLER_19_158 VPWR VGND VPWR VGND sky130_fd_sc_hd__decap_3
XFILLER_19_93 VPWR VGND VPWR VGND sky130_fd_sc_hd__decap_3
XFILLER_15_320 VPWR VGND VPWR VGND sky130_fd_sc_hd__decap_3
XPHY_EDGE_ROW_11_Left_35 VPWR VGND VPWR VGND sky130_fd_sc_hd__decap_3
XFILLER_21_323 VPWR VGND VPWR VGND sky130_fd_sc_hd__decap_3
XFILLER_18_180 VPWR VGND VPWR VGND sky130_fd_sc_hd__decap_3
XFILLER_15_18 VPWR VGND VPWR VGND sky130_fd_sc_hd__decap_3
XFILLER_0_249 VPWR VGND VPWR VGND sky130_fd_sc_hd__decap_3
Xmisfit01_core uio_oe[3] misfit01_core/HI VPWR VGND VGND VPWR sky130_fd_sc_hd__conb_1
XFILLER_16_106 VPWR VGND VPWR VGND sky130_fd_sc_hd__decap_3
XFILLER_12_312 VPWR VGND VPWR VGND sky130_fd_sc_hd__decap_3
XFILLER_12_301 VPWR VGND VPWR VGND sky130_fd_sc_hd__decap_3
XFILLER_8_327 VPWR VGND VPWR VGND sky130_fd_sc_hd__decap_3
XFILLER_21_72 VPWR VGND VPWR VGND sky130_fd_sc_hd__decap_3
XFILLER_22_109 VPWR VGND VPWR VGND sky130_fd_sc_hd__decap_3
XFILLER_15_172 VPWR VGND VPWR VGND sky130_fd_sc_hd__decap_3
XFILLER_15_161 VPWR VGND VPWR VGND sky130_fd_sc_hd__decap_3
XFILLER_7_30 VPWR VGND VPWR VGND sky130_fd_sc_hd__decap_3
XFILLER_7_63 VPWR VGND VPWR VGND sky130_fd_sc_hd__decap_3
XFILLER_7_96 VPWR VGND VPWR VGND sky130_fd_sc_hd__decap_3
XFILLER_21_175 VPWR VGND VPWR VGND sky130_fd_sc_hd__decap_3
XFILLER_21_164 VPWR VGND VPWR VGND sky130_fd_sc_hd__decap_3
XFILLER_21_131 VPWR VGND VPWR VGND sky130_fd_sc_hd__decap_3
XFILLER_5_308 VPWR VGND VPWR VGND sky130_fd_sc_hd__decap_3
XFILLER_16_94 VPWR VGND VPWR VGND sky130_fd_sc_hd__decap_3
XFILLER_16_50 VPWR VGND VPWR VGND sky130_fd_sc_hd__decap_3
XFILLER_12_153 VPWR VGND VPWR VGND sky130_fd_sc_hd__decap_3
XFILLER_4_330 VPWR VGND VPWR VGND sky130_fd_sc_hd__decap_3
XFILLER_8_124 VPWR VGND VPWR VGND sky130_fd_sc_hd__decap_3
XFILLER_8_168 VPWR VGND VPWR VGND sky130_fd_sc_hd__decap_3
XFILLER_12_186 VPWR VGND VPWR VGND sky130_fd_sc_hd__decap_3
XFILLER_12_197 VPWR VGND VPWR VGND sky130_fd_sc_hd__decap_3
XFILLER_7_190 VPWR VGND VPWR VGND sky130_fd_sc_hd__decap_3
XFILLER_5_105 VPWR VGND VPWR VGND sky130_fd_sc_hd__decap_3
XFILLER_5_116 VPWR VGND VPWR VGND sky130_fd_sc_hd__decap_3
XFILLER_5_149 VPWR VGND VPWR VGND sky130_fd_sc_hd__decap_3
XFILLER_1_311 VPWR VGND VPWR VGND sky130_fd_sc_hd__decap_3
XFILLER_17_267 VPWR VGND VPWR VGND sky130_fd_sc_hd__decap_3
XFILLER_17_234 VPWR VGND VPWR VGND sky130_fd_sc_hd__decap_3
XFILLER_4_171 VPWR VGND VPWR VGND sky130_fd_sc_hd__decap_3
XFILLER_4_53 VPWR VGND VPWR VGND sky130_fd_sc_hd__decap_3
XFILLER_4_97 VPWR VGND VPWR VGND sky130_fd_sc_hd__decap_3
XFILLER_23_259 VPWR VGND VPWR VGND sky130_fd_sc_hd__decap_3
XFILLER_23_248 VPWR VGND VPWR VGND sky130_fd_sc_hd__decap_3
XFILLER_23_18 VPWR VGND VPWR VGND sky130_fd_sc_hd__decap_3
XFILLER_23_29 VPWR VGND VPWR VGND sky130_fd_sc_hd__decap_3
XFILLER_22_292 VPWR VGND VPWR VGND sky130_fd_sc_hd__decap_3
XFILLER_14_259 VPWR VGND VPWR VGND sky130_fd_sc_hd__decap_3
XFILLER_14_248 VPWR VGND VPWR VGND sky130_fd_sc_hd__decap_3
XFILLER_14_215 VPWR VGND VPWR VGND sky130_fd_sc_hd__decap_3
XFILLER_13_51 VPWR VGND VPWR VGND sky130_fd_sc_hd__decap_3
XFILLER_13_84 VPWR VGND VPWR VGND sky130_fd_sc_hd__decap_3
XFILLER_1_196 VPWR VGND VPWR VGND sky130_fd_sc_hd__decap_3
XFILLER_1_152 VPWR VGND VPWR VGND sky130_fd_sc_hd__decap_3
XFILLER_20_218 VPWR VGND VPWR VGND sky130_fd_sc_hd__decap_3
XFILLER_13_281 VPWR VGND VPWR VGND sky130_fd_sc_hd__decap_3
XFILLER_13_270 VPWR VGND VPWR VGND sky130_fd_sc_hd__decap_3
XFILLER_9_252 VPWR VGND VPWR VGND sky130_fd_sc_hd__decap_3
XFILLER_9_296 VPWR VGND VPWR VGND sky130_fd_sc_hd__decap_3
XFILLER_18_29 VPWR VGND VPWR VGND sky130_fd_sc_hd__decap_3
XFILLER_18_18 VPWR VGND VPWR VGND sky130_fd_sc_hd__decap_3
XFILLER_19_329 VPWR VGND VPWR VGND sky130_fd_sc_hd__decap_3
XFILLER_6_200 VPWR VGND VPWR VGND sky130_fd_sc_hd__decap_3
XFILLER_6_233 VPWR VGND VPWR VGND sky130_fd_sc_hd__decap_3
XFILLER_10_262 VPWR VGND VPWR VGND sky130_fd_sc_hd__decap_3
XFILLER_10_295 VPWR VGND VPWR VGND sky130_fd_sc_hd__decap_3
XFILLER_6_277 VPWR VGND VPWR VGND sky130_fd_sc_hd__decap_3
XFILLER_1_21 VPWR VGND VPWR VGND sky130_fd_sc_hd__decap_3
XFILLER_1_87 VPWR VGND VPWR VGND sky130_fd_sc_hd__decap_3
XFILLER_3_214 VPWR VGND VPWR VGND sky130_fd_sc_hd__decap_3
XFILLER_3_225 VPWR VGND VPWR VGND sky130_fd_sc_hd__decap_3
XFILLER_3_258 VPWR VGND VPWR VGND sky130_fd_sc_hd__decap_3
XFILLER_10_41 VPWR VGND VPWR VGND sky130_fd_sc_hd__decap_3
XFILLER_10_74 VPWR VGND VPWR VGND sky130_fd_sc_hd__decap_3
XFILLER_10_85 VPWR VGND VPWR VGND sky130_fd_sc_hd__decap_3
XFILLER_19_137 VPWR VGND VPWR VGND sky130_fd_sc_hd__decap_3
XFILLER_19_72 VPWR VGND VPWR VGND sky130_fd_sc_hd__decap_3
XFILLER_15_332 VPWR VGND VPWR VGND sky130_fd_sc_hd__decap_3
XFILLER_2_280 VPWR VGND VPWR VGND sky130_fd_sc_hd__decap_3
XFILLER_18_192 VPWR VGND VPWR VGND sky130_fd_sc_hd__decap_3
XFILLER_21_302 VPWR VGND VPWR VGND sky130_fd_sc_hd__decap_3
XFILLER_0_228 VPWR VGND VPWR VGND sky130_fd_sc_hd__decap_3
XFILLER_0_206 VPWR VGND VPWR VGND sky130_fd_sc_hd__decap_3
XFILLER_16_118 VPWR VGND VPWR VGND sky130_fd_sc_hd__decap_3
XFILLER_12_324 VPWR VGND VPWR VGND sky130_fd_sc_hd__decap_3
XFILLER_21_51 VPWR VGND VPWR VGND sky130_fd_sc_hd__decap_3
XFILLER_21_84 VPWR VGND VPWR VGND sky130_fd_sc_hd__decap_3
XFILLER_11_9 VPWR VGND VPWR VGND sky130_fd_sc_hd__decap_3
XFILLER_15_184 VPWR VGND VPWR VGND sky130_fd_sc_hd__decap_3
XFILLER_15_140 VPWR VGND VPWR VGND sky130_fd_sc_hd__decap_3
XFILLER_7_42 VPWR VGND VPWR VGND sky130_fd_sc_hd__decap_3
XFILLER_7_75 VPWR VGND VPWR VGND sky130_fd_sc_hd__decap_3
XPHY_EDGE_ROW_5_Right_5 VPWR VGND VPWR VGND sky130_fd_sc_hd__decap_3
XFILLER_21_187 VPWR VGND VPWR VGND sky130_fd_sc_hd__decap_3
XFILLER_21_143 VPWR VGND VPWR VGND sky130_fd_sc_hd__decap_3
XFILLER_16_62 VPWR VGND VPWR VGND sky130_fd_sc_hd__decap_3
XFILLER_8_103 VPWR VGND VPWR VGND sky130_fd_sc_hd__decap_3
XFILLER_8_136 VPWR VGND VPWR VGND sky130_fd_sc_hd__decap_3
XFILLER_12_121 VPWR VGND VPWR VGND sky130_fd_sc_hd__decap_3
XFILLER_12_165 VPWR VGND VPWR VGND sky130_fd_sc_hd__decap_3
XFILLER_8_147 VPWR VGND VPWR VGND sky130_fd_sc_hd__decap_3
XFILLER_5_128 VPWR VGND VPWR VGND sky130_fd_sc_hd__decap_3
XFILLER_1_323 VPWR VGND VPWR VGND sky130_fd_sc_hd__decap_3
XFILLER_17_246 VPWR VGND VPWR VGND sky130_fd_sc_hd__decap_3
XFILLER_17_202 VPWR VGND VPWR VGND sky130_fd_sc_hd__decap_3
XFILLER_4_21 VPWR VGND VPWR VGND sky130_fd_sc_hd__decap_3
XFILLER_4_32 VPWR VGND VPWR VGND sky130_fd_sc_hd__decap_3
XFILLER_4_65 VPWR VGND VPWR VGND sky130_fd_sc_hd__decap_3
XFILLER_4_150 VPWR VGND VPWR VGND sky130_fd_sc_hd__decap_3
XFILLER_4_183 VPWR VGND VPWR VGND sky130_fd_sc_hd__decap_3
XFILLER_2_109 VPWR VGND VPWR VGND sky130_fd_sc_hd__decap_3
XFILLER_14_227 VPWR VGND VPWR VGND sky130_fd_sc_hd__decap_3
XFILLER_22_271 VPWR VGND VPWR VGND sky130_fd_sc_hd__decap_3
XFILLER_13_63 VPWR VGND VPWR VGND sky130_fd_sc_hd__decap_3
XFILLER_13_30 VPWR VGND VPWR VGND sky130_fd_sc_hd__decap_3
XFILLER_13_96 VPWR VGND VPWR VGND sky130_fd_sc_hd__decap_3
XFILLER_1_131 VPWR VGND VPWR VGND sky130_fd_sc_hd__decap_3
XFILLER_1_175 VPWR VGND VPWR VGND sky130_fd_sc_hd__decap_3
XFILLER_1_164 VPWR VGND VPWR VGND sky130_fd_sc_hd__decap_3
XFILLER_13_293 VPWR VGND VPWR VGND sky130_fd_sc_hd__decap_3
XFILLER_9_220 VPWR VGND VPWR VGND sky130_fd_sc_hd__decap_3
XFILLER_9_231 VPWR VGND VPWR VGND sky130_fd_sc_hd__decap_3
XFILLER_9_264 VPWR VGND VPWR VGND sky130_fd_sc_hd__decap_3
XFILLER_11_208 VPWR VGND VPWR VGND sky130_fd_sc_hd__decap_3
XFILLER_19_308 VPWR VGND VPWR VGND sky130_fd_sc_hd__decap_3
XFILLER_6_212 VPWR VGND VPWR VGND sky130_fd_sc_hd__decap_3
XFILLER_6_245 VPWR VGND VPWR VGND sky130_fd_sc_hd__decap_3
XFILLER_6_256 VPWR VGND VPWR VGND sky130_fd_sc_hd__decap_3
XFILLER_10_230 VPWR VGND VPWR VGND sky130_fd_sc_hd__decap_3
XFILLER_10_274 VPWR VGND VPWR VGND sky130_fd_sc_hd__decap_3
XFILLER_6_289 VPWR VGND VPWR VGND sky130_fd_sc_hd__decap_3
XFILLER_18_330 VPWR VGND VPWR VGND sky130_fd_sc_hd__decap_3
XFILLER_1_33 VPWR VGND VPWR VGND sky130_fd_sc_hd__decap_3
XFILLER_1_66 VPWR VGND VPWR VGND sky130_fd_sc_hd__decap_3
XFILLER_1_99 VPWR VGND VPWR VGND sky130_fd_sc_hd__decap_3
XFILLER_3_237 VPWR VGND VPWR VGND sky130_fd_sc_hd__decap_3
XFILLER_10_53 VPWR VGND VPWR VGND sky130_fd_sc_hd__decap_3
XFILLER_10_97 VPWR VGND VPWR VGND sky130_fd_sc_hd__decap_3
XFILLER_19_149 VPWR VGND VPWR VGND sky130_fd_sc_hd__decap_3
XFILLER_19_116 VPWR VGND VPWR VGND sky130_fd_sc_hd__decap_3
XFILLER_19_105 VPWR VGND VPWR VGND sky130_fd_sc_hd__decap_3
XFILLER_19_84 VPWR VGND VPWR VGND sky130_fd_sc_hd__decap_3
XFILLER_19_51 VPWR VGND VPWR VGND sky130_fd_sc_hd__decap_3
XFILLER_15_311 VPWR VGND VPWR VGND sky130_fd_sc_hd__decap_3
XFILLER_18_3 VPWR VGND VPWR VGND sky130_fd_sc_hd__decap_3
XFILLER_2_292 VPWR VGND VPWR VGND sky130_fd_sc_hd__decap_3
XFILLER_18_171 VPWR VGND VPWR VGND sky130_fd_sc_hd__decap_3
XFILLER_21_314 VPWR VGND VPWR VGND sky130_fd_sc_hd__decap_3
XFILLER_0_218 VPWR VGND VPWR VGND sky130_fd_sc_hd__decap_3
XFILLER_8_318 VPWR VGND VPWR VGND sky130_fd_sc_hd__decap_3
XFILLER_21_96 VPWR VGND VPWR VGND sky130_fd_sc_hd__decap_3
XFILLER_21_63 VPWR VGND VPWR VGND sky130_fd_sc_hd__decap_3
XFILLER_21_30 VPWR VGND VPWR VGND sky130_fd_sc_hd__decap_3
XFILLER_15_152 VPWR VGND VPWR VGND sky130_fd_sc_hd__decap_3
XFILLER_15_196 VPWR VGND VPWR VGND sky130_fd_sc_hd__decap_3
XFILLER_7_21 VPWR VGND VPWR VGND sky130_fd_sc_hd__decap_3
XFILLER_7_87 VPWR VGND VPWR VGND sky130_fd_sc_hd__decap_3
XFILLER_21_122 VPWR VGND VPWR VGND sky130_fd_sc_hd__decap_3
XFILLER_21_155 VPWR VGND VPWR VGND sky130_fd_sc_hd__decap_3
XFILLER_16_41 VPWR VGND VPWR VGND sky130_fd_sc_hd__decap_3
XFILLER_16_85 VPWR VGND VPWR VGND sky130_fd_sc_hd__decap_3
XFILLER_16_74 VPWR VGND VPWR VGND sky130_fd_sc_hd__decap_3
XFILLER_8_115 VPWR VGND VPWR VGND sky130_fd_sc_hd__decap_3
XFILLER_8_159 VPWR VGND VPWR VGND sky130_fd_sc_hd__decap_3
XPHY_EDGE_ROW_11_Right_11 VPWR VGND VPWR VGND sky130_fd_sc_hd__decap_3
XFILLER_12_100 VPWR VGND VPWR VGND sky130_fd_sc_hd__decap_3
XFILLER_12_133 VPWR VGND VPWR VGND sky130_fd_sc_hd__decap_3
XFILLER_12_144 VPWR VGND VPWR VGND sky130_fd_sc_hd__decap_3
XFILLER_12_177 VPWR VGND VPWR VGND sky130_fd_sc_hd__decap_3
XPHY_EDGE_ROW_20_Right_20 VPWR VGND VPWR VGND sky130_fd_sc_hd__decap_3
XFILLER_4_321 VPWR VGND VPWR VGND sky130_fd_sc_hd__decap_3
XFILLER_7_181 VPWR VGND VPWR VGND sky130_fd_sc_hd__decap_3
XFILLER_1_302 VPWR VGND VPWR VGND sky130_fd_sc_hd__decap_3
XFILLER_17_258 VPWR VGND VPWR VGND sky130_fd_sc_hd__decap_3
XFILLER_17_225 VPWR VGND VPWR VGND sky130_fd_sc_hd__decap_3
XFILLER_17_214 VPWR VGND VPWR VGND sky130_fd_sc_hd__decap_3
XFILLER_4_44 VPWR VGND VPWR VGND sky130_fd_sc_hd__decap_3
XFILLER_4_77 VPWR VGND VPWR VGND sky130_fd_sc_hd__decap_3
XFILLER_4_88 VPWR VGND VPWR VGND sky130_fd_sc_hd__decap_3
XFILLER_4_162 VPWR VGND VPWR VGND sky130_fd_sc_hd__decap_3
XFILLER_16_280 VPWR VGND VPWR VGND sky130_fd_sc_hd__decap_3
XFILLER_14_239 VPWR VGND VPWR VGND sky130_fd_sc_hd__decap_3
XFILLER_14_206 VPWR VGND VPWR VGND sky130_fd_sc_hd__decap_3
XFILLER_22_283 VPWR VGND VPWR VGND sky130_fd_sc_hd__decap_3
XFILLER_13_75 VPWR VGND VPWR VGND sky130_fd_sc_hd__decap_3
XFILLER_13_42 VPWR VGND VPWR VGND sky130_fd_sc_hd__decap_3
XFILLER_1_143 VPWR VGND VPWR VGND sky130_fd_sc_hd__decap_3
XFILLER_1_187 VPWR VGND VPWR VGND sky130_fd_sc_hd__decap_3
XFILLER_20_209 VPWR VGND VPWR VGND sky130_fd_sc_hd__decap_3
XFILLER_13_261 VPWR VGND VPWR VGND sky130_fd_sc_hd__decap_3
XFILLER_9_243 VPWR VGND VPWR VGND sky130_fd_sc_hd__decap_3
XFILLER_9_276 VPWR VGND VPWR VGND sky130_fd_sc_hd__decap_3
XFILLER_9_287 VPWR VGND VPWR VGND sky130_fd_sc_hd__decap_3
XFILLER_1_9 VPWR VGND VPWR VGND sky130_fd_sc_hd__decap_3
XFILLER_6_224 VPWR VGND VPWR VGND sky130_fd_sc_hd__decap_3
XFILLER_6_268 VPWR VGND VPWR VGND sky130_fd_sc_hd__decap_3
XFILLER_10_242 VPWR VGND VPWR VGND sky130_fd_sc_hd__decap_3
XFILLER_10_253 VPWR VGND VPWR VGND sky130_fd_sc_hd__decap_3
XFILLER_10_286 VPWR VGND VPWR VGND sky130_fd_sc_hd__decap_3
XFILLER_1_12 VPWR VGND VPWR VGND sky130_fd_sc_hd__decap_3
XFILLER_1_45 VPWR VGND VPWR VGND sky130_fd_sc_hd__decap_3
XFILLER_1_78 VPWR VGND VPWR VGND sky130_fd_sc_hd__decap_3
XFILLER_5_290 VPWR VGND VPWR VGND sky130_fd_sc_hd__decap_3
XFILLER_3_205 VPWR VGND VPWR VGND sky130_fd_sc_hd__decap_3
XFILLER_10_21 VPWR VGND VPWR VGND sky130_fd_sc_hd__decap_3
XFILLER_19_30 VPWR VGND VPWR VGND sky130_fd_sc_hd__decap_3
XFILLER_3_249 VPWR VGND VPWR VGND sky130_fd_sc_hd__decap_3
XFILLER_10_32 VPWR VGND VPWR VGND sky130_fd_sc_hd__decap_3
XFILLER_10_65 VPWR VGND VPWR VGND sky130_fd_sc_hd__decap_3
XFILLER_19_128 VPWR VGND VPWR VGND sky130_fd_sc_hd__decap_3
XFILLER_19_96 VPWR VGND VPWR VGND sky130_fd_sc_hd__decap_3
XFILLER_19_63 VPWR VGND VPWR VGND sky130_fd_sc_hd__decap_3
XFILLER_15_323 VPWR VGND VPWR VGND sky130_fd_sc_hd__decap_3
XFILLER_2_271 VPWR VGND VPWR VGND sky130_fd_sc_hd__decap_3
XFILLER_21_326 VPWR VGND VPWR VGND sky130_fd_sc_hd__decap_3
XFILLER_18_183 VPWR VGND VPWR VGND sky130_fd_sc_hd__decap_3
XFILLER_18_150 VPWR VGND VPWR VGND sky130_fd_sc_hd__decap_3
XFILLER_16_109 VPWR VGND VPWR VGND sky130_fd_sc_hd__decap_3
XFILLER_12_315 VPWR VGND VPWR VGND sky130_fd_sc_hd__decap_3
XFILLER_12_304 VPWR VGND VPWR VGND sky130_fd_sc_hd__decap_3
XFILLER_21_75 VPWR VGND VPWR VGND sky130_fd_sc_hd__decap_3
XFILLER_21_42 VPWR VGND VPWR VGND sky130_fd_sc_hd__decap_3
XFILLER_15_175 VPWR VGND VPWR VGND sky130_fd_sc_hd__decap_3
XFILLER_15_164 VPWR VGND VPWR VGND sky130_fd_sc_hd__decap_3
XFILLER_15_131 VPWR VGND VPWR VGND sky130_fd_sc_hd__decap_3
XPHY_EDGE_ROW_15_Left_39 VPWR VGND VPWR VGND sky130_fd_sc_hd__decap_3
XFILLER_7_33 VPWR VGND VPWR VGND sky130_fd_sc_hd__decap_3
XFILLER_7_66 VPWR VGND VPWR VGND sky130_fd_sc_hd__decap_3
XFILLER_7_99 VPWR VGND VPWR VGND sky130_fd_sc_hd__decap_3
XFILLER_21_178 VPWR VGND VPWR VGND sky130_fd_sc_hd__decap_3
XFILLER_21_134 VPWR VGND VPWR VGND sky130_fd_sc_hd__decap_3
XFILLER_16_53 VPWR VGND VPWR VGND sky130_fd_sc_hd__decap_3
XFILLER_16_97 VPWR VGND VPWR VGND sky130_fd_sc_hd__decap_3
XFILLER_8_127 VPWR VGND VPWR VGND sky130_fd_sc_hd__decap_3
XFILLER_12_112 VPWR VGND VPWR VGND sky130_fd_sc_hd__decap_3
XFILLER_12_156 VPWR VGND VPWR VGND sky130_fd_sc_hd__decap_3
XFILLER_12_189 VPWR VGND VPWR VGND sky130_fd_sc_hd__decap_3
XFILLER_7_193 VPWR VGND VPWR VGND sky130_fd_sc_hd__decap_3
XFILLER_5_108 VPWR VGND VPWR VGND sky130_fd_sc_hd__decap_3
XFILLER_5_119 VPWR VGND VPWR VGND sky130_fd_sc_hd__decap_3
XFILLER_1_314 VPWR VGND VPWR VGND sky130_fd_sc_hd__decap_3
XFILLER_17_237 VPWR VGND VPWR VGND sky130_fd_sc_hd__decap_3
XFILLER_4_130 VPWR VGND VPWR VGND sky130_fd_sc_hd__decap_3
XFILLER_4_141 VPWR VGND VPWR VGND sky130_fd_sc_hd__decap_3
XFILLER_4_12 VPWR VGND VPWR VGND sky130_fd_sc_hd__decap_3
XFILLER_4_56 VPWR VGND VPWR VGND sky130_fd_sc_hd__decap_3
XFILLER_4_174 VPWR VGND VPWR VGND sky130_fd_sc_hd__decap_3
XFILLER_16_292 VPWR VGND VPWR VGND sky130_fd_sc_hd__decap_3
XPHY_EDGE_ROW_18_Left_42 VPWR VGND VPWR VGND sky130_fd_sc_hd__decap_3
XFILLER_14_218 VPWR VGND VPWR VGND sky130_fd_sc_hd__decap_3
XFILLER_22_295 VPWR VGND VPWR VGND sky130_fd_sc_hd__decap_3
XFILLER_22_262 VPWR VGND VPWR VGND sky130_fd_sc_hd__decap_3
XFILLER_13_87 VPWR VGND VPWR VGND sky130_fd_sc_hd__decap_3
XFILLER_13_21 VPWR VGND VPWR VGND sky130_fd_sc_hd__decap_3
XFILLER_1_199 VPWR VGND VPWR VGND sky130_fd_sc_hd__decap_3
XFILLER_1_155 VPWR VGND VPWR VGND sky130_fd_sc_hd__decap_3
XFILLER_1_122 VPWR VGND VPWR VGND sky130_fd_sc_hd__decap_3
XFILLER_8_3 VPWR VGND VPWR VGND sky130_fd_sc_hd__decap_3
XFILLER_13_284 VPWR VGND VPWR VGND sky130_fd_sc_hd__decap_3
XFILLER_13_273 VPWR VGND VPWR VGND sky130_fd_sc_hd__decap_3
XFILLER_13_240 VPWR VGND VPWR VGND sky130_fd_sc_hd__decap_3
XFILLER_9_211 VPWR VGND VPWR VGND sky130_fd_sc_hd__decap_3
XFILLER_9_255 VPWR VGND VPWR VGND sky130_fd_sc_hd__decap_3
XFILLER_9_299 VPWR VGND VPWR VGND sky130_fd_sc_hd__decap_3
XPHY_EDGE_ROW_3_Left_27 VPWR VGND VPWR VGND sky130_fd_sc_hd__decap_3
XFILLER_10_221 VPWR VGND VPWR VGND sky130_fd_sc_hd__decap_3
XFILLER_6_203 VPWR VGND VPWR VGND sky130_fd_sc_hd__decap_3
XFILLER_6_236 VPWR VGND VPWR VGND sky130_fd_sc_hd__decap_3
XFILLER_10_265 VPWR VGND VPWR VGND sky130_fd_sc_hd__decap_3
XFILLER_10_298 VPWR VGND VPWR VGND sky130_fd_sc_hd__decap_3
XFILLER_1_24 VPWR VGND VPWR VGND sky130_fd_sc_hd__decap_3
XFILLER_18_321 VPWR VGND VPWR VGND sky130_fd_sc_hd__decap_3
XFILLER_1_57 VPWR VGND VPWR VGND sky130_fd_sc_hd__decap_3
Xinput1 VGND VPWR VPWR VGND inv_y _25_/A input1/a_244_47# input1/a_355_47# input1/a_27_47#
+ sky130_fd_sc_hd__clkdlybuf4s25_1
XFILLER_3_217 VPWR VGND VPWR VGND sky130_fd_sc_hd__decap_3
XFILLER_3_228 VPWR VGND VPWR VGND sky130_fd_sc_hd__decap_3
XFILLER_10_44 VPWR VGND VPWR VGND sky130_fd_sc_hd__decap_3
XFILLER_19_42 VPWR VGND VPWR VGND sky130_fd_sc_hd__decap_3
XFILLER_10_77 VPWR VGND VPWR VGND sky130_fd_sc_hd__decap_3
XFILLER_10_88 VPWR VGND VPWR VGND sky130_fd_sc_hd__decap_3
XFILLER_19_75 VPWR VGND VPWR VGND sky130_fd_sc_hd__decap_3
XFILLER_15_302 VPWR VGND VPWR VGND sky130_fd_sc_hd__decap_3
XFILLER_2_283 VPWR VGND VPWR VGND sky130_fd_sc_hd__decap_3
XFILLER_21_305 VPWR VGND VPWR VGND sky130_fd_sc_hd__decap_3
XFILLER_18_162 VPWR VGND VPWR VGND sky130_fd_sc_hd__decap_3
XFILLER_0_209 VPWR VGND VPWR VGND sky130_fd_sc_hd__decap_3
XFILLER_21_21 VPWR VGND VPWR VGND sky130_fd_sc_hd__decap_3
XFILLER_12_327 VPWR VGND VPWR VGND sky130_fd_sc_hd__decap_3
XFILLER_8_309 VPWR VGND VPWR VGND sky130_fd_sc_hd__decap_3
XFILLER_21_87 VPWR VGND VPWR VGND sky130_fd_sc_hd__decap_3
XPHY_EDGE_ROW_6_Left_30 VPWR VGND VPWR VGND sky130_fd_sc_hd__decap_3
XFILLER_15_187 VPWR VGND VPWR VGND sky130_fd_sc_hd__decap_3
XFILLER_15_143 VPWR VGND VPWR VGND sky130_fd_sc_hd__decap_3
XFILLER_7_12 VPWR VGND VPWR VGND sky130_fd_sc_hd__decap_3
XFILLER_7_45 VPWR VGND VPWR VGND sky130_fd_sc_hd__decap_3
XFILLER_7_78 VPWR VGND VPWR VGND sky130_fd_sc_hd__decap_3
XFILLER_7_320 VPWR VGND VPWR VGND sky130_fd_sc_hd__decap_3
XFILLER_23_3 VPWR VGND VPWR VGND sky130_fd_sc_hd__decap_3
XFILLER_21_146 VPWR VGND VPWR VGND sky130_fd_sc_hd__decap_3
XFILLER_21_113 VPWR VGND VPWR VGND sky130_fd_sc_hd__decap_3
XFILLER_21_102 VPWR VGND VPWR VGND sky130_fd_sc_hd__decap_3
XFILLER_16_65 VPWR VGND VPWR VGND sky130_fd_sc_hd__decap_3
XFILLER_16_32 VPWR VGND VPWR VGND sky130_fd_sc_hd__decap_3
XFILLER_16_21 VPWR VGND VPWR VGND sky130_fd_sc_hd__decap_3
XFILLER_12_124 VPWR VGND VPWR VGND sky130_fd_sc_hd__decap_3
XFILLER_4_301 VPWR VGND VPWR VGND sky130_fd_sc_hd__decap_3
XFILLER_4_312 VPWR VGND VPWR VGND sky130_fd_sc_hd__decap_3
XFILLER_8_106 VPWR VGND VPWR VGND sky130_fd_sc_hd__decap_3
XFILLER_12_168 VPWR VGND VPWR VGND sky130_fd_sc_hd__decap_3
XFILLER_7_161 VPWR VGND VPWR VGND sky130_fd_sc_hd__decap_3
XFILLER_7_172 VPWR VGND VPWR VGND sky130_fd_sc_hd__decap_3
XPHY_EDGE_ROW_9_Right_9 VPWR VGND VPWR VGND sky130_fd_sc_hd__decap_3
XFILLER_11_190 VPWR VGND VPWR VGND sky130_fd_sc_hd__decap_3
XFILLER_19_290 VPWR VGND VPWR VGND sky130_fd_sc_hd__decap_3
XFILLER_1_326 VPWR VGND VPWR VGND sky130_fd_sc_hd__decap_3
XFILLER_17_249 VPWR VGND VPWR VGND sky130_fd_sc_hd__decap_3
XFILLER_17_205 VPWR VGND VPWR VGND sky130_fd_sc_hd__decap_3
XFILLER_4_24 VPWR VGND VPWR VGND sky130_fd_sc_hd__decap_3
XFILLER_4_153 VPWR VGND VPWR VGND sky130_fd_sc_hd__decap_3
XFILLER_4_35 VPWR VGND VPWR VGND sky130_fd_sc_hd__decap_3
XFILLER_4_68 VPWR VGND VPWR VGND sky130_fd_sc_hd__decap_3
XFILLER_4_186 VPWR VGND VPWR VGND sky130_fd_sc_hd__decap_3
XFILLER_4_197 VPWR VGND VPWR VGND sky130_fd_sc_hd__decap_3
XFILLER_16_271 VPWR VGND VPWR VGND sky130_fd_sc_hd__decap_3
XFILLER_22_274 VPWR VGND VPWR VGND sky130_fd_sc_hd__decap_3
XFILLER_22_230 VPWR VGND VPWR VGND sky130_fd_sc_hd__decap_3
XFILLER_13_33 VPWR VGND VPWR VGND sky130_fd_sc_hd__decap_3
XFILLER_13_99 VPWR VGND VPWR VGND sky130_fd_sc_hd__decap_3
XFILLER_13_66 VPWR VGND VPWR VGND sky130_fd_sc_hd__decap_3
XFILLER_1_178 VPWR VGND VPWR VGND sky130_fd_sc_hd__decap_3
XFILLER_1_134 VPWR VGND VPWR VGND sky130_fd_sc_hd__decap_3
XFILLER_13_296 VPWR VGND VPWR VGND sky130_fd_sc_hd__decap_3
XFILLER_13_252 VPWR VGND VPWR VGND sky130_fd_sc_hd__decap_3
XFILLER_9_234 VPWR VGND VPWR VGND sky130_fd_sc_hd__decap_3
XFILLER_9_267 VPWR VGND VPWR VGND sky130_fd_sc_hd__decap_3
XFILLER_6_215 VPWR VGND VPWR VGND sky130_fd_sc_hd__decap_3
XFILLER_10_200 VPWR VGND VPWR VGND sky130_fd_sc_hd__decap_3
XFILLER_10_233 VPWR VGND VPWR VGND sky130_fd_sc_hd__decap_3
XFILLER_10_277 VPWR VGND VPWR VGND sky130_fd_sc_hd__decap_3
XFILLER_6_248 VPWR VGND VPWR VGND sky130_fd_sc_hd__decap_3
XFILLER_6_259 VPWR VGND VPWR VGND sky130_fd_sc_hd__decap_3
XFILLER_1_36 VPWR VGND VPWR VGND sky130_fd_sc_hd__decap_3
XFILLER_1_69 VPWR VGND VPWR VGND sky130_fd_sc_hd__decap_3
XFILLER_5_270 VPWR VGND VPWR VGND sky130_fd_sc_hd__decap_3
XFILLER_5_281 VPWR VGND VPWR VGND sky130_fd_sc_hd__decap_3
Xinput2 VGND VPWR VPWR VGND rst_n input2/X input2/a_244_47# input2/a_355_47# input2/a_27_47#
+ sky130_fd_sc_hd__clkdlybuf4s25_1
XFILLER_10_12 VPWR VGND VPWR VGND sky130_fd_sc_hd__decap_3
XFILLER_10_56 VPWR VGND VPWR VGND sky130_fd_sc_hd__decap_3
XFILLER_19_119 VPWR VGND VPWR VGND sky130_fd_sc_hd__decap_3
XFILLER_19_108 VPWR VGND VPWR VGND sky130_fd_sc_hd__decap_3
XFILLER_19_87 VPWR VGND VPWR VGND sky130_fd_sc_hd__decap_3
XFILLER_19_21 VPWR VGND VPWR VGND sky130_fd_sc_hd__decap_3
XFILLER_15_314 VPWR VGND VPWR VGND sky130_fd_sc_hd__decap_3
XFILLER_2_295 VPWR VGND VPWR VGND sky130_fd_sc_hd__decap_3
XFILLER_2_262 VPWR VGND VPWR VGND sky130_fd_sc_hd__decap_3
XFILLER_18_174 VPWR VGND VPWR VGND sky130_fd_sc_hd__decap_3
XFILLER_18_141 VPWR VGND VPWR VGND sky130_fd_sc_hd__decap_3
XFILLER_18_130 VPWR VGND VPWR VGND sky130_fd_sc_hd__decap_3
XFILLER_18_6 VPWR VGND VPWR VGND sky130_fd_sc_hd__decap_3
XFILLER_21_317 VPWR VGND VPWR VGND sky130_fd_sc_hd__decap_3
XFILLER_21_33 VPWR VGND VPWR VGND sky130_fd_sc_hd__decap_3
XFILLER_21_99 VPWR VGND VPWR VGND sky130_fd_sc_hd__decap_3
XFILLER_21_66 VPWR VGND VPWR VGND sky130_fd_sc_hd__decap_3
XFILLER_15_199 VPWR VGND VPWR VGND sky130_fd_sc_hd__decap_3
XFILLER_15_155 VPWR VGND VPWR VGND sky130_fd_sc_hd__decap_3
XFILLER_15_122 VPWR VGND VPWR VGND sky130_fd_sc_hd__decap_3
XFILLER_7_24 VPWR VGND VPWR VGND sky130_fd_sc_hd__decap_3
XFILLER_7_57 VPWR VGND VPWR VGND sky130_fd_sc_hd__decap_3
XFILLER_7_332 VPWR VGND VPWR VGND sky130_fd_sc_hd__decap_3
XFILLER_16_3 VPWR VGND VPWR VGND sky130_fd_sc_hd__decap_3
XFILLER_21_169 VPWR VGND VPWR VGND sky130_fd_sc_hd__decap_3
XFILLER_21_158 VPWR VGND VPWR VGND sky130_fd_sc_hd__decap_3
XFILLER_21_125 VPWR VGND VPWR VGND sky130_fd_sc_hd__decap_3
XFILLER_16_88 VPWR VGND VPWR VGND sky130_fd_sc_hd__decap_3
XFILLER_16_77 VPWR VGND VPWR VGND sky130_fd_sc_hd__decap_3
XFILLER_16_44 VPWR VGND VPWR VGND sky130_fd_sc_hd__decap_3
XFILLER_8_118 VPWR VGND VPWR VGND sky130_fd_sc_hd__decap_3
XFILLER_12_103 VPWR VGND VPWR VGND sky130_fd_sc_hd__decap_3
XFILLER_12_136 VPWR VGND VPWR VGND sky130_fd_sc_hd__decap_3
XFILLER_12_147 VPWR VGND VPWR VGND sky130_fd_sc_hd__decap_3
XFILLER_4_324 VPWR VGND VPWR VGND sky130_fd_sc_hd__decap_3
XFILLER_7_140 VPWR VGND VPWR VGND sky130_fd_sc_hd__decap_3
XFILLER_7_184 VPWR VGND VPWR VGND sky130_fd_sc_hd__decap_3
XFILLER_1_305 VPWR VGND VPWR VGND sky130_fd_sc_hd__decap_3
XFILLER_17_228 VPWR VGND VPWR VGND sky130_fd_sc_hd__decap_3
XFILLER_17_217 VPWR VGND VPWR VGND sky130_fd_sc_hd__decap_3
XFILLER_4_47 VPWR VGND VPWR VGND sky130_fd_sc_hd__decap_3
XFILLER_4_121 VPWR VGND VPWR VGND sky130_fd_sc_hd__decap_3
XFILLER_4_165 VPWR VGND VPWR VGND sky130_fd_sc_hd__decap_3
XFILLER_16_283 VPWR VGND VPWR VGND sky130_fd_sc_hd__decap_3
XFILLER_14_209 VPWR VGND VPWR VGND sky130_fd_sc_hd__decap_3
XFILLER_22_286 VPWR VGND VPWR VGND sky130_fd_sc_hd__decap_3
XFILLER_22_253 VPWR VGND VPWR VGND sky130_fd_sc_hd__decap_3
XFILLER_22_242 VPWR VGND VPWR VGND sky130_fd_sc_hd__decap_3
XFILLER_13_45 VPWR VGND VPWR VGND sky130_fd_sc_hd__decap_3
XFILLER_13_12 VPWR VGND VPWR VGND sky130_fd_sc_hd__decap_3
XFILLER_13_78 VPWR VGND VPWR VGND sky130_fd_sc_hd__decap_3
XFILLER_1_102 VPWR VGND VPWR VGND sky130_fd_sc_hd__decap_3
XFILLER_1_113 VPWR VGND VPWR VGND sky130_fd_sc_hd__decap_3
XFILLER_1_146 VPWR VGND VPWR VGND sky130_fd_sc_hd__decap_3
XFILLER_13_231 VPWR VGND VPWR VGND sky130_fd_sc_hd__decap_3
XFILLER_13_220 VPWR VGND VPWR VGND sky130_fd_sc_hd__decap_3
XFILLER_13_264 VPWR VGND VPWR VGND sky130_fd_sc_hd__decap_3
XFILLER_9_202 VPWR VGND VPWR VGND sky130_fd_sc_hd__decap_3
XFILLER_9_246 VPWR VGND VPWR VGND sky130_fd_sc_hd__decap_3
XFILLER_0_190 VPWR VGND VPWR VGND sky130_fd_sc_hd__decap_3
XFILLER_5_90 VPWR VGND VPWR VGND sky130_fd_sc_hd__decap_3
XFILLER_6_227 VPWR VGND VPWR VGND sky130_fd_sc_hd__decap_3
XFILLER_10_212 VPWR VGND VPWR VGND sky130_fd_sc_hd__decap_3
XFILLER_10_245 VPWR VGND VPWR VGND sky130_fd_sc_hd__decap_3
XFILLER_10_256 VPWR VGND VPWR VGND sky130_fd_sc_hd__decap_3
XFILLER_10_289 VPWR VGND VPWR VGND sky130_fd_sc_hd__decap_3
XFILLER_18_312 VPWR VGND VPWR VGND sky130_fd_sc_hd__decap_3
XFILLER_18_301 VPWR VGND VPWR VGND sky130_fd_sc_hd__decap_3
XFILLER_1_15 VPWR VGND VPWR VGND sky130_fd_sc_hd__decap_3
XFILLER_1_48 VPWR VGND VPWR VGND sky130_fd_sc_hd__decap_3
XPHY_EDGE_ROW_18_Right_18 VPWR VGND VPWR VGND sky130_fd_sc_hd__decap_3
XFILLER_5_293 VPWR VGND VPWR VGND sky130_fd_sc_hd__decap_3
Xinput3 VGND VPWR VPWR VGND ui_in[0] _00_/D input3/a_244_47# input3/a_355_47# input3/a_27_47#
+ sky130_fd_sc_hd__clkdlybuf4s25_1
XFILLER_3_208 VPWR VGND VPWR VGND sky130_fd_sc_hd__decap_3
XFILLER_10_24 VPWR VGND VPWR VGND sky130_fd_sc_hd__decap_3
XFILLER_10_35 VPWR VGND VPWR VGND sky130_fd_sc_hd__decap_3
XFILLER_10_68 VPWR VGND VPWR VGND sky130_fd_sc_hd__decap_3
XFILLER_19_99 VPWR VGND VPWR VGND sky130_fd_sc_hd__decap_3
XFILLER_19_66 VPWR VGND VPWR VGND sky130_fd_sc_hd__decap_3
XFILLER_19_33 VPWR VGND VPWR VGND sky130_fd_sc_hd__decap_3
XFILLER_15_326 VPWR VGND VPWR VGND sky130_fd_sc_hd__decap_3
X_01_ VGND VPWR VPWR VGND _01_/CLK _25_/A input2/X _24_/A _01_/a_1462_47# _01_/a_543_47#
+ _01_/a_651_413# _01_/a_193_47# _01_/a_805_47# _01_/a_448_47# _01_/a_639_47# _01_/a_1283_21#
+ _01_/a_761_289# _01_/a_1108_47# _01_/a_1217_47# _01_/a_1270_413# _01_/a_27_47# sky130_fd_sc_hd__dfrtp_2
XFILLER_2_274 VPWR VGND VPWR VGND sky130_fd_sc_hd__decap_3
XFILLER_2_230 VPWR VGND VPWR VGND sky130_fd_sc_hd__decap_3
XFILLER_18_197 VPWR VGND VPWR VGND sky130_fd_sc_hd__decap_3
XFILLER_18_186 VPWR VGND VPWR VGND sky130_fd_sc_hd__decap_3
XFILLER_18_153 VPWR VGND VPWR VGND sky130_fd_sc_hd__decap_3
XFILLER_21_329 VPWR VGND VPWR VGND sky130_fd_sc_hd__decap_3
XFILLER_2_91 VPWR VGND VPWR VGND sky130_fd_sc_hd__decap_3
XFILLER_2_80 VPWR VGND VPWR VGND sky130_fd_sc_hd__decap_3
XFILLER_12_318 VPWR VGND VPWR VGND sky130_fd_sc_hd__decap_3
XFILLER_21_78 VPWR VGND VPWR VGND sky130_fd_sc_hd__decap_3
XFILLER_21_45 VPWR VGND VPWR VGND sky130_fd_sc_hd__decap_3
XFILLER_21_12 VPWR VGND VPWR VGND sky130_fd_sc_hd__decap_3
XFILLER_15_134 VPWR VGND VPWR VGND sky130_fd_sc_hd__decap_3
XFILLER_15_178 VPWR VGND VPWR VGND sky130_fd_sc_hd__decap_3
XFILLER_7_36 VPWR VGND VPWR VGND sky130_fd_sc_hd__decap_3
XFILLER_7_311 VPWR VGND VPWR VGND sky130_fd_sc_hd__decap_3
XFILLER_7_69 VPWR VGND VPWR VGND sky130_fd_sc_hd__decap_3
XFILLER_21_137 VPWR VGND VPWR VGND sky130_fd_sc_hd__decap_3
XFILLER_16_12 VPWR VGND VPWR VGND sky130_fd_sc_hd__decap_3
XFILLER_16_56 VPWR VGND VPWR VGND sky130_fd_sc_hd__decap_3
XPHY_EDGE_ROW_0_Right_0 VPWR VGND VPWR VGND sky130_fd_sc_hd__decap_3
XFILLER_12_115 VPWR VGND VPWR VGND sky130_fd_sc_hd__decap_3
XFILLER_12_159 VPWR VGND VPWR VGND sky130_fd_sc_hd__decap_3
XFILLER_7_152 VPWR VGND VPWR VGND sky130_fd_sc_hd__decap_3
XFILLER_11_181 VPWR VGND VPWR VGND sky130_fd_sc_hd__decap_3
XFILLER_7_196 VPWR VGND VPWR VGND sky130_fd_sc_hd__decap_3
XFILLER_19_281 VPWR VGND VPWR VGND sky130_fd_sc_hd__decap_3
XFILLER_19_270 VPWR VGND VPWR VGND sky130_fd_sc_hd__decap_3
XFILLER_1_317 VPWR VGND VPWR VGND sky130_fd_sc_hd__decap_3
XFILLER_4_15 VPWR VGND VPWR VGND sky130_fd_sc_hd__decap_3
XFILLER_4_59 VPWR VGND VPWR VGND sky130_fd_sc_hd__decap_3
XFILLER_4_100 VPWR VGND VPWR VGND sky130_fd_sc_hd__decap_3
XFILLER_4_133 VPWR VGND VPWR VGND sky130_fd_sc_hd__decap_3
XFILLER_4_144 VPWR VGND VPWR VGND sky130_fd_sc_hd__decap_3
XFILLER_4_177 VPWR VGND VPWR VGND sky130_fd_sc_hd__decap_3
XFILLER_16_295 VPWR VGND VPWR VGND sky130_fd_sc_hd__decap_3
XFILLER_16_262 VPWR VGND VPWR VGND sky130_fd_sc_hd__decap_3
XFILLER_22_265 VPWR VGND VPWR VGND sky130_fd_sc_hd__decap_3
XFILLER_22_221 VPWR VGND VPWR VGND sky130_fd_sc_hd__decap_3
XFILLER_13_57 VPWR VGND VPWR VGND sky130_fd_sc_hd__decap_3
XFILLER_13_24 VPWR VGND VPWR VGND sky130_fd_sc_hd__decap_3
XFILLER_1_158 VPWR VGND VPWR VGND sky130_fd_sc_hd__decap_3
XFILLER_1_125 VPWR VGND VPWR VGND sky130_fd_sc_hd__decap_3
XFILLER_8_6 VPWR VGND VPWR VGND sky130_fd_sc_hd__decap_3
XFILLER_1_169 VPWR VGND VPWR VGND sky130_fd_sc_hd__decap_3
XFILLER_13_276 VPWR VGND VPWR VGND sky130_fd_sc_hd__decap_3
XFILLER_13_243 VPWR VGND VPWR VGND sky130_fd_sc_hd__decap_3
XFILLER_9_214 VPWR VGND VPWR VGND sky130_fd_sc_hd__decap_3
XFILLER_9_225 VPWR VGND VPWR VGND sky130_fd_sc_hd__decap_3
XFILLER_13_287 VPWR VGND VPWR VGND sky130_fd_sc_hd__decap_3
XFILLER_9_258 VPWR VGND VPWR VGND sky130_fd_sc_hd__decap_3
XFILLER_8_280 VPWR VGND VPWR VGND sky130_fd_sc_hd__decap_3
XFILLER_6_206 VPWR VGND VPWR VGND sky130_fd_sc_hd__decap_3
XFILLER_6_239 VPWR VGND VPWR VGND sky130_fd_sc_hd__decap_3
XFILLER_10_224 VPWR VGND VPWR VGND sky130_fd_sc_hd__decap_3
XFILLER_10_268 VPWR VGND VPWR VGND sky130_fd_sc_hd__decap_3
XFILLER_6_3 VPWR VGND VPWR VGND sky130_fd_sc_hd__decap_3
XFILLER_18_324 VPWR VGND VPWR VGND sky130_fd_sc_hd__decap_3
XFILLER_1_27 VPWR VGND VPWR VGND sky130_fd_sc_hd__decap_3
XFILLER_5_261 VPWR VGND VPWR VGND sky130_fd_sc_hd__decap_3
XFILLER_19_12 VPWR VGND VPWR VGND sky130_fd_sc_hd__decap_3
XFILLER_10_47 VPWR VGND VPWR VGND sky130_fd_sc_hd__decap_3
XFILLER_19_78 VPWR VGND VPWR VGND sky130_fd_sc_hd__decap_3
XFILLER_19_45 VPWR VGND VPWR VGND sky130_fd_sc_hd__decap_3
XFILLER_15_305 VPWR VGND VPWR VGND sky130_fd_sc_hd__decap_3
X_00_ VGND VPWR VPWR VGND _00_/CLK _00_/D input2/X inv_a _00_/a_1462_47# _00_/a_543_47#
+ _00_/a_651_413# _00_/a_193_47# _00_/a_805_47# _00_/a_448_47# _00_/a_639_47# _00_/a_1283_21#
+ _00_/a_761_289# _00_/a_1108_47# _00_/a_1217_47# _00_/a_1270_413# _00_/a_27_47# sky130_fd_sc_hd__dfrtp_2
XFILLER_2_286 VPWR VGND VPWR VGND sky130_fd_sc_hd__decap_3
XFILLER_2_253 VPWR VGND VPWR VGND sky130_fd_sc_hd__decap_3
XFILLER_2_242 VPWR VGND VPWR VGND sky130_fd_sc_hd__decap_3
XFILLER_21_308 VPWR VGND VPWR VGND sky130_fd_sc_hd__decap_3
XFILLER_18_165 VPWR VGND VPWR VGND sky130_fd_sc_hd__decap_3
XFILLER_18_121 VPWR VGND VPWR VGND sky130_fd_sc_hd__decap_3
XFILLER_20_330 VPWR VGND VPWR VGND sky130_fd_sc_hd__decap_3
XFILLER_21_57 VPWR VGND VPWR VGND sky130_fd_sc_hd__decap_3
XFILLER_21_24 VPWR VGND VPWR VGND sky130_fd_sc_hd__decap_3
XFILLER_15_146 VPWR VGND VPWR VGND sky130_fd_sc_hd__decap_3
XFILLER_15_113 VPWR VGND VPWR VGND sky130_fd_sc_hd__decap_3
XFILLER_15_102 VPWR VGND VPWR VGND sky130_fd_sc_hd__decap_3
XFILLER_23_190 VPWR VGND VPWR VGND sky130_fd_sc_hd__decap_3
XFILLER_7_15 VPWR VGND VPWR VGND sky130_fd_sc_hd__decap_3
XFILLER_7_48 VPWR VGND VPWR VGND sky130_fd_sc_hd__decap_3
XFILLER_7_323 VPWR VGND VPWR VGND sky130_fd_sc_hd__decap_3
XFILLER_11_90 VPWR VGND VPWR VGND sky130_fd_sc_hd__decap_3
XFILLER_23_6 VPWR VGND VPWR VGND sky130_fd_sc_hd__decap_3
XFILLER_21_149 VPWR VGND VPWR VGND sky130_fd_sc_hd__decap_3
XFILLER_21_116 VPWR VGND VPWR VGND sky130_fd_sc_hd__decap_3
XFILLER_21_105 VPWR VGND VPWR VGND sky130_fd_sc_hd__decap_3
XFILLER_16_68 VPWR VGND VPWR VGND sky130_fd_sc_hd__decap_3
XFILLER_16_35 VPWR VGND VPWR VGND sky130_fd_sc_hd__decap_3
XFILLER_16_24 VPWR VGND VPWR VGND sky130_fd_sc_hd__decap_3
XFILLER_20_171 VPWR VGND VPWR VGND sky130_fd_sc_hd__decap_3
XFILLER_8_109 VPWR VGND VPWR VGND sky130_fd_sc_hd__decap_3
XFILLER_12_127 VPWR VGND VPWR VGND sky130_fd_sc_hd__decap_3
XFILLER_4_304 VPWR VGND VPWR VGND sky130_fd_sc_hd__decap_3
XFILLER_4_315 VPWR VGND VPWR VGND sky130_fd_sc_hd__decap_3
XFILLER_7_131 VPWR VGND VPWR VGND sky130_fd_sc_hd__decap_3
XFILLER_7_164 VPWR VGND VPWR VGND sky130_fd_sc_hd__decap_3
XFILLER_7_175 VPWR VGND VPWR VGND sky130_fd_sc_hd__decap_3
XFILLER_11_193 VPWR VGND VPWR VGND sky130_fd_sc_hd__decap_3
XFILLER_21_3 VPWR VGND VPWR VGND sky130_fd_sc_hd__decap_3
XFILLER_19_293 VPWR VGND VPWR VGND sky130_fd_sc_hd__decap_3
XFILLER_1_329 VPWR VGND VPWR VGND sky130_fd_sc_hd__decap_3
XFILLER_8_80 VPWR VGND VPWR VGND sky130_fd_sc_hd__decap_3
XFILLER_8_91 VPWR VGND VPWR VGND sky130_fd_sc_hd__decap_3
XFILLER_17_208 VPWR VGND VPWR VGND sky130_fd_sc_hd__decap_3
XFILLER_4_112 VPWR VGND VPWR VGND sky130_fd_sc_hd__decap_3
XFILLER_4_38 VPWR VGND VPWR VGND sky130_fd_sc_hd__decap_3
XFILLER_4_156 VPWR VGND VPWR VGND sky130_fd_sc_hd__decap_3
XFILLER_4_189 VPWR VGND VPWR VGND sky130_fd_sc_hd__decap_3
XFILLER_16_230 VPWR VGND VPWR VGND sky130_fd_sc_hd__decap_3
XFILLER_16_274 VPWR VGND VPWR VGND sky130_fd_sc_hd__decap_3
XFILLER_22_233 VPWR VGND VPWR VGND sky130_fd_sc_hd__decap_3
XFILLER_22_277 VPWR VGND VPWR VGND sky130_fd_sc_hd__decap_3
XFILLER_13_69 VPWR VGND VPWR VGND sky130_fd_sc_hd__decap_3
XFILLER_13_36 VPWR VGND VPWR VGND sky130_fd_sc_hd__decap_3
XFILLER_1_137 VPWR VGND VPWR VGND sky130_fd_sc_hd__decap_3
XFILLER_13_299 VPWR VGND VPWR VGND sky130_fd_sc_hd__decap_3
XFILLER_13_255 VPWR VGND VPWR VGND sky130_fd_sc_hd__decap_3
XFILLER_13_211 VPWR VGND VPWR VGND sky130_fd_sc_hd__decap_3
XFILLER_9_237 VPWR VGND VPWR VGND sky130_fd_sc_hd__decap_3
XFILLER_0_181 VPWR VGND VPWR VGND sky130_fd_sc_hd__decap_3
XFILLER_5_81 VPWR VGND VPWR VGND sky130_fd_sc_hd__decap_3
XFILLER_8_292 VPWR VGND VPWR VGND sky130_fd_sc_hd__decap_3
XFILLER_10_203 VPWR VGND VPWR VGND sky130_fd_sc_hd__decap_3
XFILLER_6_218 VPWR VGND VPWR VGND sky130_fd_sc_hd__decap_3
XFILLER_10_236 VPWR VGND VPWR VGND sky130_fd_sc_hd__decap_3
XPHY_EDGE_ROW_23_Left_47 VPWR VGND VPWR VGND sky130_fd_sc_hd__decap_3
XFILLER_1_39 VPWR VGND VPWR VGND sky130_fd_sc_hd__decap_3
XFILLER_5_240 VPWR VGND VPWR VGND sky130_fd_sc_hd__decap_3
XFILLER_5_273 VPWR VGND VPWR VGND sky130_fd_sc_hd__decap_3
XFILLER_5_284 VPWR VGND VPWR VGND sky130_fd_sc_hd__decap_3
XFILLER_10_15 VPWR VGND VPWR VGND sky130_fd_sc_hd__decap_3
XFILLER_19_24 VPWR VGND VPWR VGND sky130_fd_sc_hd__decap_3
XFILLER_10_59 VPWR VGND VPWR VGND sky130_fd_sc_hd__decap_3
XFILLER_19_57 VPWR VGND VPWR VGND sky130_fd_sc_hd__decap_3
XFILLER_15_317 VPWR VGND VPWR VGND sky130_fd_sc_hd__decap_3
XFILLER_2_265 VPWR VGND VPWR VGND sky130_fd_sc_hd__decap_3
XFILLER_2_221 VPWR VGND VPWR VGND sky130_fd_sc_hd__decap_3
XFILLER_18_133 VPWR VGND VPWR VGND sky130_fd_sc_hd__decap_3
XFILLER_18_100 VPWR VGND VPWR VGND sky130_fd_sc_hd__decap_3
XFILLER_18_9 VPWR VGND VPWR VGND sky130_fd_sc_hd__decap_3
XFILLER_2_298 VPWR VGND VPWR VGND sky130_fd_sc_hd__decap_3
XFILLER_18_177 VPWR VGND VPWR VGND sky130_fd_sc_hd__decap_3
XFILLER_18_144 VPWR VGND VPWR VGND sky130_fd_sc_hd__decap_3
XFILLER_2_71 VPWR VGND VPWR VGND sky130_fd_sc_hd__decap_3
XFILLER_12_309 VPWR VGND VPWR VGND sky130_fd_sc_hd__decap_3
XFILLER_21_69 VPWR VGND VPWR VGND sky130_fd_sc_hd__decap_3
XFILLER_21_36 VPWR VGND VPWR VGND sky130_fd_sc_hd__decap_3
XFILLER_15_169 VPWR VGND VPWR VGND sky130_fd_sc_hd__decap_3
XFILLER_15_158 VPWR VGND VPWR VGND sky130_fd_sc_hd__decap_3
XFILLER_15_125 VPWR VGND VPWR VGND sky130_fd_sc_hd__decap_3
XFILLER_7_27 VPWR VGND VPWR VGND sky130_fd_sc_hd__decap_3
XFILLER_7_302 VPWR VGND VPWR VGND sky130_fd_sc_hd__decap_3
XFILLER_11_320 VPWR VGND VPWR VGND sky130_fd_sc_hd__decap_3
XFILLER_16_6 VPWR VGND VPWR VGND sky130_fd_sc_hd__decap_3
XFILLER_21_128 VPWR VGND VPWR VGND sky130_fd_sc_hd__decap_3
XFILLER_14_180 VPWR VGND VPWR VGND sky130_fd_sc_hd__decap_3
XPHY_EDGE_ROW_10_Left_34 VPWR VGND VPWR VGND sky130_fd_sc_hd__decap_3
XFILLER_16_47 VPWR VGND VPWR VGND sky130_fd_sc_hd__decap_3
XFILLER_12_106 VPWR VGND VPWR VGND sky130_fd_sc_hd__decap_3
XFILLER_20_150 VPWR VGND VPWR VGND sky130_fd_sc_hd__decap_3
XFILLER_4_327 VPWR VGND VPWR VGND sky130_fd_sc_hd__decap_3
XFILLER_7_143 VPWR VGND VPWR VGND sky130_fd_sc_hd__decap_3
XFILLER_7_187 VPWR VGND VPWR VGND sky130_fd_sc_hd__decap_3
XFILLER_11_161 VPWR VGND VPWR VGND sky130_fd_sc_hd__decap_3
XFILLER_11_172 VPWR VGND VPWR VGND sky130_fd_sc_hd__decap_3
XFILLER_14_3 VPWR VGND VPWR VGND sky130_fd_sc_hd__decap_3
XFILLER_19_261 VPWR VGND VPWR VGND sky130_fd_sc_hd__decap_3
XFILLER_1_308 VPWR VGND VPWR VGND sky130_fd_sc_hd__decap_3
XFILLER_4_124 VPWR VGND VPWR VGND sky130_fd_sc_hd__decap_3
XFILLER_0_330 VPWR VGND VPWR VGND sky130_fd_sc_hd__decap_3
XFILLER_4_168 VPWR VGND VPWR VGND sky130_fd_sc_hd__decap_3
XFILLER_17_90 VPWR VGND VPWR VGND sky130_fd_sc_hd__decap_3
XFILLER_16_253 VPWR VGND VPWR VGND sky130_fd_sc_hd__decap_3
XFILLER_16_242 VPWR VGND VPWR VGND sky130_fd_sc_hd__decap_3
XFILLER_16_286 VPWR VGND VPWR VGND sky130_fd_sc_hd__decap_3
XFILLER_3_190 VPWR VGND VPWR VGND sky130_fd_sc_hd__decap_3
XFILLER_22_256 VPWR VGND VPWR VGND sky130_fd_sc_hd__decap_3
XFILLER_22_245 VPWR VGND VPWR VGND sky130_fd_sc_hd__decap_3
XFILLER_13_15 VPWR VGND VPWR VGND sky130_fd_sc_hd__decap_3
XFILLER_22_289 VPWR VGND VPWR VGND sky130_fd_sc_hd__decap_3
XFILLER_13_48 VPWR VGND VPWR VGND sky130_fd_sc_hd__decap_3
XFILLER_1_149 VPWR VGND VPWR VGND sky130_fd_sc_hd__decap_3
XFILLER_1_105 VPWR VGND VPWR VGND sky130_fd_sc_hd__decap_3
XFILLER_1_116 VPWR VGND VPWR VGND sky130_fd_sc_hd__decap_3
XFILLER_13_267 VPWR VGND VPWR VGND sky130_fd_sc_hd__decap_3
XFILLER_13_234 VPWR VGND VPWR VGND sky130_fd_sc_hd__decap_3
XFILLER_9_205 VPWR VGND VPWR VGND sky130_fd_sc_hd__decap_3
XFILLER_9_249 VPWR VGND VPWR VGND sky130_fd_sc_hd__decap_3
Xmisfit01_core_20 uo_out[6] misfit01_core_20/HI VPWR VGND VGND VPWR sky130_fd_sc_hd__conb_1
XFILLER_0_193 VPWR VGND VPWR VGND sky130_fd_sc_hd__decap_3
XFILLER_8_271 VPWR VGND VPWR VGND sky130_fd_sc_hd__decap_3
XFILLER_5_60 VPWR VGND VPWR VGND sky130_fd_sc_hd__decap_3
XFILLER_5_93 VPWR VGND VPWR VGND sky130_fd_sc_hd__decap_3
XFILLER_10_215 VPWR VGND VPWR VGND sky130_fd_sc_hd__decap_3
XFILLER_10_248 VPWR VGND VPWR VGND sky130_fd_sc_hd__decap_3
XFILLER_10_259 VPWR VGND VPWR VGND sky130_fd_sc_hd__decap_3
XFILLER_18_315 VPWR VGND VPWR VGND sky130_fd_sc_hd__decap_3
XFILLER_18_304 VPWR VGND VPWR VGND sky130_fd_sc_hd__decap_3
XFILLER_1_18 VPWR VGND VPWR VGND sky130_fd_sc_hd__decap_3
XFILLER_14_91 VPWR VGND VPWR VGND sky130_fd_sc_hd__decap_3
XFILLER_14_80 VPWR VGND VPWR VGND sky130_fd_sc_hd__decap_3
XFILLER_5_252 VPWR VGND VPWR VGND sky130_fd_sc_hd__decap_3
XFILLER_5_296 VPWR VGND VPWR VGND sky130_fd_sc_hd__decap_3
XFILLER_10_38 VPWR VGND VPWR VGND sky130_fd_sc_hd__decap_3
XFILLER_19_69 VPWR VGND VPWR VGND sky130_fd_sc_hd__decap_3
XFILLER_19_36 VPWR VGND VPWR VGND sky130_fd_sc_hd__decap_3
XFILLER_15_329 VPWR VGND VPWR VGND sky130_fd_sc_hd__decap_3
XPHY_EDGE_ROW_14_Right_14 VPWR VGND VPWR VGND sky130_fd_sc_hd__decap_3
XPHY_EDGE_ROW_23_Right_23 VPWR VGND VPWR VGND sky130_fd_sc_hd__decap_3
XFILLER_2_277 VPWR VGND VPWR VGND sky130_fd_sc_hd__decap_3
XFILLER_2_233 VPWR VGND VPWR VGND sky130_fd_sc_hd__decap_3
XFILLER_2_200 VPWR VGND VPWR VGND sky130_fd_sc_hd__decap_3
XFILLER_18_156 VPWR VGND VPWR VGND sky130_fd_sc_hd__decap_3
XFILLER_18_112 VPWR VGND VPWR VGND sky130_fd_sc_hd__decap_3
XFILLER_18_189 VPWR VGND VPWR VGND sky130_fd_sc_hd__decap_3
XFILLER_2_50 VPWR VGND VPWR VGND sky130_fd_sc_hd__decap_3
XFILLER_2_94 VPWR VGND VPWR VGND sky130_fd_sc_hd__decap_3
XFILLER_21_15 VPWR VGND VPWR VGND sky130_fd_sc_hd__decap_3
XFILLER_20_321 VPWR VGND VPWR VGND sky130_fd_sc_hd__decap_3
XFILLER_21_48 VPWR VGND VPWR VGND sky130_fd_sc_hd__decap_3
XFILLER_15_137 VPWR VGND VPWR VGND sky130_fd_sc_hd__decap_3
XFILLER_11_332 VPWR VGND VPWR VGND sky130_fd_sc_hd__decap_3
XFILLER_7_39 VPWR VGND VPWR VGND sky130_fd_sc_hd__decap_3
XFILLER_7_314 VPWR VGND VPWR VGND sky130_fd_sc_hd__decap_3
XFILLER_11_81 VPWR VGND VPWR VGND sky130_fd_sc_hd__decap_3
XFILLER_14_192 VPWR VGND VPWR VGND sky130_fd_sc_hd__decap_3
XFILLER_16_59 VPWR VGND VPWR VGND sky130_fd_sc_hd__decap_3
XFILLER_16_15 VPWR VGND VPWR VGND sky130_fd_sc_hd__decap_3
XFILLER_12_118 VPWR VGND VPWR VGND sky130_fd_sc_hd__decap_3
XFILLER_20_162 VPWR VGND VPWR VGND sky130_fd_sc_hd__decap_3
XFILLER_7_122 VPWR VGND VPWR VGND sky130_fd_sc_hd__decap_3
XFILLER_11_140 VPWR VGND VPWR VGND sky130_fd_sc_hd__decap_3
XFILLER_22_91 VPWR VGND VPWR VGND sky130_fd_sc_hd__decap_3
XFILLER_22_80 VPWR VGND VPWR VGND sky130_fd_sc_hd__decap_3
XFILLER_7_155 VPWR VGND VPWR VGND sky130_fd_sc_hd__decap_3
XFILLER_7_199 VPWR VGND VPWR VGND sky130_fd_sc_hd__decap_3
XFILLER_11_184 VPWR VGND VPWR VGND sky130_fd_sc_hd__decap_3
XFILLER_19_240 VPWR VGND VPWR VGND sky130_fd_sc_hd__decap_3
XFILLER_19_284 VPWR VGND VPWR VGND sky130_fd_sc_hd__decap_3
XFILLER_19_273 VPWR VGND VPWR VGND sky130_fd_sc_hd__decap_3
XFILLER_8_71 VPWR VGND VPWR VGND sky130_fd_sc_hd__decap_3
XPHY_EDGE_ROW_4_Right_4 VPWR VGND VPWR VGND sky130_fd_sc_hd__decap_3
XFILLER_4_18 VPWR VGND VPWR VGND sky130_fd_sc_hd__decap_3
XFILLER_4_29 VPWR VGND VPWR VGND sky130_fd_sc_hd__decap_3
XFILLER_4_103 VPWR VGND VPWR VGND sky130_fd_sc_hd__decap_3
XFILLER_4_136 VPWR VGND VPWR VGND sky130_fd_sc_hd__decap_3
XFILLER_4_147 VPWR VGND VPWR VGND sky130_fd_sc_hd__decap_3
XFILLER_16_298 VPWR VGND VPWR VGND sky130_fd_sc_hd__decap_3
XFILLER_16_265 VPWR VGND VPWR VGND sky130_fd_sc_hd__decap_3
XFILLER_16_221 VPWR VGND VPWR VGND sky130_fd_sc_hd__decap_3
XFILLER_22_268 VPWR VGND VPWR VGND sky130_fd_sc_hd__decap_3
XFILLER_22_224 VPWR VGND VPWR VGND sky130_fd_sc_hd__decap_3
XFILLER_13_27 VPWR VGND VPWR VGND sky130_fd_sc_hd__decap_3
XFILLER_1_128 VPWR VGND VPWR VGND sky130_fd_sc_hd__decap_3
XFILLER_8_9 VPWR VGND VPWR VGND sky130_fd_sc_hd__decap_3
XFILLER_13_202 VPWR VGND VPWR VGND sky130_fd_sc_hd__decap_3
Xmisfit01_core_21 uo_out[7] misfit01_core_21/HI VPWR VGND VGND VPWR sky130_fd_sc_hd__conb_1
Xmisfit01_core_10 uio_out[2] misfit01_core_10/HI VPWR VGND VGND VPWR sky130_fd_sc_hd__conb_1
XFILLER_21_290 VPWR VGND VPWR VGND sky130_fd_sc_hd__decap_3
XFILLER_13_246 VPWR VGND VPWR VGND sky130_fd_sc_hd__decap_3
XFILLER_9_217 VPWR VGND VPWR VGND sky130_fd_sc_hd__decap_3
XFILLER_9_228 VPWR VGND VPWR VGND sky130_fd_sc_hd__decap_3
XFILLER_0_172 VPWR VGND VPWR VGND sky130_fd_sc_hd__decap_3
XFILLER_0_150 VPWR VGND VPWR VGND sky130_fd_sc_hd__decap_3
XFILLER_8_283 VPWR VGND VPWR VGND sky130_fd_sc_hd__decap_3
XFILLER_5_72 VPWR VGND VPWR VGND sky130_fd_sc_hd__decap_3
XFILLER_6_209 VPWR VGND VPWR VGND sky130_fd_sc_hd__decap_3
XFILLER_10_227 VPWR VGND VPWR VGND sky130_fd_sc_hd__decap_3
XFILLER_6_6 VPWR VGND VPWR VGND sky130_fd_sc_hd__decap_3
XFILLER_18_327 VPWR VGND VPWR VGND sky130_fd_sc_hd__decap_3
XFILLER_5_220 VPWR VGND VPWR VGND sky130_fd_sc_hd__decap_3
XFILLER_5_231 VPWR VGND VPWR VGND sky130_fd_sc_hd__decap_3
XFILLER_5_264 VPWR VGND VPWR VGND sky130_fd_sc_hd__decap_3
XFILLER_19_48 VPWR VGND VPWR VGND sky130_fd_sc_hd__decap_3
XFILLER_19_15 VPWR VGND VPWR VGND sky130_fd_sc_hd__decap_3
XFILLER_23_330 VPWR VGND VPWR VGND sky130_fd_sc_hd__decap_3
XFILLER_15_308 VPWR VGND VPWR VGND sky130_fd_sc_hd__decap_3
XFILLER_2_289 VPWR VGND VPWR VGND sky130_fd_sc_hd__decap_3
XFILLER_2_256 VPWR VGND VPWR VGND sky130_fd_sc_hd__decap_3
XFILLER_2_245 VPWR VGND VPWR VGND sky130_fd_sc_hd__decap_3
XFILLER_2_212 VPWR VGND VPWR VGND sky130_fd_sc_hd__decap_3
XFILLER_4_3 VPWR VGND VPWR VGND sky130_fd_sc_hd__decap_3
XFILLER_18_168 VPWR VGND VPWR VGND sky130_fd_sc_hd__decap_3
XFILLER_18_124 VPWR VGND VPWR VGND sky130_fd_sc_hd__decap_3
XFILLER_14_330 VPWR VGND VPWR VGND sky130_fd_sc_hd__decap_3
XFILLER_2_62 VPWR VGND VPWR VGND sky130_fd_sc_hd__decap_3
XFILLER_17_190 VPWR VGND VPWR VGND sky130_fd_sc_hd__decap_3
XFILLER_21_27 VPWR VGND VPWR VGND sky130_fd_sc_hd__decap_3
XFILLER_15_116 VPWR VGND VPWR VGND sky130_fd_sc_hd__decap_3
XFILLER_15_105 VPWR VGND VPWR VGND sky130_fd_sc_hd__decap_3
XFILLER_23_193 VPWR VGND VPWR VGND sky130_fd_sc_hd__decap_3
XFILLER_23_160 VPWR VGND VPWR VGND sky130_fd_sc_hd__decap_3
XFILLER_15_149 VPWR VGND VPWR VGND sky130_fd_sc_hd__decap_3
XFILLER_7_18 VPWR VGND VPWR VGND sky130_fd_sc_hd__decap_3
XFILLER_11_311 VPWR VGND VPWR VGND sky130_fd_sc_hd__decap_3
XFILLER_7_326 VPWR VGND VPWR VGND sky130_fd_sc_hd__decap_3
XFILLER_11_60 VPWR VGND VPWR VGND sky130_fd_sc_hd__decap_3
XFILLER_11_93 VPWR VGND VPWR VGND sky130_fd_sc_hd__decap_3
XFILLER_23_9 VPWR VGND VPWR VGND sky130_fd_sc_hd__decap_3
XFILLER_21_108 VPWR VGND VPWR VGND sky130_fd_sc_hd__decap_3
XFILLER_21_119 VPWR VGND VPWR VGND sky130_fd_sc_hd__decap_3
XFILLER_14_171 VPWR VGND VPWR VGND sky130_fd_sc_hd__decap_3
XFILLER_20_141 VPWR VGND VPWR VGND sky130_fd_sc_hd__decap_3
XFILLER_20_130 VPWR VGND VPWR VGND sky130_fd_sc_hd__decap_3
XFILLER_16_38 VPWR VGND VPWR VGND sky130_fd_sc_hd__decap_3
XFILLER_4_318 VPWR VGND VPWR VGND sky130_fd_sc_hd__decap_3
XFILLER_7_134 VPWR VGND VPWR VGND sky130_fd_sc_hd__decap_3
XFILLER_11_152 VPWR VGND VPWR VGND sky130_fd_sc_hd__decap_3
XFILLER_11_196 VPWR VGND VPWR VGND sky130_fd_sc_hd__decap_3
XFILLER_7_178 VPWR VGND VPWR VGND sky130_fd_sc_hd__decap_3
XFILLER_21_6 VPWR VGND VPWR VGND sky130_fd_sc_hd__decap_3
XFILLER_19_252 VPWR VGND VPWR VGND sky130_fd_sc_hd__decap_3
XFILLER_19_296 VPWR VGND VPWR VGND sky130_fd_sc_hd__decap_3
XFILLER_8_50 VPWR VGND VPWR VGND sky130_fd_sc_hd__decap_3
XFILLER_8_94 VPWR VGND VPWR VGND sky130_fd_sc_hd__decap_3
XFILLER_0_321 VPWR VGND VPWR VGND sky130_fd_sc_hd__decap_3
XFILLER_4_115 VPWR VGND VPWR VGND sky130_fd_sc_hd__decap_3
XFILLER_4_159 VPWR VGND VPWR VGND sky130_fd_sc_hd__decap_3
XFILLER_17_81 VPWR VGND VPWR VGND sky130_fd_sc_hd__decap_3
XFILLER_16_277 VPWR VGND VPWR VGND sky130_fd_sc_hd__decap_3
XFILLER_16_233 VPWR VGND VPWR VGND sky130_fd_sc_hd__decap_3
XFILLER_16_200 VPWR VGND VPWR VGND sky130_fd_sc_hd__decap_3
XFILLER_3_181 VPWR VGND VPWR VGND sky130_fd_sc_hd__decap_3
XFILLER_22_236 VPWR VGND VPWR VGND sky130_fd_sc_hd__decap_3
XFILLER_13_39 VPWR VGND VPWR VGND sky130_fd_sc_hd__decap_3
XFILLER_13_258 VPWR VGND VPWR VGND sky130_fd_sc_hd__decap_3
XFILLER_13_225 VPWR VGND VPWR VGND sky130_fd_sc_hd__decap_3
XFILLER_13_214 VPWR VGND VPWR VGND sky130_fd_sc_hd__decap_3
Xmisfit01_core_11 uio_out[3] misfit01_core_11/HI VPWR VGND VGND VPWR sky130_fd_sc_hd__conb_1
Xmisfit01_core_22 uio_oe[0] misfit01_core_22/HI VPWR VGND VGND VPWR sky130_fd_sc_hd__conb_1
XFILLER_0_162 VPWR VGND VPWR VGND sky130_fd_sc_hd__decap_3
XFILLER_0_184 VPWR VGND VPWR VGND sky130_fd_sc_hd__decap_3
XFILLER_12_280 VPWR VGND VPWR VGND sky130_fd_sc_hd__decap_3
XFILLER_5_51 VPWR VGND VPWR VGND sky130_fd_sc_hd__decap_3
XFILLER_8_262 VPWR VGND VPWR VGND sky130_fd_sc_hd__decap_3
XFILLER_8_295 VPWR VGND VPWR VGND sky130_fd_sc_hd__decap_3
XFILLER_5_84 VPWR VGND VPWR VGND sky130_fd_sc_hd__decap_3
XFILLER_10_206 VPWR VGND VPWR VGND sky130_fd_sc_hd__decap_3
XFILLER_10_239 VPWR VGND VPWR VGND sky130_fd_sc_hd__decap_3
XFILLER_14_71 VPWR VGND VPWR VGND sky130_fd_sc_hd__decap_3
XFILLER_5_243 VPWR VGND VPWR VGND sky130_fd_sc_hd__decap_3
XFILLER_5_276 VPWR VGND VPWR VGND sky130_fd_sc_hd__decap_3
XFILLER_5_287 VPWR VGND VPWR VGND sky130_fd_sc_hd__decap_3
XFILLER_10_18 VPWR VGND VPWR VGND sky130_fd_sc_hd__decap_3
XFILLER_10_29 VPWR VGND VPWR VGND sky130_fd_sc_hd__decap_3
XFILLER_19_27 VPWR VGND VPWR VGND sky130_fd_sc_hd__decap_3
XFILLER_2_268 VPWR VGND VPWR VGND sky130_fd_sc_hd__decap_3
XFILLER_2_224 VPWR VGND VPWR VGND sky130_fd_sc_hd__decap_3
XFILLER_18_147 VPWR VGND VPWR VGND sky130_fd_sc_hd__decap_3
XFILLER_18_136 VPWR VGND VPWR VGND sky130_fd_sc_hd__decap_3
XFILLER_18_103 VPWR VGND VPWR VGND sky130_fd_sc_hd__decap_3
XFILLER_2_85 VPWR VGND VPWR VGND sky130_fd_sc_hd__decap_3
XFILLER_2_74 VPWR VGND VPWR VGND sky130_fd_sc_hd__decap_3
XFILLER_2_41 VPWR VGND VPWR VGND sky130_fd_sc_hd__decap_3
XFILLER_1_290 VPWR VGND VPWR VGND sky130_fd_sc_hd__decap_3
XFILLER_20_312 VPWR VGND VPWR VGND sky130_fd_sc_hd__decap_3
XFILLER_20_301 VPWR VGND VPWR VGND sky130_fd_sc_hd__decap_3
XFILLER_21_39 VPWR VGND VPWR VGND sky130_fd_sc_hd__decap_3
XFILLER_15_128 VPWR VGND VPWR VGND sky130_fd_sc_hd__decap_3
XFILLER_23_172 VPWR VGND VPWR VGND sky130_fd_sc_hd__decap_3
XFILLER_7_305 VPWR VGND VPWR VGND sky130_fd_sc_hd__decap_3
XFILLER_11_323 VPWR VGND VPWR VGND sky130_fd_sc_hd__decap_3
XFILLER_11_72 VPWR VGND VPWR VGND sky130_fd_sc_hd__decap_3
XFILLER_16_9 VPWR VGND VPWR VGND sky130_fd_sc_hd__decap_3
XFILLER_14_150 VPWR VGND VPWR VGND sky130_fd_sc_hd__decap_3
XFILLER_14_183 VPWR VGND VPWR VGND sky130_fd_sc_hd__decap_3
Xclkbuf_1_0__f_clk VGND VPWR VGND VPWR clkbuf_0_clk/X _01_/CLK clkbuf_1_0__f_clk/a_110_47#
+ sky130_fd_sc_hd__clkbuf_16
XFILLER_20_153 VPWR VGND VPWR VGND sky130_fd_sc_hd__decap_3
XFILLER_12_109 VPWR VGND VPWR VGND sky130_fd_sc_hd__decap_3
XFILLER_20_197 VPWR VGND VPWR VGND sky130_fd_sc_hd__decap_3
XFILLER_22_71 VPWR VGND VPWR VGND sky130_fd_sc_hd__decap_3
XFILLER_7_102 VPWR VGND VPWR VGND sky130_fd_sc_hd__decap_3
XFILLER_7_113 VPWR VGND VPWR VGND sky130_fd_sc_hd__decap_3
XFILLER_7_146 VPWR VGND VPWR VGND sky130_fd_sc_hd__decap_3
XFILLER_11_131 VPWR VGND VPWR VGND sky130_fd_sc_hd__decap_3
XFILLER_11_164 VPWR VGND VPWR VGND sky130_fd_sc_hd__decap_3
XFILLER_11_175 VPWR VGND VPWR VGND sky130_fd_sc_hd__decap_3
XFILLER_19_264 VPWR VGND VPWR VGND sky130_fd_sc_hd__decap_3
XFILLER_19_231 VPWR VGND VPWR VGND sky130_fd_sc_hd__decap_3
XFILLER_19_220 VPWR VGND VPWR VGND sky130_fd_sc_hd__decap_3
XFILLER_14_6 VPWR VGND VPWR VGND sky130_fd_sc_hd__decap_3
XPHY_EDGE_ROW_14_Left_38 VPWR VGND VPWR VGND sky130_fd_sc_hd__decap_3
XFILLER_8_62 VPWR VGND VPWR VGND sky130_fd_sc_hd__decap_3
XFILLER_4_127 VPWR VGND VPWR VGND sky130_fd_sc_hd__decap_3
XFILLER_16_212 VPWR VGND VPWR VGND sky130_fd_sc_hd__decap_3
XFILLER_17_93 VPWR VGND VPWR VGND sky130_fd_sc_hd__decap_3
XFILLER_17_60 VPWR VGND VPWR VGND sky130_fd_sc_hd__decap_3
XFILLER_16_289 VPWR VGND VPWR VGND sky130_fd_sc_hd__decap_3
XFILLER_16_256 VPWR VGND VPWR VGND sky130_fd_sc_hd__decap_3
XFILLER_16_245 VPWR VGND VPWR VGND sky130_fd_sc_hd__decap_3
XFILLER_3_193 VPWR VGND VPWR VGND sky130_fd_sc_hd__decap_3
XFILLER_12_3 VPWR VGND VPWR VGND sky130_fd_sc_hd__decap_3
XFILLER_22_259 VPWR VGND VPWR VGND sky130_fd_sc_hd__decap_3
XFILLER_22_248 VPWR VGND VPWR VGND sky130_fd_sc_hd__decap_3
XFILLER_13_18 VPWR VGND VPWR VGND sky130_fd_sc_hd__decap_3
XFILLER_1_108 VPWR VGND VPWR VGND sky130_fd_sc_hd__decap_3
XFILLER_1_119 VPWR VGND VPWR VGND sky130_fd_sc_hd__decap_3
XFILLER_13_237 VPWR VGND VPWR VGND sky130_fd_sc_hd__decap_3
XFILLER_9_208 VPWR VGND VPWR VGND sky130_fd_sc_hd__decap_3
Xmisfit01_core_12 uio_out[4] misfit01_core_12/HI VPWR VGND VGND VPWR sky130_fd_sc_hd__conb_1
Xmisfit01_core_23 uio_oe[1] misfit01_core_23/HI VPWR VGND VGND VPWR sky130_fd_sc_hd__conb_1
XFILLER_21_281 VPWR VGND VPWR VGND sky130_fd_sc_hd__decap_3
XFILLER_21_270 VPWR VGND VPWR VGND sky130_fd_sc_hd__decap_3
XFILLER_0_141 VPWR VGND VPWR VGND sky130_fd_sc_hd__decap_3
XFILLER_12_292 VPWR VGND VPWR VGND sky130_fd_sc_hd__decap_3
XFILLER_8_230 VPWR VGND VPWR VGND sky130_fd_sc_hd__decap_3
XFILLER_5_30 VPWR VGND VPWR VGND sky130_fd_sc_hd__decap_3
XFILLER_5_63 VPWR VGND VPWR VGND sky130_fd_sc_hd__decap_3
XFILLER_5_96 VPWR VGND VPWR VGND sky130_fd_sc_hd__decap_3
XFILLER_8_274 VPWR VGND VPWR VGND sky130_fd_sc_hd__decap_3
XPHY_EDGE_ROW_17_Left_41 VPWR VGND VPWR VGND sky130_fd_sc_hd__decap_3
XFILLER_10_218 VPWR VGND VPWR VGND sky130_fd_sc_hd__decap_3
XFILLER_18_318 VPWR VGND VPWR VGND sky130_fd_sc_hd__decap_3
XFILLER_14_94 VPWR VGND VPWR VGND sky130_fd_sc_hd__decap_3
XFILLER_14_50 VPWR VGND VPWR VGND sky130_fd_sc_hd__decap_3
XFILLER_5_211 VPWR VGND VPWR VGND sky130_fd_sc_hd__decap_3
XFILLER_5_255 VPWR VGND VPWR VGND sky130_fd_sc_hd__decap_3
XFILLER_5_299 VPWR VGND VPWR VGND sky130_fd_sc_hd__decap_3
XFILLER_19_39 VPWR VGND VPWR VGND sky130_fd_sc_hd__decap_3
XFILLER_23_321 VPWR VGND VPWR VGND sky130_fd_sc_hd__decap_3
XPHY_EDGE_ROW_2_Left_26 VPWR VGND VPWR VGND sky130_fd_sc_hd__decap_3
XFILLER_2_236 VPWR VGND VPWR VGND sky130_fd_sc_hd__decap_3
XFILLER_2_203 VPWR VGND VPWR VGND sky130_fd_sc_hd__decap_3
XFILLER_18_115 VPWR VGND VPWR VGND sky130_fd_sc_hd__decap_3
XFILLER_18_159 VPWR VGND VPWR VGND sky130_fd_sc_hd__decap_3
XFILLER_14_321 VPWR VGND VPWR VGND sky130_fd_sc_hd__decap_3
XFILLER_2_97 VPWR VGND VPWR VGND sky130_fd_sc_hd__decap_3
XFILLER_2_53 VPWR VGND VPWR VGND sky130_fd_sc_hd__decap_3
XPHY_EDGE_ROW_10_Right_10 VPWR VGND VPWR VGND sky130_fd_sc_hd__decap_3
XFILLER_20_324 VPWR VGND VPWR VGND sky130_fd_sc_hd__decap_3
XFILLER_17_181 VPWR VGND VPWR VGND sky130_fd_sc_hd__decap_3
XFILLER_21_18 VPWR VGND VPWR VGND sky130_fd_sc_hd__decap_3
XFILLER_23_184 VPWR VGND VPWR VGND sky130_fd_sc_hd__decap_3
XFILLER_7_317 VPWR VGND VPWR VGND sky130_fd_sc_hd__decap_3
XFILLER_11_302 VPWR VGND VPWR VGND sky130_fd_sc_hd__decap_3
XFILLER_11_51 VPWR VGND VPWR VGND sky130_fd_sc_hd__decap_3
XFILLER_11_84 VPWR VGND VPWR VGND sky130_fd_sc_hd__decap_3
XFILLER_14_162 VPWR VGND VPWR VGND sky130_fd_sc_hd__decap_3
XFILLER_16_29 VPWR VGND VPWR VGND sky130_fd_sc_hd__decap_3
XFILLER_16_18 VPWR VGND VPWR VGND sky130_fd_sc_hd__decap_3
XFILLER_20_165 VPWR VGND VPWR VGND sky130_fd_sc_hd__decap_3
XFILLER_20_121 VPWR VGND VPWR VGND sky130_fd_sc_hd__decap_3
XFILLER_4_309 VPWR VGND VPWR VGND sky130_fd_sc_hd__decap_3
XFILLER_22_94 VPWR VGND VPWR VGND sky130_fd_sc_hd__decap_3
XFILLER_22_50 VPWR VGND VPWR VGND sky130_fd_sc_hd__decap_3
XFILLER_3_320 VPWR VGND VPWR VGND sky130_fd_sc_hd__decap_3
XFILLER_7_125 VPWR VGND VPWR VGND sky130_fd_sc_hd__decap_3
XFILLER_7_158 VPWR VGND VPWR VGND sky130_fd_sc_hd__decap_3
XFILLER_7_169 VPWR VGND VPWR VGND sky130_fd_sc_hd__decap_3
XFILLER_11_143 VPWR VGND VPWR VGND sky130_fd_sc_hd__decap_3
XFILLER_11_187 VPWR VGND VPWR VGND sky130_fd_sc_hd__decap_3
XFILLER_19_287 VPWR VGND VPWR VGND sky130_fd_sc_hd__decap_3
XFILLER_19_276 VPWR VGND VPWR VGND sky130_fd_sc_hd__decap_3
XFILLER_19_243 VPWR VGND VPWR VGND sky130_fd_sc_hd__decap_3
XFILLER_8_41 VPWR VGND VPWR VGND sky130_fd_sc_hd__decap_3
XFILLER_8_74 VPWR VGND VPWR VGND sky130_fd_sc_hd__decap_3
XFILLER_8_85 VPWR VGND VPWR VGND sky130_fd_sc_hd__decap_3
XFILLER_6_180 VPWR VGND VPWR VGND sky130_fd_sc_hd__decap_3
XFILLER_4_106 VPWR VGND VPWR VGND sky130_fd_sc_hd__decap_3
XFILLER_0_312 VPWR VGND VPWR VGND sky130_fd_sc_hd__decap_3
XFILLER_17_72 VPWR VGND VPWR VGND sky130_fd_sc_hd__decap_3
XFILLER_16_224 VPWR VGND VPWR VGND sky130_fd_sc_hd__decap_3
XFILLER_16_268 VPWR VGND VPWR VGND sky130_fd_sc_hd__decap_3
XFILLER_3_161 VPWR VGND VPWR VGND sky130_fd_sc_hd__decap_3
XFILLER_3_172 VPWR VGND VPWR VGND sky130_fd_sc_hd__decap_3
XFILLER_22_227 VPWR VGND VPWR VGND sky130_fd_sc_hd__decap_3
XPHY_EDGE_ROW_8_Right_8 VPWR VGND VPWR VGND sky130_fd_sc_hd__decap_3
XFILLER_15_290 VPWR VGND VPWR VGND sky130_fd_sc_hd__decap_3
XFILLER_13_249 VPWR VGND VPWR VGND sky130_fd_sc_hd__decap_3
XFILLER_13_205 VPWR VGND VPWR VGND sky130_fd_sc_hd__decap_3
Xmisfit01_core_13 uio_out[5] misfit01_core_13/HI VPWR VGND VGND VPWR sky130_fd_sc_hd__conb_1
Xmisfit01_core_24 uio_oe[2] misfit01_core_24/HI VPWR VGND VGND VPWR sky130_fd_sc_hd__conb_1
XFILLER_21_293 VPWR VGND VPWR VGND sky130_fd_sc_hd__decap_3
XFILLER_0_197 VPWR VGND VPWR VGND sky130_fd_sc_hd__decap_3
XFILLER_0_175 VPWR VGND VPWR VGND sky130_fd_sc_hd__decap_3
XFILLER_0_153 VPWR VGND VPWR VGND sky130_fd_sc_hd__decap_3
XFILLER_0_131 VPWR VGND VPWR VGND sky130_fd_sc_hd__decap_3
XFILLER_12_271 VPWR VGND VPWR VGND sky130_fd_sc_hd__decap_3
XFILLER_8_242 VPWR VGND VPWR VGND sky130_fd_sc_hd__decap_3
XFILLER_8_253 VPWR VGND VPWR VGND sky130_fd_sc_hd__decap_3
XFILLER_8_286 VPWR VGND VPWR VGND sky130_fd_sc_hd__decap_3
XFILLER_5_42 VPWR VGND VPWR VGND sky130_fd_sc_hd__decap_3
XFILLER_5_75 VPWR VGND VPWR VGND sky130_fd_sc_hd__decap_3
XFILLER_6_9 VPWR VGND VPWR VGND sky130_fd_sc_hd__decap_3
XFILLER_14_62 VPWR VGND VPWR VGND sky130_fd_sc_hd__decap_3
XFILLER_5_234 VPWR VGND VPWR VGND sky130_fd_sc_hd__decap_3
XFILLER_5_267 VPWR VGND VPWR VGND sky130_fd_sc_hd__decap_3
XFILLER_19_18 VPWR VGND VPWR VGND sky130_fd_sc_hd__decap_3
XFILLER_2_259 VPWR VGND VPWR VGND sky130_fd_sc_hd__decap_3
XFILLER_2_248 VPWR VGND VPWR VGND sky130_fd_sc_hd__decap_3
XFILLER_2_215 VPWR VGND VPWR VGND sky130_fd_sc_hd__decap_3
XFILLER_4_6 VPWR VGND VPWR VGND sky130_fd_sc_hd__decap_3
XFILLER_18_127 VPWR VGND VPWR VGND sky130_fd_sc_hd__decap_3
XFILLER_2_32 VPWR VGND VPWR VGND sky130_fd_sc_hd__decap_3
XFILLER_2_21 VPWR VGND VPWR VGND sky130_fd_sc_hd__decap_3
XFILLER_1_281 VPWR VGND VPWR VGND sky130_fd_sc_hd__decap_3
XFILLER_1_270 VPWR VGND VPWR VGND sky130_fd_sc_hd__decap_3
XFILLER_2_65 VPWR VGND VPWR VGND sky130_fd_sc_hd__decap_3
XFILLER_17_193 VPWR VGND VPWR VGND sky130_fd_sc_hd__decap_3
XFILLER_23_141 VPWR VGND VPWR VGND sky130_fd_sc_hd__decap_3
XFILLER_23_130 VPWR VGND VPWR VGND sky130_fd_sc_hd__decap_3
XFILLER_15_119 VPWR VGND VPWR VGND sky130_fd_sc_hd__decap_3
XFILLER_15_108 VPWR VGND VPWR VGND sky130_fd_sc_hd__decap_3
XFILLER_11_314 VPWR VGND VPWR VGND sky130_fd_sc_hd__decap_3
XFILLER_7_329 VPWR VGND VPWR VGND sky130_fd_sc_hd__decap_3
XFILLER_11_30 VPWR VGND VPWR VGND sky130_fd_sc_hd__decap_3
XFILLER_2_3 VPWR VGND VPWR VGND sky130_fd_sc_hd__decap_3
XFILLER_11_63 VPWR VGND VPWR VGND sky130_fd_sc_hd__decap_3
XFILLER_11_96 VPWR VGND VPWR VGND sky130_fd_sc_hd__decap_3
XFILLER_14_174 VPWR VGND VPWR VGND sky130_fd_sc_hd__decap_3
XFILLER_14_141 VPWR VGND VPWR VGND sky130_fd_sc_hd__decap_3
XFILLER_14_130 VPWR VGND VPWR VGND sky130_fd_sc_hd__decap_3
XFILLER_20_144 VPWR VGND VPWR VGND sky130_fd_sc_hd__decap_3
XFILLER_20_133 VPWR VGND VPWR VGND sky130_fd_sc_hd__decap_3
XFILLER_20_100 VPWR VGND VPWR VGND sky130_fd_sc_hd__decap_3
XFILLER_11_122 VPWR VGND VPWR VGND sky130_fd_sc_hd__decap_3
XFILLER_11_155 VPWR VGND VPWR VGND sky130_fd_sc_hd__decap_3
XFILLER_22_62 VPWR VGND VPWR VGND sky130_fd_sc_hd__decap_3
XFILLER_3_332 VPWR VGND VPWR VGND sky130_fd_sc_hd__decap_3
XFILLER_7_137 VPWR VGND VPWR VGND sky130_fd_sc_hd__decap_3
XFILLER_11_199 VPWR VGND VPWR VGND sky130_fd_sc_hd__decap_3
XFILLER_21_9 VPWR VGND VPWR VGND sky130_fd_sc_hd__decap_3
XFILLER_19_211 VPWR VGND VPWR VGND sky130_fd_sc_hd__decap_3
XFILLER_19_299 VPWR VGND VPWR VGND sky130_fd_sc_hd__decap_3
XFILLER_19_255 VPWR VGND VPWR VGND sky130_fd_sc_hd__decap_3
XFILLER_8_53 VPWR VGND VPWR VGND sky130_fd_sc_hd__decap_3
XFILLER_8_97 VPWR VGND VPWR VGND sky130_fd_sc_hd__decap_3
XFILLER_6_192 VPWR VGND VPWR VGND sky130_fd_sc_hd__decap_3
XFILLER_4_118 VPWR VGND VPWR VGND sky130_fd_sc_hd__decap_3
XFILLER_0_324 VPWR VGND VPWR VGND sky130_fd_sc_hd__decap_3
XFILLER_0_302 VPWR VGND VPWR VGND sky130_fd_sc_hd__decap_3
XFILLER_17_84 VPWR VGND VPWR VGND sky130_fd_sc_hd__decap_3
XFILLER_17_51 VPWR VGND VPWR VGND sky130_fd_sc_hd__decap_3
XFILLER_16_236 VPWR VGND VPWR VGND sky130_fd_sc_hd__decap_3
XFILLER_16_203 VPWR VGND VPWR VGND sky130_fd_sc_hd__decap_3
XFILLER_3_140 VPWR VGND VPWR VGND sky130_fd_sc_hd__decap_3
XFILLER_3_184 VPWR VGND VPWR VGND sky130_fd_sc_hd__decap_3
XFILLER_22_239 VPWR VGND VPWR VGND sky130_fd_sc_hd__decap_3
Xmisfit01_core_14 uio_out[6] misfit01_core_14/HI VPWR VGND VGND VPWR sky130_fd_sc_hd__conb_1
XFILLER_21_261 VPWR VGND VPWR VGND sky130_fd_sc_hd__decap_3
XFILLER_13_228 VPWR VGND VPWR VGND sky130_fd_sc_hd__decap_3
XFILLER_13_217 VPWR VGND VPWR VGND sky130_fd_sc_hd__decap_3
XFILLER_0_187 VPWR VGND VPWR VGND sky130_fd_sc_hd__decap_3
XFILLER_0_165 VPWR VGND VPWR VGND sky130_fd_sc_hd__decap_3
XFILLER_12_283 VPWR VGND VPWR VGND sky130_fd_sc_hd__decap_3
XFILLER_5_21 VPWR VGND VPWR VGND sky130_fd_sc_hd__decap_3
XFILLER_8_221 VPWR VGND VPWR VGND sky130_fd_sc_hd__decap_3
XFILLER_8_265 VPWR VGND VPWR VGND sky130_fd_sc_hd__decap_3
XFILLER_8_298 VPWR VGND VPWR VGND sky130_fd_sc_hd__decap_3
XFILLER_5_87 VPWR VGND VPWR VGND sky130_fd_sc_hd__decap_3
XFILLER_10_209 VPWR VGND VPWR VGND sky130_fd_sc_hd__decap_3
XFILLER_18_309 VPWR VGND VPWR VGND sky130_fd_sc_hd__decap_3
XFILLER_14_85 VPWR VGND VPWR VGND sky130_fd_sc_hd__decap_3
XFILLER_14_74 VPWR VGND VPWR VGND sky130_fd_sc_hd__decap_3
XFILLER_14_41 VPWR VGND VPWR VGND sky130_fd_sc_hd__decap_3
XFILLER_5_202 VPWR VGND VPWR VGND sky130_fd_sc_hd__decap_3
XFILLER_5_246 VPWR VGND VPWR VGND sky130_fd_sc_hd__decap_3
XFILLER_17_320 VPWR VGND VPWR VGND sky130_fd_sc_hd__decap_3
XFILLER_23_312 VPWR VGND VPWR VGND sky130_fd_sc_hd__decap_3
XFILLER_2_227 VPWR VGND VPWR VGND sky130_fd_sc_hd__decap_3
XFILLER_18_106 VPWR VGND VPWR VGND sky130_fd_sc_hd__decap_3
XFILLER_14_312 VPWR VGND VPWR VGND sky130_fd_sc_hd__decap_3
XFILLER_14_301 VPWR VGND VPWR VGND sky130_fd_sc_hd__decap_3
XFILLER_2_77 VPWR VGND VPWR VGND sky130_fd_sc_hd__decap_3
XFILLER_2_44 VPWR VGND VPWR VGND sky130_fd_sc_hd__decap_3
XFILLER_1_293 VPWR VGND VPWR VGND sky130_fd_sc_hd__decap_3
XFILLER_17_172 VPWR VGND VPWR VGND sky130_fd_sc_hd__decap_3
XFILLER_17_161 VPWR VGND VPWR VGND sky130_fd_sc_hd__decap_3
XFILLER_2_88 VPWR VGND VPWR VGND sky130_fd_sc_hd__decap_3
XFILLER_20_315 VPWR VGND VPWR VGND sky130_fd_sc_hd__decap_3
XFILLER_20_304 VPWR VGND VPWR VGND sky130_fd_sc_hd__decap_3
XFILLER_23_197 VPWR VGND VPWR VGND sky130_fd_sc_hd__decap_3
XFILLER_11_326 VPWR VGND VPWR VGND sky130_fd_sc_hd__decap_3
XFILLER_7_308 VPWR VGND VPWR VGND sky130_fd_sc_hd__decap_3
XFILLER_11_42 VPWR VGND VPWR VGND sky130_fd_sc_hd__decap_3
XFILLER_11_75 VPWR VGND VPWR VGND sky130_fd_sc_hd__decap_3
XFILLER_14_197 VPWR VGND VPWR VGND sky130_fd_sc_hd__decap_3
XFILLER_14_186 VPWR VGND VPWR VGND sky130_fd_sc_hd__decap_3
XFILLER_14_153 VPWR VGND VPWR VGND sky130_fd_sc_hd__decap_3
XFILLER_6_330 VPWR VGND VPWR VGND sky130_fd_sc_hd__decap_3
XFILLER_20_112 VPWR VGND VPWR VGND sky130_fd_sc_hd__decap_3
XFILLER_20_156 VPWR VGND VPWR VGND sky130_fd_sc_hd__decap_3
XFILLER_9_190 VPWR VGND VPWR VGND sky130_fd_sc_hd__decap_3
XFILLER_22_41 VPWR VGND VPWR VGND sky130_fd_sc_hd__decap_3
XFILLER_7_105 VPWR VGND VPWR VGND sky130_fd_sc_hd__decap_3
XFILLER_7_116 VPWR VGND VPWR VGND sky130_fd_sc_hd__decap_3
XFILLER_11_134 VPWR VGND VPWR VGND sky130_fd_sc_hd__decap_3
XFILLER_11_178 VPWR VGND VPWR VGND sky130_fd_sc_hd__decap_3
XFILLER_22_85 VPWR VGND VPWR VGND sky130_fd_sc_hd__decap_3
XFILLER_22_74 VPWR VGND VPWR VGND sky130_fd_sc_hd__decap_3
XFILLER_3_311 VPWR VGND VPWR VGND sky130_fd_sc_hd__decap_3
XFILLER_7_149 VPWR VGND VPWR VGND sky130_fd_sc_hd__decap_3
XFILLER_19_234 VPWR VGND VPWR VGND sky130_fd_sc_hd__decap_3
XFILLER_14_9 VPWR VGND VPWR VGND sky130_fd_sc_hd__decap_3
XFILLER_19_267 VPWR VGND VPWR VGND sky130_fd_sc_hd__decap_3
XFILLER_6_171 VPWR VGND VPWR VGND sky130_fd_sc_hd__decap_3
XFILLER_8_21 VPWR VGND VPWR VGND sky130_fd_sc_hd__decap_3
XFILLER_8_32 VPWR VGND VPWR VGND sky130_fd_sc_hd__decap_3
XFILLER_8_65 VPWR VGND VPWR VGND sky130_fd_sc_hd__decap_3
XFILLER_17_96 VPWR VGND VPWR VGND sky130_fd_sc_hd__decap_3
XFILLER_17_63 VPWR VGND VPWR VGND sky130_fd_sc_hd__decap_3
XFILLER_17_30 VPWR VGND VPWR VGND sky130_fd_sc_hd__decap_3
XFILLER_16_259 VPWR VGND VPWR VGND sky130_fd_sc_hd__decap_3
XFILLER_16_248 VPWR VGND VPWR VGND sky130_fd_sc_hd__decap_3
XFILLER_16_215 VPWR VGND VPWR VGND sky130_fd_sc_hd__decap_3
XFILLER_3_152 VPWR VGND VPWR VGND sky130_fd_sc_hd__decap_3
XFILLER_3_196 VPWR VGND VPWR VGND sky130_fd_sc_hd__decap_3
XFILLER_12_6 VPWR VGND VPWR VGND sky130_fd_sc_hd__decap_3
XFILLER_22_218 VPWR VGND VPWR VGND sky130_fd_sc_hd__decap_3
XFILLER_15_281 VPWR VGND VPWR VGND sky130_fd_sc_hd__decap_3
XFILLER_15_270 VPWR VGND VPWR VGND sky130_fd_sc_hd__decap_3
Xmisfit01_core_15 uio_out[7] misfit01_core_15/HI VPWR VGND VGND VPWR sky130_fd_sc_hd__conb_1
XFILLER_21_284 VPWR VGND VPWR VGND sky130_fd_sc_hd__decap_3
XFILLER_21_273 VPWR VGND VPWR VGND sky130_fd_sc_hd__decap_3
XFILLER_21_240 VPWR VGND VPWR VGND sky130_fd_sc_hd__decap_3
XFILLER_0_144 VPWR VGND VPWR VGND sky130_fd_sc_hd__decap_3
XFILLER_0_100 VPWR VGND VPWR VGND sky130_fd_sc_hd__decap_3
XFILLER_0_122 VPWR VGND VPWR VGND sky130_fd_sc_hd__decap_3
XFILLER_8_200 VPWR VGND VPWR VGND sky130_fd_sc_hd__decap_3
XFILLER_12_262 VPWR VGND VPWR VGND sky130_fd_sc_hd__decap_3
XFILLER_12_295 VPWR VGND VPWR VGND sky130_fd_sc_hd__decap_3
XFILLER_5_33 VPWR VGND VPWR VGND sky130_fd_sc_hd__decap_3
XFILLER_8_233 VPWR VGND VPWR VGND sky130_fd_sc_hd__decap_3
XFILLER_8_277 VPWR VGND VPWR VGND sky130_fd_sc_hd__decap_3
XFILLER_5_66 VPWR VGND VPWR VGND sky130_fd_sc_hd__decap_3
XFILLER_5_99 VPWR VGND VPWR VGND sky130_fd_sc_hd__decap_3
XFILLER_10_3 VPWR VGND VPWR VGND sky130_fd_sc_hd__decap_3
XFILLER_14_53 VPWR VGND VPWR VGND sky130_fd_sc_hd__decap_3
XFILLER_14_97 VPWR VGND VPWR VGND sky130_fd_sc_hd__decap_3
XFILLER_5_214 VPWR VGND VPWR VGND sky130_fd_sc_hd__decap_3
XFILLER_5_225 VPWR VGND VPWR VGND sky130_fd_sc_hd__decap_3
XFILLER_5_258 VPWR VGND VPWR VGND sky130_fd_sc_hd__decap_3
XFILLER_17_332 VPWR VGND VPWR VGND sky130_fd_sc_hd__decap_3
XFILLER_4_280 VPWR VGND VPWR VGND sky130_fd_sc_hd__decap_3
XFILLER_23_324 VPWR VGND VPWR VGND sky130_fd_sc_hd__decap_3
XFILLER_2_239 VPWR VGND VPWR VGND sky130_fd_sc_hd__decap_3
XFILLER_2_206 VPWR VGND VPWR VGND sky130_fd_sc_hd__decap_3
XFILLER_18_118 VPWR VGND VPWR VGND sky130_fd_sc_hd__decap_3
XFILLER_14_324 VPWR VGND VPWR VGND sky130_fd_sc_hd__decap_3
XFILLER_2_56 VPWR VGND VPWR VGND sky130_fd_sc_hd__decap_3
XFILLER_2_12 VPWR VGND VPWR VGND sky130_fd_sc_hd__decap_3
XFILLER_1_261 VPWR VGND VPWR VGND sky130_fd_sc_hd__decap_3
XFILLER_17_184 VPWR VGND VPWR VGND sky130_fd_sc_hd__decap_3
XFILLER_17_140 VPWR VGND VPWR VGND sky130_fd_sc_hd__decap_3
XFILLER_20_327 VPWR VGND VPWR VGND sky130_fd_sc_hd__decap_3
XFILLER_23_154 VPWR VGND VPWR VGND sky130_fd_sc_hd__decap_3
XFILLER_11_305 VPWR VGND VPWR VGND sky130_fd_sc_hd__decap_3
XFILLER_11_21 VPWR VGND VPWR VGND sky130_fd_sc_hd__decap_3
XFILLER_11_87 VPWR VGND VPWR VGND sky130_fd_sc_hd__decap_3
XFILLER_14_121 VPWR VGND VPWR VGND sky130_fd_sc_hd__decap_3
XFILLER_14_165 VPWR VGND VPWR VGND sky130_fd_sc_hd__decap_3
XFILLER_20_124 VPWR VGND VPWR VGND sky130_fd_sc_hd__decap_3
XFILLER_20_168 VPWR VGND VPWR VGND sky130_fd_sc_hd__decap_3
XFILLER_22_53 VPWR VGND VPWR VGND sky130_fd_sc_hd__decap_3
XFILLER_7_128 VPWR VGND VPWR VGND sky130_fd_sc_hd__decap_3
XFILLER_11_102 VPWR VGND VPWR VGND sky130_fd_sc_hd__decap_3
XFILLER_11_113 VPWR VGND VPWR VGND sky130_fd_sc_hd__decap_3
XFILLER_11_146 VPWR VGND VPWR VGND sky130_fd_sc_hd__decap_3
XFILLER_22_97 VPWR VGND VPWR VGND sky130_fd_sc_hd__decap_3
XFILLER_3_323 VPWR VGND VPWR VGND sky130_fd_sc_hd__decap_3
XFILLER_19_246 VPWR VGND VPWR VGND sky130_fd_sc_hd__decap_3
XFILLER_19_202 VPWR VGND VPWR VGND sky130_fd_sc_hd__decap_3
XFILLER_6_150 VPWR VGND VPWR VGND sky130_fd_sc_hd__decap_3
XFILLER_6_183 VPWR VGND VPWR VGND sky130_fd_sc_hd__decap_3
XFILLER_8_44 VPWR VGND VPWR VGND sky130_fd_sc_hd__decap_3
XFILLER_8_77 VPWR VGND VPWR VGND sky130_fd_sc_hd__decap_3
XFILLER_8_88 VPWR VGND VPWR VGND sky130_fd_sc_hd__decap_3
XFILLER_0_315 VPWR VGND VPWR VGND sky130_fd_sc_hd__decap_3
XFILLER_4_109 VPWR VGND VPWR VGND sky130_fd_sc_hd__decap_3
XPHY_EDGE_ROW_9_Left_33 VPWR VGND VPWR VGND sky130_fd_sc_hd__decap_3
XFILLER_17_75 VPWR VGND VPWR VGND sky130_fd_sc_hd__decap_3
XFILLER_17_42 VPWR VGND VPWR VGND sky130_fd_sc_hd__decap_3
XFILLER_16_227 VPWR VGND VPWR VGND sky130_fd_sc_hd__decap_3
XFILLER_3_131 VPWR VGND VPWR VGND sky130_fd_sc_hd__decap_3
XFILLER_3_164 VPWR VGND VPWR VGND sky130_fd_sc_hd__decap_3
XFILLER_3_175 VPWR VGND VPWR VGND sky130_fd_sc_hd__decap_3
XFILLER_15_293 VPWR VGND VPWR VGND sky130_fd_sc_hd__decap_3
XFILLER_13_208 VPWR VGND VPWR VGND sky130_fd_sc_hd__decap_3
Xmisfit01_core_16 uo_out[2] misfit01_core_16/HI VPWR VGND VGND VPWR sky130_fd_sc_hd__conb_1
XFILLER_21_296 VPWR VGND VPWR VGND sky130_fd_sc_hd__decap_3
XFILLER_21_252 VPWR VGND VPWR VGND sky130_fd_sc_hd__decap_3
XPHY_EDGE_ROW_17_Right_17 VPWR VGND VPWR VGND sky130_fd_sc_hd__decap_3
XFILLER_0_178 VPWR VGND VPWR VGND sky130_fd_sc_hd__decap_3
XFILLER_0_156 VPWR VGND VPWR VGND sky130_fd_sc_hd__decap_3
XFILLER_0_134 VPWR VGND VPWR VGND sky130_fd_sc_hd__decap_3
XFILLER_12_274 VPWR VGND VPWR VGND sky130_fd_sc_hd__decap_3
XFILLER_8_212 VPWR VGND VPWR VGND sky130_fd_sc_hd__decap_3
XFILLER_8_245 VPWR VGND VPWR VGND sky130_fd_sc_hd__decap_3
XFILLER_12_230 VPWR VGND VPWR VGND sky130_fd_sc_hd__decap_3
XFILLER_5_12 VPWR VGND VPWR VGND sky130_fd_sc_hd__decap_3
XFILLER_5_45 VPWR VGND VPWR VGND sky130_fd_sc_hd__decap_3
XFILLER_5_78 VPWR VGND VPWR VGND sky130_fd_sc_hd__decap_3
XFILLER_8_256 VPWR VGND VPWR VGND sky130_fd_sc_hd__decap_3
XFILLER_8_289 VPWR VGND VPWR VGND sky130_fd_sc_hd__decap_3
XFILLER_14_65 VPWR VGND VPWR VGND sky130_fd_sc_hd__decap_3
XFILLER_14_32 VPWR VGND VPWR VGND sky130_fd_sc_hd__decap_3
XFILLER_14_21 VPWR VGND VPWR VGND sky130_fd_sc_hd__decap_3
XFILLER_5_237 VPWR VGND VPWR VGND sky130_fd_sc_hd__decap_3
XFILLER_17_311 VPWR VGND VPWR VGND sky130_fd_sc_hd__decap_3
XFILLER_4_292 VPWR VGND VPWR VGND sky130_fd_sc_hd__decap_3
XFILLER_23_303 VPWR VGND VPWR VGND sky130_fd_sc_hd__decap_3
XFILLER_2_218 VPWR VGND VPWR VGND sky130_fd_sc_hd__decap_3
XFILLER_4_9 VPWR VGND VPWR VGND sky130_fd_sc_hd__decap_3
XPHY_EDGE_ROW_22_Left_46 VPWR VGND VPWR VGND sky130_fd_sc_hd__decap_3
XFILLER_1_240 VPWR VGND VPWR VGND sky130_fd_sc_hd__decap_3
XFILLER_2_68 VPWR VGND VPWR VGND sky130_fd_sc_hd__decap_3
XFILLER_2_35 VPWR VGND VPWR VGND sky130_fd_sc_hd__decap_3
XFILLER_2_24 VPWR VGND VPWR VGND sky130_fd_sc_hd__decap_3
XFILLER_1_284 VPWR VGND VPWR VGND sky130_fd_sc_hd__decap_3
XFILLER_1_273 VPWR VGND VPWR VGND sky130_fd_sc_hd__decap_3
XFILLER_17_196 VPWR VGND VPWR VGND sky130_fd_sc_hd__decap_3
XFILLER_17_152 VPWR VGND VPWR VGND sky130_fd_sc_hd__decap_3
XFILLER_23_100 VPWR VGND VPWR VGND sky130_fd_sc_hd__decap_3
XFILLER_11_317 VPWR VGND VPWR VGND sky130_fd_sc_hd__decap_3
XFILLER_2_6 VPWR VGND VPWR VGND sky130_fd_sc_hd__decap_3
XFILLER_11_33 VPWR VGND VPWR VGND sky130_fd_sc_hd__decap_3
XFILLER_11_66 VPWR VGND VPWR VGND sky130_fd_sc_hd__decap_3
XFILLER_11_99 VPWR VGND VPWR VGND sky130_fd_sc_hd__decap_3
XFILLER_14_177 VPWR VGND VPWR VGND sky130_fd_sc_hd__decap_3
XFILLER_14_144 VPWR VGND VPWR VGND sky130_fd_sc_hd__decap_3
XFILLER_14_133 VPWR VGND VPWR VGND sky130_fd_sc_hd__decap_3
XFILLER_14_100 VPWR VGND VPWR VGND sky130_fd_sc_hd__decap_3
XFILLER_6_321 VPWR VGND VPWR VGND sky130_fd_sc_hd__decap_3
XFILLER_20_147 VPWR VGND VPWR VGND sky130_fd_sc_hd__decap_3
XFILLER_20_136 VPWR VGND VPWR VGND sky130_fd_sc_hd__decap_3
XFILLER_20_103 VPWR VGND VPWR VGND sky130_fd_sc_hd__decap_3
XFILLER_9_181 VPWR VGND VPWR VGND sky130_fd_sc_hd__decap_3
XFILLER_22_65 VPWR VGND VPWR VGND sky130_fd_sc_hd__decap_3
XFILLER_22_32 VPWR VGND VPWR VGND sky130_fd_sc_hd__decap_3
XFILLER_22_21 VPWR VGND VPWR VGND sky130_fd_sc_hd__decap_3
XFILLER_3_302 VPWR VGND VPWR VGND sky130_fd_sc_hd__decap_3
XFILLER_11_125 VPWR VGND VPWR VGND sky130_fd_sc_hd__decap_3
XFILLER_11_158 VPWR VGND VPWR VGND sky130_fd_sc_hd__decap_3
XFILLER_11_169 VPWR VGND VPWR VGND sky130_fd_sc_hd__decap_3
XFILLER_0_3 VPWR VGND VPWR VGND sky130_fd_sc_hd__decap_3
XFILLER_19_258 VPWR VGND VPWR VGND sky130_fd_sc_hd__decap_3
XFILLER_19_225 VPWR VGND VPWR VGND sky130_fd_sc_hd__decap_3
XFILLER_19_214 VPWR VGND VPWR VGND sky130_fd_sc_hd__decap_3
XFILLER_8_12 VPWR VGND VPWR VGND sky130_fd_sc_hd__decap_3
XFILLER_8_56 VPWR VGND VPWR VGND sky130_fd_sc_hd__decap_3
XFILLER_6_162 VPWR VGND VPWR VGND sky130_fd_sc_hd__decap_3
XFILLER_10_180 VPWR VGND VPWR VGND sky130_fd_sc_hd__decap_3
XFILLER_18_280 VPWR VGND VPWR VGND sky130_fd_sc_hd__decap_3
XFILLER_0_327 VPWR VGND VPWR VGND sky130_fd_sc_hd__decap_3
XFILLER_0_305 VPWR VGND VPWR VGND sky130_fd_sc_hd__decap_3
XFILLER_17_21 VPWR VGND VPWR VGND sky130_fd_sc_hd__decap_3
XFILLER_16_239 VPWR VGND VPWR VGND sky130_fd_sc_hd__decap_3
XFILLER_16_206 VPWR VGND VPWR VGND sky130_fd_sc_hd__decap_3
XFILLER_17_87 VPWR VGND VPWR VGND sky130_fd_sc_hd__decap_3
XFILLER_3_143 VPWR VGND VPWR VGND sky130_fd_sc_hd__decap_3
XFILLER_3_187 VPWR VGND VPWR VGND sky130_fd_sc_hd__decap_3
XFILLER_15_261 VPWR VGND VPWR VGND sky130_fd_sc_hd__decap_3
XFILLER_21_264 VPWR VGND VPWR VGND sky130_fd_sc_hd__decap_3
XFILLER_21_231 VPWR VGND VPWR VGND sky130_fd_sc_hd__decap_3
XFILLER_21_220 VPWR VGND VPWR VGND sky130_fd_sc_hd__decap_3
Xmisfit01_core_17 uo_out[3] misfit01_core_17/HI VPWR VGND VGND VPWR sky130_fd_sc_hd__conb_1
XFILLER_0_113 VPWR VGND VPWR VGND sky130_fd_sc_hd__decap_3
XFILLER_12_286 VPWR VGND VPWR VGND sky130_fd_sc_hd__decap_3
XFILLER_8_224 VPWR VGND VPWR VGND sky130_fd_sc_hd__decap_3
XFILLER_8_268 VPWR VGND VPWR VGND sky130_fd_sc_hd__decap_3
XFILLER_12_242 VPWR VGND VPWR VGND sky130_fd_sc_hd__decap_3
XFILLER_12_253 VPWR VGND VPWR VGND sky130_fd_sc_hd__decap_3
XFILLER_5_24 VPWR VGND VPWR VGND sky130_fd_sc_hd__decap_3
XFILLER_5_57 VPWR VGND VPWR VGND sky130_fd_sc_hd__decap_3
XFILLER_7_290 VPWR VGND VPWR VGND sky130_fd_sc_hd__decap_3
XFILLER_14_88 VPWR VGND VPWR VGND sky130_fd_sc_hd__decap_3
XFILLER_14_77 VPWR VGND VPWR VGND sky130_fd_sc_hd__decap_3
XFILLER_14_44 VPWR VGND VPWR VGND sky130_fd_sc_hd__decap_3
XFILLER_5_205 VPWR VGND VPWR VGND sky130_fd_sc_hd__decap_3
XFILLER_5_249 VPWR VGND VPWR VGND sky130_fd_sc_hd__decap_3
XFILLER_17_323 VPWR VGND VPWR VGND sky130_fd_sc_hd__decap_3
XFILLER_4_271 VPWR VGND VPWR VGND sky130_fd_sc_hd__decap_3
XFILLER_23_315 VPWR VGND VPWR VGND sky130_fd_sc_hd__decap_3
XFILLER_18_109 VPWR VGND VPWR VGND sky130_fd_sc_hd__decap_3
XFILLER_14_315 VPWR VGND VPWR VGND sky130_fd_sc_hd__decap_3
XFILLER_14_304 VPWR VGND VPWR VGND sky130_fd_sc_hd__decap_3
XFILLER_1_252 VPWR VGND VPWR VGND sky130_fd_sc_hd__decap_3
XFILLER_17_164 VPWR VGND VPWR VGND sky130_fd_sc_hd__decap_3
XFILLER_17_131 VPWR VGND VPWR VGND sky130_fd_sc_hd__decap_3
XFILLER_2_47 VPWR VGND VPWR VGND sky130_fd_sc_hd__decap_3
XFILLER_1_296 VPWR VGND VPWR VGND sky130_fd_sc_hd__decap_3
XFILLER_20_318 VPWR VGND VPWR VGND sky130_fd_sc_hd__decap_3
XFILLER_17_175 VPWR VGND VPWR VGND sky130_fd_sc_hd__decap_3
XFILLER_23_178 VPWR VGND VPWR VGND sky130_fd_sc_hd__decap_3
XFILLER_11_12 VPWR VGND VPWR VGND sky130_fd_sc_hd__decap_3
XFILLER_11_329 VPWR VGND VPWR VGND sky130_fd_sc_hd__decap_3
XFILLER_11_45 VPWR VGND VPWR VGND sky130_fd_sc_hd__decap_3
XFILLER_11_78 VPWR VGND VPWR VGND sky130_fd_sc_hd__decap_3
XFILLER_14_189 VPWR VGND VPWR VGND sky130_fd_sc_hd__decap_3
XFILLER_14_156 VPWR VGND VPWR VGND sky130_fd_sc_hd__decap_3
XFILLER_14_112 VPWR VGND VPWR VGND sky130_fd_sc_hd__decap_3
XFILLER_20_159 VPWR VGND VPWR VGND sky130_fd_sc_hd__decap_3
XFILLER_20_115 VPWR VGND VPWR VGND sky130_fd_sc_hd__decap_3
XFILLER_9_193 VPWR VGND VPWR VGND sky130_fd_sc_hd__decap_3
XFILLER_3_90 VPWR VGND VPWR VGND sky130_fd_sc_hd__decap_3
XFILLER_11_137 VPWR VGND VPWR VGND sky130_fd_sc_hd__decap_3
XFILLER_22_88 VPWR VGND VPWR VGND sky130_fd_sc_hd__decap_3
XFILLER_22_77 VPWR VGND VPWR VGND sky130_fd_sc_hd__decap_3
XFILLER_22_44 VPWR VGND VPWR VGND sky130_fd_sc_hd__decap_3
XFILLER_3_314 VPWR VGND VPWR VGND sky130_fd_sc_hd__decap_3
XFILLER_7_108 VPWR VGND VPWR VGND sky130_fd_sc_hd__decap_3
XFILLER_7_119 VPWR VGND VPWR VGND sky130_fd_sc_hd__decap_3
XFILLER_19_237 VPWR VGND VPWR VGND sky130_fd_sc_hd__decap_3
XFILLER_8_24 VPWR VGND VPWR VGND sky130_fd_sc_hd__decap_3
XFILLER_8_35 VPWR VGND VPWR VGND sky130_fd_sc_hd__decap_3
XFILLER_8_68 VPWR VGND VPWR VGND sky130_fd_sc_hd__decap_3
XFILLER_6_130 VPWR VGND VPWR VGND sky130_fd_sc_hd__decap_3
XFILLER_6_141 VPWR VGND VPWR VGND sky130_fd_sc_hd__decap_3
XFILLER_6_174 VPWR VGND VPWR VGND sky130_fd_sc_hd__decap_3
XFILLER_10_192 VPWR VGND VPWR VGND sky130_fd_sc_hd__decap_3
XFILLER_18_292 VPWR VGND VPWR VGND sky130_fd_sc_hd__decap_3
XFILLER_17_99 VPWR VGND VPWR VGND sky130_fd_sc_hd__decap_3
XFILLER_17_66 VPWR VGND VPWR VGND sky130_fd_sc_hd__decap_3
XFILLER_17_33 VPWR VGND VPWR VGND sky130_fd_sc_hd__decap_3
XFILLER_16_218 VPWR VGND VPWR VGND sky130_fd_sc_hd__decap_3
XFILLER_3_122 VPWR VGND VPWR VGND sky130_fd_sc_hd__decap_3
XFILLER_3_155 VPWR VGND VPWR VGND sky130_fd_sc_hd__decap_3
XFILLER_3_199 VPWR VGND VPWR VGND sky130_fd_sc_hd__decap_3
XFILLER_12_9 VPWR VGND VPWR VGND sky130_fd_sc_hd__decap_3
XFILLER_15_284 VPWR VGND VPWR VGND sky130_fd_sc_hd__decap_3
XFILLER_15_273 VPWR VGND VPWR VGND sky130_fd_sc_hd__decap_3
XFILLER_15_240 VPWR VGND VPWR VGND sky130_fd_sc_hd__decap_3
XFILLER_0_80 VPWR VGND VPWR VGND sky130_fd_sc_hd__decap_3
XFILLER_21_287 VPWR VGND VPWR VGND sky130_fd_sc_hd__decap_3
XFILLER_21_276 VPWR VGND VPWR VGND sky130_fd_sc_hd__decap_3
XFILLER_21_243 VPWR VGND VPWR VGND sky130_fd_sc_hd__decap_3
XFILLER_0_91 VPWR VGND VPWR VGND sky130_fd_sc_hd__decap_3
XPHY_EDGE_ROW_3_Right_3 VPWR VGND VPWR VGND sky130_fd_sc_hd__decap_3
Xmisfit01_core_18 uo_out[4] misfit01_core_18/HI VPWR VGND VGND VPWR sky130_fd_sc_hd__conb_1
XFILLER_0_103 VPWR VGND VPWR VGND sky130_fd_sc_hd__decap_3
Xclkbuf_1_1__f_clk VGND VPWR VGND VPWR clkbuf_0_clk/X _00_/CLK clkbuf_1_1__f_clk/a_110_47#
+ sky130_fd_sc_hd__clkbuf_16
XFILLER_0_169 VPWR VGND VPWR VGND sky130_fd_sc_hd__decap_3
XFILLER_0_147 VPWR VGND VPWR VGND sky130_fd_sc_hd__decap_3
XFILLER_0_125 VPWR VGND VPWR VGND sky130_fd_sc_hd__decap_3
XFILLER_12_221 VPWR VGND VPWR VGND sky130_fd_sc_hd__decap_3
XFILLER_12_298 VPWR VGND VPWR VGND sky130_fd_sc_hd__decap_3
XFILLER_8_203 VPWR VGND VPWR VGND sky130_fd_sc_hd__decap_3
XFILLER_8_236 VPWR VGND VPWR VGND sky130_fd_sc_hd__decap_3
XFILLER_12_265 VPWR VGND VPWR VGND sky130_fd_sc_hd__decap_3
XFILLER_5_36 VPWR VGND VPWR VGND sky130_fd_sc_hd__decap_3
XFILLER_5_69 VPWR VGND VPWR VGND sky130_fd_sc_hd__decap_3
XFILLER_10_6 VPWR VGND VPWR VGND sky130_fd_sc_hd__decap_3
XFILLER_14_56 VPWR VGND VPWR VGND sky130_fd_sc_hd__decap_3
XFILLER_14_12 VPWR VGND VPWR VGND sky130_fd_sc_hd__decap_3
XFILLER_5_217 VPWR VGND VPWR VGND sky130_fd_sc_hd__decap_3
XFILLER_5_228 VPWR VGND VPWR VGND sky130_fd_sc_hd__decap_3
XFILLER_17_302 VPWR VGND VPWR VGND sky130_fd_sc_hd__decap_3
XFILLER_4_283 VPWR VGND VPWR VGND sky130_fd_sc_hd__decap_3
XFILLER_23_327 VPWR VGND VPWR VGND sky130_fd_sc_hd__decap_3
XFILLER_2_209 VPWR VGND VPWR VGND sky130_fd_sc_hd__decap_3
XFILLER_14_327 VPWR VGND VPWR VGND sky130_fd_sc_hd__decap_3
XFILLER_2_59 VPWR VGND VPWR VGND sky130_fd_sc_hd__decap_3
XFILLER_2_15 VPWR VGND VPWR VGND sky130_fd_sc_hd__decap_3
XFILLER_1_264 VPWR VGND VPWR VGND sky130_fd_sc_hd__decap_3
XFILLER_1_231 VPWR VGND VPWR VGND sky130_fd_sc_hd__decap_3
XFILLER_1_220 VPWR VGND VPWR VGND sky130_fd_sc_hd__decap_3
XFILLER_17_187 VPWR VGND VPWR VGND sky130_fd_sc_hd__decap_3
XFILLER_17_143 VPWR VGND VPWR VGND sky130_fd_sc_hd__decap_3
XFILLER_9_320 VPWR VGND VPWR VGND sky130_fd_sc_hd__decap_3
XFILLER_23_124 VPWR VGND VPWR VGND sky130_fd_sc_hd__decap_3
XFILLER_11_308 VPWR VGND VPWR VGND sky130_fd_sc_hd__decap_3
XFILLER_11_24 VPWR VGND VPWR VGND sky130_fd_sc_hd__decap_3
XFILLER_11_57 VPWR VGND VPWR VGND sky130_fd_sc_hd__decap_3
XFILLER_14_168 VPWR VGND VPWR VGND sky130_fd_sc_hd__decap_3
XFILLER_14_124 VPWR VGND VPWR VGND sky130_fd_sc_hd__decap_3
XFILLER_6_301 VPWR VGND VPWR VGND sky130_fd_sc_hd__decap_3
XFILLER_10_330 VPWR VGND VPWR VGND sky130_fd_sc_hd__decap_3
XFILLER_6_312 VPWR VGND VPWR VGND sky130_fd_sc_hd__decap_3
XFILLER_20_127 VPWR VGND VPWR VGND sky130_fd_sc_hd__decap_3
XFILLER_13_190 VPWR VGND VPWR VGND sky130_fd_sc_hd__decap_3
XFILLER_9_161 VPWR VGND VPWR VGND sky130_fd_sc_hd__decap_3
XFILLER_9_172 VPWR VGND VPWR VGND sky130_fd_sc_hd__decap_3
XFILLER_22_12 VPWR VGND VPWR VGND sky130_fd_sc_hd__decap_3
XFILLER_11_105 VPWR VGND VPWR VGND sky130_fd_sc_hd__decap_3
XFILLER_11_116 VPWR VGND VPWR VGND sky130_fd_sc_hd__decap_3
XFILLER_11_149 VPWR VGND VPWR VGND sky130_fd_sc_hd__decap_3
XFILLER_22_56 VPWR VGND VPWR VGND sky130_fd_sc_hd__decap_3
XFILLER_3_326 VPWR VGND VPWR VGND sky130_fd_sc_hd__decap_3
XFILLER_19_205 VPWR VGND VPWR VGND sky130_fd_sc_hd__decap_3
XFILLER_19_249 VPWR VGND VPWR VGND sky130_fd_sc_hd__decap_3
XFILLER_6_153 VPWR VGND VPWR VGND sky130_fd_sc_hd__decap_3
XFILLER_8_47 VPWR VGND VPWR VGND sky130_fd_sc_hd__decap_3
XFILLER_10_171 VPWR VGND VPWR VGND sky130_fd_sc_hd__decap_3
XFILLER_6_186 VPWR VGND VPWR VGND sky130_fd_sc_hd__decap_3
XFILLER_6_197 VPWR VGND VPWR VGND sky130_fd_sc_hd__decap_3
XFILLER_19_3 VPWR VGND VPWR VGND sky130_fd_sc_hd__decap_3
XFILLER_18_271 VPWR VGND VPWR VGND sky130_fd_sc_hd__decap_3
XFILLER_0_318 VPWR VGND VPWR VGND sky130_fd_sc_hd__decap_3
XFILLER_17_78 VPWR VGND VPWR VGND sky130_fd_sc_hd__decap_3
XFILLER_17_45 VPWR VGND VPWR VGND sky130_fd_sc_hd__decap_3
XFILLER_17_12 VPWR VGND VPWR VGND sky130_fd_sc_hd__decap_3
XFILLER_3_134 VPWR VGND VPWR VGND sky130_fd_sc_hd__decap_3
XFILLER_3_178 VPWR VGND VPWR VGND sky130_fd_sc_hd__decap_3
XFILLER_15_296 VPWR VGND VPWR VGND sky130_fd_sc_hd__decap_3
XFILLER_15_252 VPWR VGND VPWR VGND sky130_fd_sc_hd__decap_3
Xmisfit01_core_19 uo_out[5] misfit01_core_19/HI VPWR VGND VGND VPWR sky130_fd_sc_hd__conb_1
XFILLER_21_299 VPWR VGND VPWR VGND sky130_fd_sc_hd__decap_3
XFILLER_21_255 VPWR VGND VPWR VGND sky130_fd_sc_hd__decap_3
XFILLER_21_211 VPWR VGND VPWR VGND sky130_fd_sc_hd__decap_3
XFILLER_9_90 VPWR VGND VPWR VGND sky130_fd_sc_hd__decap_3
XFILLER_0_159 VPWR VGND VPWR VGND sky130_fd_sc_hd__decap_3
XFILLER_0_137 VPWR VGND VPWR VGND sky130_fd_sc_hd__decap_3
XFILLER_12_200 VPWR VGND VPWR VGND sky130_fd_sc_hd__decap_3
XFILLER_12_233 VPWR VGND VPWR VGND sky130_fd_sc_hd__decap_3
XFILLER_12_277 VPWR VGND VPWR VGND sky130_fd_sc_hd__decap_3
XFILLER_5_15 VPWR VGND VPWR VGND sky130_fd_sc_hd__decap_3
XFILLER_8_215 VPWR VGND VPWR VGND sky130_fd_sc_hd__decap_3
XFILLER_8_248 VPWR VGND VPWR VGND sky130_fd_sc_hd__decap_3
XFILLER_8_259 VPWR VGND VPWR VGND sky130_fd_sc_hd__decap_3
XFILLER_5_48 VPWR VGND VPWR VGND sky130_fd_sc_hd__decap_3
XPHY_EDGE_ROW_13_Right_13 VPWR VGND VPWR VGND sky130_fd_sc_hd__decap_3
XPHY_EDGE_ROW_22_Right_22 VPWR VGND VPWR VGND sky130_fd_sc_hd__decap_3
XFILLER_7_270 VPWR VGND VPWR VGND sky130_fd_sc_hd__decap_3
XFILLER_7_281 VPWR VGND VPWR VGND sky130_fd_sc_hd__decap_3
XFILLER_14_35 VPWR VGND VPWR VGND sky130_fd_sc_hd__decap_3
XFILLER_14_24 VPWR VGND VPWR VGND sky130_fd_sc_hd__decap_3
XFILLER_14_68 VPWR VGND VPWR VGND sky130_fd_sc_hd__decap_3
XFILLER_17_314 VPWR VGND VPWR VGND sky130_fd_sc_hd__decap_3
XFILLER_4_262 VPWR VGND VPWR VGND sky130_fd_sc_hd__decap_3
XFILLER_4_295 VPWR VGND VPWR VGND sky130_fd_sc_hd__decap_3
XFILLER_6_80 VPWR VGND VPWR VGND sky130_fd_sc_hd__decap_3
XFILLER_6_91 VPWR VGND VPWR VGND sky130_fd_sc_hd__decap_3
XFILLER_2_38 VPWR VGND VPWR VGND sky130_fd_sc_hd__decap_3
XFILLER_1_287 VPWR VGND VPWR VGND sky130_fd_sc_hd__decap_3
XFILLER_1_276 VPWR VGND VPWR VGND sky130_fd_sc_hd__decap_3
XFILLER_1_243 VPWR VGND VPWR VGND sky130_fd_sc_hd__decap_3
XFILLER_17_199 VPWR VGND VPWR VGND sky130_fd_sc_hd__decap_3
XFILLER_17_155 VPWR VGND VPWR VGND sky130_fd_sc_hd__decap_3
XFILLER_17_122 VPWR VGND VPWR VGND sky130_fd_sc_hd__decap_3
XFILLER_20_309 VPWR VGND VPWR VGND sky130_fd_sc_hd__decap_3
XFILLER_9_332 VPWR VGND VPWR VGND sky130_fd_sc_hd__decap_3
XFILLER_11_36 VPWR VGND VPWR VGND sky130_fd_sc_hd__decap_3
XFILLER_11_69 VPWR VGND VPWR VGND sky130_fd_sc_hd__decap_3
XFILLER_2_9 VPWR VGND VPWR VGND sky130_fd_sc_hd__decap_3
XFILLER_14_136 VPWR VGND VPWR VGND sky130_fd_sc_hd__decap_3
XFILLER_14_103 VPWR VGND VPWR VGND sky130_fd_sc_hd__decap_3
XFILLER_22_180 VPWR VGND VPWR VGND sky130_fd_sc_hd__decap_3
XFILLER_14_147 VPWR VGND VPWR VGND sky130_fd_sc_hd__decap_3
XFILLER_6_324 VPWR VGND VPWR VGND sky130_fd_sc_hd__decap_3
XFILLER_20_106 VPWR VGND VPWR VGND sky130_fd_sc_hd__decap_3
XFILLER_9_140 VPWR VGND VPWR VGND sky130_fd_sc_hd__decap_3
XFILLER_9_184 VPWR VGND VPWR VGND sky130_fd_sc_hd__decap_3
XFILLER_3_81 VPWR VGND VPWR VGND sky130_fd_sc_hd__decap_3
XFILLER_22_35 VPWR VGND VPWR VGND sky130_fd_sc_hd__decap_3
XFILLER_22_24 VPWR VGND VPWR VGND sky130_fd_sc_hd__decap_3
XFILLER_11_128 VPWR VGND VPWR VGND sky130_fd_sc_hd__decap_3
XFILLER_22_68 VPWR VGND VPWR VGND sky130_fd_sc_hd__decap_3
XFILLER_0_6 VPWR VGND VPWR VGND sky130_fd_sc_hd__decap_3
XFILLER_3_305 VPWR VGND VPWR VGND sky130_fd_sc_hd__decap_3
XFILLER_19_228 VPWR VGND VPWR VGND sky130_fd_sc_hd__decap_3
XFILLER_19_217 VPWR VGND VPWR VGND sky130_fd_sc_hd__decap_3
XFILLER_8_15 VPWR VGND VPWR VGND sky130_fd_sc_hd__decap_3
XFILLER_6_121 VPWR VGND VPWR VGND sky130_fd_sc_hd__decap_3
XFILLER_6_165 VPWR VGND VPWR VGND sky130_fd_sc_hd__decap_3
XFILLER_8_59 VPWR VGND VPWR VGND sky130_fd_sc_hd__decap_3
XFILLER_10_150 VPWR VGND VPWR VGND sky130_fd_sc_hd__decap_3
XFILLER_10_183 VPWR VGND VPWR VGND sky130_fd_sc_hd__decap_3
XFILLER_18_283 VPWR VGND VPWR VGND sky130_fd_sc_hd__decap_3
XFILLER_17_57 VPWR VGND VPWR VGND sky130_fd_sc_hd__decap_3
XFILLER_17_24 VPWR VGND VPWR VGND sky130_fd_sc_hd__decap_3
XFILLER_16_209 VPWR VGND VPWR VGND sky130_fd_sc_hd__decap_3
XFILLER_3_102 VPWR VGND VPWR VGND sky130_fd_sc_hd__decap_3
XFILLER_3_113 VPWR VGND VPWR VGND sky130_fd_sc_hd__decap_3
XFILLER_3_146 VPWR VGND VPWR VGND sky130_fd_sc_hd__decap_3
XFILLER_15_220 VPWR VGND VPWR VGND sky130_fd_sc_hd__decap_3
XFILLER_15_264 VPWR VGND VPWR VGND sky130_fd_sc_hd__decap_3
XFILLER_15_231 VPWR VGND VPWR VGND sky130_fd_sc_hd__decap_3
XPHY_EDGE_ROW_13_Left_37 VPWR VGND VPWR VGND sky130_fd_sc_hd__decap_3
XFILLER_0_71 VPWR VGND VPWR VGND sky130_fd_sc_hd__decap_3
XFILLER_21_267 VPWR VGND VPWR VGND sky130_fd_sc_hd__decap_3
XFILLER_21_234 VPWR VGND VPWR VGND sky130_fd_sc_hd__decap_3
XFILLER_0_116 VPWR VGND VPWR VGND sky130_fd_sc_hd__decap_3
XFILLER_8_227 VPWR VGND VPWR VGND sky130_fd_sc_hd__decap_3
XFILLER_12_212 VPWR VGND VPWR VGND sky130_fd_sc_hd__decap_3
XFILLER_12_245 VPWR VGND VPWR VGND sky130_fd_sc_hd__decap_3
XFILLER_12_256 VPWR VGND VPWR VGND sky130_fd_sc_hd__decap_3
XFILLER_12_289 VPWR VGND VPWR VGND sky130_fd_sc_hd__decap_3
XFILLER_5_27 VPWR VGND VPWR VGND sky130_fd_sc_hd__decap_3
XFILLER_7_293 VPWR VGND VPWR VGND sky130_fd_sc_hd__decap_3
XFILLER_14_47 VPWR VGND VPWR VGND sky130_fd_sc_hd__decap_3
XFILLER_5_208 VPWR VGND VPWR VGND sky130_fd_sc_hd__decap_3
XFILLER_17_326 VPWR VGND VPWR VGND sky130_fd_sc_hd__decap_3
XFILLER_4_230 VPWR VGND VPWR VGND sky130_fd_sc_hd__decap_3
XFILLER_4_274 VPWR VGND VPWR VGND sky130_fd_sc_hd__decap_3
XFILLER_23_318 VPWR VGND VPWR VGND sky130_fd_sc_hd__decap_3
XPHY_EDGE_ROW_16_Left_40 VPWR VGND VPWR VGND sky130_fd_sc_hd__decap_3
XFILLER_14_318 VPWR VGND VPWR VGND sky130_fd_sc_hd__decap_3
XFILLER_1_211 VPWR VGND VPWR VGND sky130_fd_sc_hd__decap_3
XFILLER_9_3 VPWR VGND VPWR VGND sky130_fd_sc_hd__decap_3
XFILLER_1_299 VPWR VGND VPWR VGND sky130_fd_sc_hd__decap_3
XFILLER_1_255 VPWR VGND VPWR VGND sky130_fd_sc_hd__decap_3
XFILLER_17_178 VPWR VGND VPWR VGND sky130_fd_sc_hd__decap_3
XFILLER_17_134 VPWR VGND VPWR VGND sky130_fd_sc_hd__decap_3
XFILLER_15_90 VPWR VGND VPWR VGND sky130_fd_sc_hd__decap_3
XFILLER_9_311 VPWR VGND VPWR VGND sky130_fd_sc_hd__decap_3
XFILLER_23_148 VPWR VGND VPWR VGND sky130_fd_sc_hd__decap_3
XFILLER_11_15 VPWR VGND VPWR VGND sky130_fd_sc_hd__decap_3
XFILLER_11_48 VPWR VGND VPWR VGND sky130_fd_sc_hd__decap_3
XFILLER_14_159 VPWR VGND VPWR VGND sky130_fd_sc_hd__decap_3
XFILLER_14_115 VPWR VGND VPWR VGND sky130_fd_sc_hd__decap_3
XPHY_EDGE_ROW_1_Left_25 VPWR VGND VPWR VGND sky130_fd_sc_hd__decap_3
XFILLER_10_321 VPWR VGND VPWR VGND sky130_fd_sc_hd__decap_3
XFILLER_20_118 VPWR VGND VPWR VGND sky130_fd_sc_hd__decap_3
XFILLER_13_181 VPWR VGND VPWR VGND sky130_fd_sc_hd__decap_3
XFILLER_9_152 VPWR VGND VPWR VGND sky130_fd_sc_hd__decap_3
XFILLER_9_196 VPWR VGND VPWR VGND sky130_fd_sc_hd__decap_3
XFILLER_3_60 VPWR VGND VPWR VGND sky130_fd_sc_hd__decap_3
XFILLER_3_93 VPWR VGND VPWR VGND sky130_fd_sc_hd__decap_3
XFILLER_22_47 VPWR VGND VPWR VGND sky130_fd_sc_hd__decap_3
XFILLER_3_317 VPWR VGND VPWR VGND sky130_fd_sc_hd__decap_3
XFILLER_8_38 VPWR VGND VPWR VGND sky130_fd_sc_hd__decap_3
XFILLER_6_100 VPWR VGND VPWR VGND sky130_fd_sc_hd__decap_3
XFILLER_6_133 VPWR VGND VPWR VGND sky130_fd_sc_hd__decap_3
XFILLER_6_144 VPWR VGND VPWR VGND sky130_fd_sc_hd__decap_3
XFILLER_6_177 VPWR VGND VPWR VGND sky130_fd_sc_hd__decap_3
XFILLER_10_162 VPWR VGND VPWR VGND sky130_fd_sc_hd__decap_3
XFILLER_12_80 VPWR VGND VPWR VGND sky130_fd_sc_hd__decap_3
XFILLER_12_91 VPWR VGND VPWR VGND sky130_fd_sc_hd__decap_3
XFILLER_18_295 VPWR VGND VPWR VGND sky130_fd_sc_hd__decap_3
XFILLER_18_262 VPWR VGND VPWR VGND sky130_fd_sc_hd__decap_3
XFILLER_0_309 VPWR VGND VPWR VGND sky130_fd_sc_hd__decap_3
XFILLER_17_36 VPWR VGND VPWR VGND sky130_fd_sc_hd__decap_3
XFILLER_17_69 VPWR VGND VPWR VGND sky130_fd_sc_hd__decap_3
XFILLER_3_125 VPWR VGND VPWR VGND sky130_fd_sc_hd__decap_3
XFILLER_3_158 VPWR VGND VPWR VGND sky130_fd_sc_hd__decap_3
XFILLER_3_169 VPWR VGND VPWR VGND sky130_fd_sc_hd__decap_3
XFILLER_15_243 VPWR VGND VPWR VGND sky130_fd_sc_hd__decap_3
XFILLER_15_287 VPWR VGND VPWR VGND sky130_fd_sc_hd__decap_3
XFILLER_15_276 VPWR VGND VPWR VGND sky130_fd_sc_hd__decap_3
XFILLER_2_180 VPWR VGND VPWR VGND sky130_fd_sc_hd__decap_3
XFILLER_21_246 VPWR VGND VPWR VGND sky130_fd_sc_hd__decap_3
XFILLER_0_50 VPWR VGND VPWR VGND sky130_fd_sc_hd__decap_3
XFILLER_0_94 VPWR VGND VPWR VGND sky130_fd_sc_hd__decap_3
XFILLER_9_81 VPWR VGND VPWR VGND sky130_fd_sc_hd__decap_3
XFILLER_0_106 VPWR VGND VPWR VGND sky130_fd_sc_hd__decap_3
XFILLER_0_128 VPWR VGND VPWR VGND sky130_fd_sc_hd__decap_3
XFILLER_8_206 VPWR VGND VPWR VGND sky130_fd_sc_hd__decap_3
XFILLER_8_239 VPWR VGND VPWR VGND sky130_fd_sc_hd__decap_3
XFILLER_12_224 VPWR VGND VPWR VGND sky130_fd_sc_hd__decap_3
XFILLER_12_268 VPWR VGND VPWR VGND sky130_fd_sc_hd__decap_3
XFILLER_5_39 VPWR VGND VPWR VGND sky130_fd_sc_hd__decap_3
XFILLER_10_9 VPWR VGND VPWR VGND sky130_fd_sc_hd__decap_3
XFILLER_7_261 VPWR VGND VPWR VGND sky130_fd_sc_hd__decap_3
XFILLER_11_290 VPWR VGND VPWR VGND sky130_fd_sc_hd__decap_3
XPHY_EDGE_ROW_7_Right_7 VPWR VGND VPWR VGND sky130_fd_sc_hd__decap_3
XFILLER_14_59 VPWR VGND VPWR VGND sky130_fd_sc_hd__decap_3
XFILLER_14_15 VPWR VGND VPWR VGND sky130_fd_sc_hd__decap_3
XFILLER_17_305 VPWR VGND VPWR VGND sky130_fd_sc_hd__decap_3
XFILLER_20_91 VPWR VGND VPWR VGND sky130_fd_sc_hd__decap_3
XFILLER_20_80 VPWR VGND VPWR VGND sky130_fd_sc_hd__decap_3
XFILLER_4_242 VPWR VGND VPWR VGND sky130_fd_sc_hd__decap_3
XFILLER_4_253 VPWR VGND VPWR VGND sky130_fd_sc_hd__decap_3
XFILLER_4_286 VPWR VGND VPWR VGND sky130_fd_sc_hd__decap_3
XFILLER_6_71 VPWR VGND VPWR VGND sky130_fd_sc_hd__decap_3
XFILLER_22_330 VPWR VGND VPWR VGND sky130_fd_sc_hd__decap_3
XFILLER_1_267 VPWR VGND VPWR VGND sky130_fd_sc_hd__decap_3
XFILLER_1_234 VPWR VGND VPWR VGND sky130_fd_sc_hd__decap_3
XFILLER_17_146 VPWR VGND VPWR VGND sky130_fd_sc_hd__decap_3
XFILLER_17_113 VPWR VGND VPWR VGND sky130_fd_sc_hd__decap_3
XFILLER_17_102 VPWR VGND VPWR VGND sky130_fd_sc_hd__decap_3
XFILLER_2_29 VPWR VGND VPWR VGND sky130_fd_sc_hd__decap_3
XFILLER_2_18 VPWR VGND VPWR VGND sky130_fd_sc_hd__decap_3
XFILLER_9_323 VPWR VGND VPWR VGND sky130_fd_sc_hd__decap_3
XFILLER_11_27 VPWR VGND VPWR VGND sky130_fd_sc_hd__decap_3
XFILLER_14_127 VPWR VGND VPWR VGND sky130_fd_sc_hd__decap_3
XFILLER_22_171 VPWR VGND VPWR VGND sky130_fd_sc_hd__decap_3
XFILLER_6_304 VPWR VGND VPWR VGND sky130_fd_sc_hd__decap_3
XFILLER_6_315 VPWR VGND VPWR VGND sky130_fd_sc_hd__decap_3
XFILLER_13_193 VPWR VGND VPWR VGND sky130_fd_sc_hd__decap_3
XFILLER_9_131 VPWR VGND VPWR VGND sky130_fd_sc_hd__decap_3
XFILLER_9_164 VPWR VGND VPWR VGND sky130_fd_sc_hd__decap_3
XFILLER_9_175 VPWR VGND VPWR VGND sky130_fd_sc_hd__decap_3
XFILLER_3_72 VPWR VGND VPWR VGND sky130_fd_sc_hd__decap_3
XFILLER_11_108 VPWR VGND VPWR VGND sky130_fd_sc_hd__decap_3
XFILLER_11_119 VPWR VGND VPWR VGND sky130_fd_sc_hd__decap_3
XFILLER_22_59 VPWR VGND VPWR VGND sky130_fd_sc_hd__decap_3
XFILLER_22_15 VPWR VGND VPWR VGND sky130_fd_sc_hd__decap_3
XFILLER_3_329 VPWR VGND VPWR VGND sky130_fd_sc_hd__decap_3
XFILLER_19_208 VPWR VGND VPWR VGND sky130_fd_sc_hd__decap_3
XFILLER_10_130 VPWR VGND VPWR VGND sky130_fd_sc_hd__decap_3
XFILLER_10_141 VPWR VGND VPWR VGND sky130_fd_sc_hd__decap_3
XFILLER_6_112 VPWR VGND VPWR VGND sky130_fd_sc_hd__decap_3
XFILLER_6_156 VPWR VGND VPWR VGND sky130_fd_sc_hd__decap_3
XFILLER_6_189 VPWR VGND VPWR VGND sky130_fd_sc_hd__decap_3
XFILLER_10_174 VPWR VGND VPWR VGND sky130_fd_sc_hd__decap_3
XFILLER_19_6 VPWR VGND VPWR VGND sky130_fd_sc_hd__decap_3
XFILLER_18_274 VPWR VGND VPWR VGND sky130_fd_sc_hd__decap_3
XFILLER_18_230 VPWR VGND VPWR VGND sky130_fd_sc_hd__decap_3
XFILLER_17_48 VPWR VGND VPWR VGND sky130_fd_sc_hd__decap_3
XFILLER_17_15 VPWR VGND VPWR VGND sky130_fd_sc_hd__decap_3
XFILLER_3_137 VPWR VGND VPWR VGND sky130_fd_sc_hd__decap_3
XFILLER_15_255 VPWR VGND VPWR VGND sky130_fd_sc_hd__decap_3
XFILLER_15_211 VPWR VGND VPWR VGND sky130_fd_sc_hd__decap_3
XFILLER_15_299 VPWR VGND VPWR VGND sky130_fd_sc_hd__decap_3
XFILLER_2_192 VPWR VGND VPWR VGND sky130_fd_sc_hd__decap_3
XFILLER_17_3 VPWR VGND VPWR VGND sky130_fd_sc_hd__decap_3
XFILLER_21_258 VPWR VGND VPWR VGND sky130_fd_sc_hd__decap_3
XFILLER_21_225 VPWR VGND VPWR VGND sky130_fd_sc_hd__decap_3
XFILLER_21_214 VPWR VGND VPWR VGND sky130_fd_sc_hd__decap_3
XFILLER_9_60 VPWR VGND VPWR VGND sky130_fd_sc_hd__decap_3
XFILLER_9_93 VPWR VGND VPWR VGND sky130_fd_sc_hd__decap_3
XFILLER_12_203 VPWR VGND VPWR VGND sky130_fd_sc_hd__decap_3
XFILLER_20_280 VPWR VGND VPWR VGND sky130_fd_sc_hd__decap_3
XFILLER_8_218 VPWR VGND VPWR VGND sky130_fd_sc_hd__decap_3
XFILLER_12_236 VPWR VGND VPWR VGND sky130_fd_sc_hd__decap_3
XFILLER_5_18 VPWR VGND VPWR VGND sky130_fd_sc_hd__decap_3
XFILLER_18_80 VPWR VGND VPWR VGND sky130_fd_sc_hd__decap_3
XFILLER_18_91 VPWR VGND VPWR VGND sky130_fd_sc_hd__decap_3
XFILLER_7_240 VPWR VGND VPWR VGND sky130_fd_sc_hd__decap_3
XFILLER_7_273 VPWR VGND VPWR VGND sky130_fd_sc_hd__decap_3
XFILLER_7_284 VPWR VGND VPWR VGND sky130_fd_sc_hd__decap_3
XFILLER_14_38 VPWR VGND VPWR VGND sky130_fd_sc_hd__decap_3
XFILLER_17_317 VPWR VGND VPWR VGND sky130_fd_sc_hd__decap_3
XFILLER_4_221 VPWR VGND VPWR VGND sky130_fd_sc_hd__decap_3
XFILLER_4_265 VPWR VGND VPWR VGND sky130_fd_sc_hd__decap_3
XFILLER_4_298 VPWR VGND VPWR VGND sky130_fd_sc_hd__decap_3
XFILLER_23_309 VPWR VGND VPWR VGND sky130_fd_sc_hd__decap_3
XFILLER_6_50 VPWR VGND VPWR VGND sky130_fd_sc_hd__decap_3
XFILLER_6_94 VPWR VGND VPWR VGND sky130_fd_sc_hd__decap_3
XFILLER_14_309 VPWR VGND VPWR VGND sky130_fd_sc_hd__decap_3
XFILLER_1_246 VPWR VGND VPWR VGND sky130_fd_sc_hd__decap_3
XFILLER_1_202 VPWR VGND VPWR VGND sky130_fd_sc_hd__decap_3
XFILLER_17_169 VPWR VGND VPWR VGND sky130_fd_sc_hd__decap_3
XFILLER_17_158 VPWR VGND VPWR VGND sky130_fd_sc_hd__decap_3
XFILLER_17_125 VPWR VGND VPWR VGND sky130_fd_sc_hd__decap_3
XFILLER_15_81 VPWR VGND VPWR VGND sky130_fd_sc_hd__decap_3
XFILLER_13_320 VPWR VGND VPWR VGND sky130_fd_sc_hd__decap_3
XFILLER_9_302 VPWR VGND VPWR VGND sky130_fd_sc_hd__decap_3
XFILLER_0_290 VPWR VGND VPWR VGND sky130_fd_sc_hd__decap_3
XFILLER_23_106 VPWR VGND VPWR VGND sky130_fd_sc_hd__decap_3
XFILLER_16_180 VPWR VGND VPWR VGND sky130_fd_sc_hd__decap_3
XFILLER_11_39 VPWR VGND VPWR VGND sky130_fd_sc_hd__decap_3
XFILLER_22_183 VPWR VGND VPWR VGND sky130_fd_sc_hd__decap_3
XFILLER_22_150 VPWR VGND VPWR VGND sky130_fd_sc_hd__decap_3
XFILLER_14_106 VPWR VGND VPWR VGND sky130_fd_sc_hd__decap_3
XFILLER_10_301 VPWR VGND VPWR VGND sky130_fd_sc_hd__decap_3
XFILLER_10_312 VPWR VGND VPWR VGND sky130_fd_sc_hd__decap_3
XFILLER_6_327 VPWR VGND VPWR VGND sky130_fd_sc_hd__decap_3
XFILLER_20_109 VPWR VGND VPWR VGND sky130_fd_sc_hd__decap_3
XFILLER_13_172 VPWR VGND VPWR VGND sky130_fd_sc_hd__decap_3
XFILLER_13_161 VPWR VGND VPWR VGND sky130_fd_sc_hd__decap_3
XFILLER_9_143 VPWR VGND VPWR VGND sky130_fd_sc_hd__decap_3
XFILLER_9_187 VPWR VGND VPWR VGND sky130_fd_sc_hd__decap_3
XFILLER_3_51 VPWR VGND VPWR VGND sky130_fd_sc_hd__decap_3
XFILLER_3_84 VPWR VGND VPWR VGND sky130_fd_sc_hd__decap_3
XFILLER_22_38 VPWR VGND VPWR VGND sky130_fd_sc_hd__decap_3
XFILLER_3_308 VPWR VGND VPWR VGND sky130_fd_sc_hd__decap_3
XFILLER_0_9 VPWR VGND VPWR VGND sky130_fd_sc_hd__decap_3
XFILLER_6_124 VPWR VGND VPWR VGND sky130_fd_sc_hd__decap_3
XFILLER_8_18 VPWR VGND VPWR VGND sky130_fd_sc_hd__decap_3
XFILLER_8_29 VPWR VGND VPWR VGND sky130_fd_sc_hd__decap_3
XFILLER_10_153 VPWR VGND VPWR VGND sky130_fd_sc_hd__decap_3
XFILLER_10_186 VPWR VGND VPWR VGND sky130_fd_sc_hd__decap_3
XFILLER_2_330 VPWR VGND VPWR VGND sky130_fd_sc_hd__decap_3
XFILLER_6_168 VPWR VGND VPWR VGND sky130_fd_sc_hd__decap_3
XFILLER_10_197 VPWR VGND VPWR VGND sky130_fd_sc_hd__decap_3
XFILLER_12_71 VPWR VGND VPWR VGND sky130_fd_sc_hd__decap_3
XFILLER_18_242 VPWR VGND VPWR VGND sky130_fd_sc_hd__decap_3
XFILLER_18_286 VPWR VGND VPWR VGND sky130_fd_sc_hd__decap_3
XFILLER_18_253 VPWR VGND VPWR VGND sky130_fd_sc_hd__decap_3
XFILLER_5_190 VPWR VGND VPWR VGND sky130_fd_sc_hd__decap_3
XFILLER_17_27 VPWR VGND VPWR VGND sky130_fd_sc_hd__decap_3
XFILLER_3_105 VPWR VGND VPWR VGND sky130_fd_sc_hd__decap_3
XFILLER_3_116 VPWR VGND VPWR VGND sky130_fd_sc_hd__decap_3
XFILLER_3_149 VPWR VGND VPWR VGND sky130_fd_sc_hd__decap_3
XFILLER_15_267 VPWR VGND VPWR VGND sky130_fd_sc_hd__decap_3
XFILLER_15_234 VPWR VGND VPWR VGND sky130_fd_sc_hd__decap_3
XFILLER_23_70 VPWR VGND VPWR VGND sky130_fd_sc_hd__decap_3
XFILLER_2_171 VPWR VGND VPWR VGND sky130_fd_sc_hd__decap_3
XFILLER_0_41 VPWR VGND VPWR VGND sky130_fd_sc_hd__decap_3
XFILLER_0_74 VPWR VGND VPWR VGND sky130_fd_sc_hd__decap_3
XFILLER_0_85 VPWR VGND VPWR VGND sky130_fd_sc_hd__decap_3
XFILLER_21_237 VPWR VGND VPWR VGND sky130_fd_sc_hd__decap_3
XFILLER_9_72 VPWR VGND VPWR VGND sky130_fd_sc_hd__decap_3
XFILLER_0_119 VPWR VGND VPWR VGND sky130_fd_sc_hd__decap_3
XFILLER_12_215 VPWR VGND VPWR VGND sky130_fd_sc_hd__decap_3
XFILLER_20_292 VPWR VGND VPWR VGND sky130_fd_sc_hd__decap_3
XFILLER_12_248 VPWR VGND VPWR VGND sky130_fd_sc_hd__decap_3
XFILLER_12_259 VPWR VGND VPWR VGND sky130_fd_sc_hd__decap_3
XFILLER_7_252 VPWR VGND VPWR VGND sky130_fd_sc_hd__decap_3
XFILLER_7_296 VPWR VGND VPWR VGND sky130_fd_sc_hd__decap_3
XFILLER_11_270 VPWR VGND VPWR VGND sky130_fd_sc_hd__decap_3
XFILLER_11_281 VPWR VGND VPWR VGND sky130_fd_sc_hd__decap_3
XFILLER_17_329 VPWR VGND VPWR VGND sky130_fd_sc_hd__decap_3
XFILLER_4_200 VPWR VGND VPWR VGND sky130_fd_sc_hd__decap_3
XFILLER_4_233 VPWR VGND VPWR VGND sky130_fd_sc_hd__decap_3
XFILLER_20_71 VPWR VGND VPWR VGND sky130_fd_sc_hd__decap_3
XFILLER_4_277 VPWR VGND VPWR VGND sky130_fd_sc_hd__decap_3
XFILLER_6_62 VPWR VGND VPWR VGND sky130_fd_sc_hd__decap_3
XFILLER_22_321 VPWR VGND VPWR VGND sky130_fd_sc_hd__decap_3
XFILLER_1_258 VPWR VGND VPWR VGND sky130_fd_sc_hd__decap_3
XFILLER_1_225 VPWR VGND VPWR VGND sky130_fd_sc_hd__decap_3
XFILLER_1_214 VPWR VGND VPWR VGND sky130_fd_sc_hd__decap_3
XFILLER_9_6 VPWR VGND VPWR VGND sky130_fd_sc_hd__decap_3
XFILLER_17_137 VPWR VGND VPWR VGND sky130_fd_sc_hd__decap_3
XFILLER_15_93 VPWR VGND VPWR VGND sky130_fd_sc_hd__decap_3
XFILLER_15_60 VPWR VGND VPWR VGND sky130_fd_sc_hd__decap_3
XFILLER_13_332 VPWR VGND VPWR VGND sky130_fd_sc_hd__decap_3
XFILLER_9_314 VPWR VGND VPWR VGND sky130_fd_sc_hd__decap_3
XFILLER_23_118 VPWR VGND VPWR VGND sky130_fd_sc_hd__decap_3
XFILLER_16_192 VPWR VGND VPWR VGND sky130_fd_sc_hd__decap_3
XFILLER_11_18 VPWR VGND VPWR VGND sky130_fd_sc_hd__decap_3
XFILLER_14_118 VPWR VGND VPWR VGND sky130_fd_sc_hd__decap_3
XFILLER_22_162 VPWR VGND VPWR VGND sky130_fd_sc_hd__decap_3
XFILLER_10_324 VPWR VGND VPWR VGND sky130_fd_sc_hd__decap_3
XFILLER_7_3 VPWR VGND VPWR VGND sky130_fd_sc_hd__decap_3
XFILLER_13_140 VPWR VGND VPWR VGND sky130_fd_sc_hd__decap_3
XFILLER_13_184 VPWR VGND VPWR VGND sky130_fd_sc_hd__decap_3
XFILLER_9_122 VPWR VGND VPWR VGND sky130_fd_sc_hd__decap_3
XFILLER_9_155 VPWR VGND VPWR VGND sky130_fd_sc_hd__decap_3
XFILLER_9_199 VPWR VGND VPWR VGND sky130_fd_sc_hd__decap_3
XFILLER_3_63 VPWR VGND VPWR VGND sky130_fd_sc_hd__decap_3
XFILLER_3_30 VPWR VGND VPWR VGND sky130_fd_sc_hd__decap_3
XFILLER_3_96 VPWR VGND VPWR VGND sky130_fd_sc_hd__decap_3
XPHY_EDGE_ROW_5_Left_29 VPWR VGND VPWR VGND sky130_fd_sc_hd__decap_3
XFILLER_6_103 VPWR VGND VPWR VGND sky130_fd_sc_hd__decap_3
XFILLER_6_136 VPWR VGND VPWR VGND sky130_fd_sc_hd__decap_3
XFILLER_6_147 VPWR VGND VPWR VGND sky130_fd_sc_hd__decap_3
XFILLER_10_121 VPWR VGND VPWR VGND sky130_fd_sc_hd__decap_3
XFILLER_10_165 VPWR VGND VPWR VGND sky130_fd_sc_hd__decap_3
XFILLER_12_50 VPWR VGND VPWR VGND sky130_fd_sc_hd__decap_3
XFILLER_12_94 VPWR VGND VPWR VGND sky130_fd_sc_hd__decap_3
XFILLER_18_265 VPWR VGND VPWR VGND sky130_fd_sc_hd__decap_3
XFILLER_18_221 VPWR VGND VPWR VGND sky130_fd_sc_hd__decap_3
XFILLER_18_298 VPWR VGND VPWR VGND sky130_fd_sc_hd__decap_3
XFILLER_17_39 VPWR VGND VPWR VGND sky130_fd_sc_hd__decap_3
XFILLER_3_128 VPWR VGND VPWR VGND sky130_fd_sc_hd__decap_3
XFILLER_15_202 VPWR VGND VPWR VGND sky130_fd_sc_hd__decap_3
XFILLER_23_290 VPWR VGND VPWR VGND sky130_fd_sc_hd__decap_3
XFILLER_15_246 VPWR VGND VPWR VGND sky130_fd_sc_hd__decap_3
XFILLER_2_183 VPWR VGND VPWR VGND sky130_fd_sc_hd__decap_3
XFILLER_2_150 VPWR VGND VPWR VGND sky130_fd_sc_hd__decap_3
XFILLER_0_53 VPWR VGND VPWR VGND sky130_fd_sc_hd__decap_3
XFILLER_0_97 VPWR VGND VPWR VGND sky130_fd_sc_hd__decap_3
XFILLER_21_249 VPWR VGND VPWR VGND sky130_fd_sc_hd__decap_3
XFILLER_9_51 VPWR VGND VPWR VGND sky130_fd_sc_hd__decap_3
XFILLER_9_84 VPWR VGND VPWR VGND sky130_fd_sc_hd__decap_3
XFILLER_0_109 VPWR VGND VPWR VGND sky130_fd_sc_hd__decap_3
XFILLER_8_209 VPWR VGND VPWR VGND sky130_fd_sc_hd__decap_3
XFILLER_12_227 VPWR VGND VPWR VGND sky130_fd_sc_hd__decap_3
XFILLER_20_271 VPWR VGND VPWR VGND sky130_fd_sc_hd__decap_3
XPHY_EDGE_ROW_8_Left_32 VPWR VGND VPWR VGND sky130_fd_sc_hd__decap_3
XFILLER_18_71 VPWR VGND VPWR VGND sky130_fd_sc_hd__decap_3
XFILLER_7_220 VPWR VGND VPWR VGND sky130_fd_sc_hd__decap_3
XFILLER_7_231 VPWR VGND VPWR VGND sky130_fd_sc_hd__decap_3
XFILLER_11_293 VPWR VGND VPWR VGND sky130_fd_sc_hd__decap_3
XFILLER_7_264 VPWR VGND VPWR VGND sky130_fd_sc_hd__decap_3
XFILLER_22_3 VPWR VGND VPWR VGND sky130_fd_sc_hd__decap_3
XFILLER_14_29 VPWR VGND VPWR VGND sky130_fd_sc_hd__decap_3
XFILLER_14_18 VPWR VGND VPWR VGND sky130_fd_sc_hd__decap_3
XFILLER_17_308 VPWR VGND VPWR VGND sky130_fd_sc_hd__decap_3
XFILLER_20_94 VPWR VGND VPWR VGND sky130_fd_sc_hd__decap_3
XFILLER_20_50 VPWR VGND VPWR VGND sky130_fd_sc_hd__decap_3
XFILLER_4_212 VPWR VGND VPWR VGND sky130_fd_sc_hd__decap_3
XFILLER_4_245 VPWR VGND VPWR VGND sky130_fd_sc_hd__decap_3
XFILLER_4_256 VPWR VGND VPWR VGND sky130_fd_sc_hd__decap_3
XFILLER_4_289 VPWR VGND VPWR VGND sky130_fd_sc_hd__decap_3
XFILLER_16_330 VPWR VGND VPWR VGND sky130_fd_sc_hd__decap_3
XFILLER_6_41 VPWR VGND VPWR VGND sky130_fd_sc_hd__decap_3
XFILLER_6_74 VPWR VGND VPWR VGND sky130_fd_sc_hd__decap_3
XFILLER_6_85 VPWR VGND VPWR VGND sky130_fd_sc_hd__decap_3
XFILLER_19_190 VPWR VGND VPWR VGND sky130_fd_sc_hd__decap_3
XFILLER_1_237 VPWR VGND VPWR VGND sky130_fd_sc_hd__decap_3
XFILLER_17_149 VPWR VGND VPWR VGND sky130_fd_sc_hd__decap_3
XFILLER_17_116 VPWR VGND VPWR VGND sky130_fd_sc_hd__decap_3
XFILLER_17_105 VPWR VGND VPWR VGND sky130_fd_sc_hd__decap_3
XFILLER_13_311 VPWR VGND VPWR VGND sky130_fd_sc_hd__decap_3
XFILLER_15_72 VPWR VGND VPWR VGND sky130_fd_sc_hd__decap_3
XFILLER_9_326 VPWR VGND VPWR VGND sky130_fd_sc_hd__decap_3
XFILLER_0_281 VPWR VGND VPWR VGND sky130_fd_sc_hd__decap_3
XFILLER_16_171 VPWR VGND VPWR VGND sky130_fd_sc_hd__decap_3
XFILLER_22_174 VPWR VGND VPWR VGND sky130_fd_sc_hd__decap_3
XFILLER_22_141 VPWR VGND VPWR VGND sky130_fd_sc_hd__decap_3
XFILLER_22_130 VPWR VGND VPWR VGND sky130_fd_sc_hd__decap_3
XFILLER_6_318 VPWR VGND VPWR VGND sky130_fd_sc_hd__decap_3
XFILLER_13_152 VPWR VGND VPWR VGND sky130_fd_sc_hd__decap_3
XFILLER_9_134 VPWR VGND VPWR VGND sky130_fd_sc_hd__decap_3
XPHY_EDGE_ROW_21_Left_45 VPWR VGND VPWR VGND sky130_fd_sc_hd__decap_3
XFILLER_13_196 VPWR VGND VPWR VGND sky130_fd_sc_hd__decap_3
XFILLER_9_178 VPWR VGND VPWR VGND sky130_fd_sc_hd__decap_3
XFILLER_3_42 VPWR VGND VPWR VGND sky130_fd_sc_hd__decap_3
XFILLER_3_75 VPWR VGND VPWR VGND sky130_fd_sc_hd__decap_3
XFILLER_22_29 VPWR VGND VPWR VGND sky130_fd_sc_hd__decap_3
XFILLER_22_18 VPWR VGND VPWR VGND sky130_fd_sc_hd__decap_3
XFILLER_10_100 VPWR VGND VPWR VGND sky130_fd_sc_hd__decap_3
XFILLER_6_115 VPWR VGND VPWR VGND sky130_fd_sc_hd__decap_3
XFILLER_6_159 VPWR VGND VPWR VGND sky130_fd_sc_hd__decap_3
XFILLER_10_133 VPWR VGND VPWR VGND sky130_fd_sc_hd__decap_3
XFILLER_10_144 VPWR VGND VPWR VGND sky130_fd_sc_hd__decap_3
XFILLER_10_177 VPWR VGND VPWR VGND sky130_fd_sc_hd__decap_3
XFILLER_12_62 VPWR VGND VPWR VGND sky130_fd_sc_hd__decap_3
XFILLER_2_321 VPWR VGND VPWR VGND sky130_fd_sc_hd__decap_3
XFILLER_19_9 VPWR VGND VPWR VGND sky130_fd_sc_hd__decap_3
XFILLER_18_277 VPWR VGND VPWR VGND sky130_fd_sc_hd__decap_3
XFILLER_18_233 VPWR VGND VPWR VGND sky130_fd_sc_hd__decap_3
XFILLER_18_200 VPWR VGND VPWR VGND sky130_fd_sc_hd__decap_3
XFILLER_5_181 VPWR VGND VPWR VGND sky130_fd_sc_hd__decap_3
XFILLER_17_18 VPWR VGND VPWR VGND sky130_fd_sc_hd__decap_3
XFILLER_15_225 VPWR VGND VPWR VGND sky130_fd_sc_hd__decap_3
XFILLER_15_214 VPWR VGND VPWR VGND sky130_fd_sc_hd__decap_3
XFILLER_23_50 VPWR VGND VPWR VGND sky130_fd_sc_hd__decap_3
XFILLER_15_258 VPWR VGND VPWR VGND sky130_fd_sc_hd__decap_3
XFILLER_23_94 VPWR VGND VPWR VGND sky130_fd_sc_hd__decap_3
XFILLER_17_6 VPWR VGND VPWR VGND sky130_fd_sc_hd__decap_3
XFILLER_2_162 VPWR VGND VPWR VGND sky130_fd_sc_hd__decap_3
XFILLER_21_228 VPWR VGND VPWR VGND sky130_fd_sc_hd__decap_3
XFILLER_21_217 VPWR VGND VPWR VGND sky130_fd_sc_hd__decap_3
XFILLER_0_21 VPWR VGND VPWR VGND sky130_fd_sc_hd__decap_3
XFILLER_0_32 VPWR VGND VPWR VGND sky130_fd_sc_hd__decap_3
XFILLER_9_30 VPWR VGND VPWR VGND sky130_fd_sc_hd__decap_3
XFILLER_14_280 VPWR VGND VPWR VGND sky130_fd_sc_hd__decap_3
XFILLER_9_63 VPWR VGND VPWR VGND sky130_fd_sc_hd__decap_3
XFILLER_9_96 VPWR VGND VPWR VGND sky130_fd_sc_hd__decap_3
XFILLER_12_206 VPWR VGND VPWR VGND sky130_fd_sc_hd__decap_3
XFILLER_12_239 VPWR VGND VPWR VGND sky130_fd_sc_hd__decap_3
XFILLER_20_283 VPWR VGND VPWR VGND sky130_fd_sc_hd__decap_3
XFILLER_18_94 VPWR VGND VPWR VGND sky130_fd_sc_hd__decap_3
XFILLER_18_50 VPWR VGND VPWR VGND sky130_fd_sc_hd__decap_3
XFILLER_7_243 VPWR VGND VPWR VGND sky130_fd_sc_hd__decap_3
XFILLER_11_261 VPWR VGND VPWR VGND sky130_fd_sc_hd__decap_3
XFILLER_7_276 VPWR VGND VPWR VGND sky130_fd_sc_hd__decap_3
XFILLER_7_287 VPWR VGND VPWR VGND sky130_fd_sc_hd__decap_3
XFILLER_15_3 VPWR VGND VPWR VGND sky130_fd_sc_hd__decap_3
XFILLER_20_62 VPWR VGND VPWR VGND sky130_fd_sc_hd__decap_3
XFILLER_4_224 VPWR VGND VPWR VGND sky130_fd_sc_hd__decap_3
XFILLER_4_268 VPWR VGND VPWR VGND sky130_fd_sc_hd__decap_3
XFILLER_6_53 VPWR VGND VPWR VGND sky130_fd_sc_hd__decap_3
XFILLER_3_290 VPWR VGND VPWR VGND sky130_fd_sc_hd__decap_3
XFILLER_6_97 VPWR VGND VPWR VGND sky130_fd_sc_hd__decap_3
XFILLER_22_312 VPWR VGND VPWR VGND sky130_fd_sc_hd__decap_3
XFILLER_1_249 VPWR VGND VPWR VGND sky130_fd_sc_hd__decap_3
XFILLER_1_205 VPWR VGND VPWR VGND sky130_fd_sc_hd__decap_3
XFILLER_17_128 VPWR VGND VPWR VGND sky130_fd_sc_hd__decap_3
XFILLER_15_84 VPWR VGND VPWR VGND sky130_fd_sc_hd__decap_3
XFILLER_15_51 VPWR VGND VPWR VGND sky130_fd_sc_hd__decap_3
XFILLER_13_323 VPWR VGND VPWR VGND sky130_fd_sc_hd__decap_3
XFILLER_9_305 VPWR VGND VPWR VGND sky130_fd_sc_hd__decap_3
XFILLER_0_271 VPWR VGND VPWR VGND sky130_fd_sc_hd__decap_3
XFILLER_16_150 VPWR VGND VPWR VGND sky130_fd_sc_hd__decap_3
XFILLER_0_293 VPWR VGND VPWR VGND sky130_fd_sc_hd__decap_3
XFILLER_16_183 VPWR VGND VPWR VGND sky130_fd_sc_hd__decap_3
XFILLER_14_109 VPWR VGND VPWR VGND sky130_fd_sc_hd__decap_3
XFILLER_22_186 VPWR VGND VPWR VGND sky130_fd_sc_hd__decap_3
XFILLER_22_153 VPWR VGND VPWR VGND sky130_fd_sc_hd__decap_3
XFILLER_10_304 VPWR VGND VPWR VGND sky130_fd_sc_hd__decap_3
XFILLER_10_315 VPWR VGND VPWR VGND sky130_fd_sc_hd__decap_3
XFILLER_13_175 VPWR VGND VPWR VGND sky130_fd_sc_hd__decap_3
XFILLER_13_164 VPWR VGND VPWR VGND sky130_fd_sc_hd__decap_3
XFILLER_13_131 VPWR VGND VPWR VGND sky130_fd_sc_hd__decap_3
XFILLER_9_102 VPWR VGND VPWR VGND sky130_fd_sc_hd__decap_3
XFILLER_9_113 VPWR VGND VPWR VGND sky130_fd_sc_hd__decap_3
XFILLER_9_146 VPWR VGND VPWR VGND sky130_fd_sc_hd__decap_3
XFILLER_3_21 VPWR VGND VPWR VGND sky130_fd_sc_hd__decap_3
XFILLER_3_87 VPWR VGND VPWR VGND sky130_fd_sc_hd__decap_3
XFILLER_10_112 VPWR VGND VPWR VGND sky130_fd_sc_hd__decap_3
XFILLER_6_127 VPWR VGND VPWR VGND sky130_fd_sc_hd__decap_3
XFILLER_10_156 VPWR VGND VPWR VGND sky130_fd_sc_hd__decap_3
XFILLER_10_189 VPWR VGND VPWR VGND sky130_fd_sc_hd__decap_3
XFILLER_12_41 VPWR VGND VPWR VGND sky130_fd_sc_hd__decap_3
XFILLER_12_74 VPWR VGND VPWR VGND sky130_fd_sc_hd__decap_3
XFILLER_12_85 VPWR VGND VPWR VGND sky130_fd_sc_hd__decap_3
XFILLER_18_289 VPWR VGND VPWR VGND sky130_fd_sc_hd__decap_3
XFILLER_18_256 VPWR VGND VPWR VGND sky130_fd_sc_hd__decap_3
XFILLER_18_245 VPWR VGND VPWR VGND sky130_fd_sc_hd__decap_3
XFILLER_18_212 VPWR VGND VPWR VGND sky130_fd_sc_hd__decap_3
XPHY_EDGE_ROW_16_Right_16 VPWR VGND VPWR VGND sky130_fd_sc_hd__decap_3
XFILLER_5_193 VPWR VGND VPWR VGND sky130_fd_sc_hd__decap_3
XFILLER_3_108 VPWR VGND VPWR VGND sky130_fd_sc_hd__decap_3
XFILLER_3_119 VPWR VGND VPWR VGND sky130_fd_sc_hd__decap_3
XFILLER_15_237 VPWR VGND VPWR VGND sky130_fd_sc_hd__decap_3
XFILLER_23_281 VPWR VGND VPWR VGND sky130_fd_sc_hd__decap_3
XFILLER_2_174 VPWR VGND VPWR VGND sky130_fd_sc_hd__decap_3
XFILLER_2_141 VPWR VGND VPWR VGND sky130_fd_sc_hd__decap_3
XFILLER_2_130 VPWR VGND VPWR VGND sky130_fd_sc_hd__decap_3
XFILLER_0_44 VPWR VGND VPWR VGND sky130_fd_sc_hd__decap_3
XFILLER_14_292 VPWR VGND VPWR VGND sky130_fd_sc_hd__decap_3
XFILLER_0_77 VPWR VGND VPWR VGND sky130_fd_sc_hd__decap_3
XFILLER_0_88 VPWR VGND VPWR VGND sky130_fd_sc_hd__decap_3
XFILLER_9_42 VPWR VGND VPWR VGND sky130_fd_sc_hd__decap_3
XFILLER_9_75 VPWR VGND VPWR VGND sky130_fd_sc_hd__decap_3
XFILLER_20_262 VPWR VGND VPWR VGND sky130_fd_sc_hd__decap_3
XFILLER_12_218 VPWR VGND VPWR VGND sky130_fd_sc_hd__decap_3
XFILLER_20_295 VPWR VGND VPWR VGND sky130_fd_sc_hd__decap_3
XFILLER_18_62 VPWR VGND VPWR VGND sky130_fd_sc_hd__decap_3
XFILLER_7_211 VPWR VGND VPWR VGND sky130_fd_sc_hd__decap_3
XFILLER_7_255 VPWR VGND VPWR VGND sky130_fd_sc_hd__decap_3
XFILLER_7_299 VPWR VGND VPWR VGND sky130_fd_sc_hd__decap_3
XFILLER_11_240 VPWR VGND VPWR VGND sky130_fd_sc_hd__decap_3
XFILLER_11_273 VPWR VGND VPWR VGND sky130_fd_sc_hd__decap_3
XFILLER_11_284 VPWR VGND VPWR VGND sky130_fd_sc_hd__decap_3
XPHY_EDGE_ROW_2_Right_2 VPWR VGND VPWR VGND sky130_fd_sc_hd__decap_3
XFILLER_4_203 VPWR VGND VPWR VGND sky130_fd_sc_hd__decap_3
XFILLER_20_85 VPWR VGND VPWR VGND sky130_fd_sc_hd__decap_3
XFILLER_20_74 VPWR VGND VPWR VGND sky130_fd_sc_hd__decap_3
XFILLER_20_41 VPWR VGND VPWR VGND sky130_fd_sc_hd__decap_3
XFILLER_4_236 VPWR VGND VPWR VGND sky130_fd_sc_hd__decap_3
XFILLER_16_321 VPWR VGND VPWR VGND sky130_fd_sc_hd__decap_3
XFILLER_6_21 VPWR VGND VPWR VGND sky130_fd_sc_hd__decap_3
XFILLER_6_32 VPWR VGND VPWR VGND sky130_fd_sc_hd__decap_3
XFILLER_6_65 VPWR VGND VPWR VGND sky130_fd_sc_hd__decap_3
XFILLER_22_324 VPWR VGND VPWR VGND sky130_fd_sc_hd__decap_3
XFILLER_19_181 VPWR VGND VPWR VGND sky130_fd_sc_hd__decap_3
XFILLER_1_228 VPWR VGND VPWR VGND sky130_fd_sc_hd__decap_3
XFILLER_1_217 VPWR VGND VPWR VGND sky130_fd_sc_hd__decap_3
XFILLER_9_9 VPWR VGND VPWR VGND sky130_fd_sc_hd__decap_3
XFILLER_15_96 VPWR VGND VPWR VGND sky130_fd_sc_hd__decap_3
XFILLER_15_63 VPWR VGND VPWR VGND sky130_fd_sc_hd__decap_3
XFILLER_15_30 VPWR VGND VPWR VGND sky130_fd_sc_hd__decap_3
XFILLER_13_302 VPWR VGND VPWR VGND sky130_fd_sc_hd__decap_3
XFILLER_9_317 VPWR VGND VPWR VGND sky130_fd_sc_hd__decap_3
XFILLER_16_162 VPWR VGND VPWR VGND sky130_fd_sc_hd__decap_3
XFILLER_22_165 VPWR VGND VPWR VGND sky130_fd_sc_hd__decap_3
XFILLER_22_121 VPWR VGND VPWR VGND sky130_fd_sc_hd__decap_3
XFILLER_6_309 VPWR VGND VPWR VGND sky130_fd_sc_hd__decap_3
XFILLER_10_327 VPWR VGND VPWR VGND sky130_fd_sc_hd__decap_3
XFILLER_7_6 VPWR VGND VPWR VGND sky130_fd_sc_hd__decap_3
XFILLER_13_187 VPWR VGND VPWR VGND sky130_fd_sc_hd__decap_3
XFILLER_13_143 VPWR VGND VPWR VGND sky130_fd_sc_hd__decap_3
XFILLER_9_125 VPWR VGND VPWR VGND sky130_fd_sc_hd__decap_3
XFILLER_9_158 VPWR VGND VPWR VGND sky130_fd_sc_hd__decap_3
XFILLER_9_169 VPWR VGND VPWR VGND sky130_fd_sc_hd__decap_3
XFILLER_5_320 VPWR VGND VPWR VGND sky130_fd_sc_hd__decap_3
XFILLER_3_66 VPWR VGND VPWR VGND sky130_fd_sc_hd__decap_3
XFILLER_3_33 VPWR VGND VPWR VGND sky130_fd_sc_hd__decap_3
XFILLER_3_99 VPWR VGND VPWR VGND sky130_fd_sc_hd__decap_3
XFILLER_8_180 VPWR VGND VPWR VGND sky130_fd_sc_hd__decap_3
XFILLER_6_106 VPWR VGND VPWR VGND sky130_fd_sc_hd__decap_3
XFILLER_10_124 VPWR VGND VPWR VGND sky130_fd_sc_hd__decap_3
XFILLER_10_168 VPWR VGND VPWR VGND sky130_fd_sc_hd__decap_3
XFILLER_2_312 VPWR VGND VPWR VGND sky130_fd_sc_hd__decap_3
XFILLER_2_301 VPWR VGND VPWR VGND sky130_fd_sc_hd__decap_3
XFILLER_5_3 VPWR VGND VPWR VGND sky130_fd_sc_hd__decap_3
XFILLER_12_53 VPWR VGND VPWR VGND sky130_fd_sc_hd__decap_3
XFILLER_12_97 VPWR VGND VPWR VGND sky130_fd_sc_hd__decap_3
XFILLER_18_224 VPWR VGND VPWR VGND sky130_fd_sc_hd__decap_3
XFILLER_18_268 VPWR VGND VPWR VGND sky130_fd_sc_hd__decap_3
XFILLER_5_161 VPWR VGND VPWR VGND sky130_fd_sc_hd__decap_3
XFILLER_5_172 VPWR VGND VPWR VGND sky130_fd_sc_hd__decap_3
XFILLER_17_290 VPWR VGND VPWR VGND sky130_fd_sc_hd__decap_3
XFILLER_15_249 VPWR VGND VPWR VGND sky130_fd_sc_hd__decap_3
XFILLER_15_205 VPWR VGND VPWR VGND sky130_fd_sc_hd__decap_3
XFILLER_23_271 VPWR VGND VPWR VGND sky130_fd_sc_hd__decap_3
XFILLER_23_41 VPWR VGND VPWR VGND sky130_fd_sc_hd__decap_3
XFILLER_2_197 VPWR VGND VPWR VGND sky130_fd_sc_hd__decap_3
XFILLER_2_186 VPWR VGND VPWR VGND sky130_fd_sc_hd__decap_3
XFILLER_2_153 VPWR VGND VPWR VGND sky130_fd_sc_hd__decap_3
XFILLER_0_12 VPWR VGND VPWR VGND sky130_fd_sc_hd__decap_3
XFILLER_14_271 VPWR VGND VPWR VGND sky130_fd_sc_hd__decap_3
XFILLER_9_21 VPWR VGND VPWR VGND sky130_fd_sc_hd__decap_3
XFILLER_9_87 VPWR VGND VPWR VGND sky130_fd_sc_hd__decap_3
XFILLER_20_274 VPWR VGND VPWR VGND sky130_fd_sc_hd__decap_3
XFILLER_20_230 VPWR VGND VPWR VGND sky130_fd_sc_hd__decap_3
XFILLER_18_85 VPWR VGND VPWR VGND sky130_fd_sc_hd__decap_3
XFILLER_18_74 VPWR VGND VPWR VGND sky130_fd_sc_hd__decap_3
XFILLER_18_41 VPWR VGND VPWR VGND sky130_fd_sc_hd__decap_3
XFILLER_7_234 VPWR VGND VPWR VGND sky130_fd_sc_hd__decap_3
XFILLER_7_267 VPWR VGND VPWR VGND sky130_fd_sc_hd__decap_3
XFILLER_11_252 VPWR VGND VPWR VGND sky130_fd_sc_hd__decap_3
XFILLER_11_296 VPWR VGND VPWR VGND sky130_fd_sc_hd__decap_3
XFILLER_22_6 VPWR VGND VPWR VGND sky130_fd_sc_hd__decap_3
XFILLER_4_215 VPWR VGND VPWR VGND sky130_fd_sc_hd__decap_3
XFILLER_4_248 VPWR VGND VPWR VGND sky130_fd_sc_hd__decap_3
XFILLER_20_97 VPWR VGND VPWR VGND sky130_fd_sc_hd__decap_3
XFILLER_20_53 VPWR VGND VPWR VGND sky130_fd_sc_hd__decap_3
XFILLER_4_259 VPWR VGND VPWR VGND sky130_fd_sc_hd__decap_3
XFILLER_3_270 VPWR VGND VPWR VGND sky130_fd_sc_hd__decap_3
XFILLER_3_281 VPWR VGND VPWR VGND sky130_fd_sc_hd__decap_3
XFILLER_6_44 VPWR VGND VPWR VGND sky130_fd_sc_hd__decap_3
XFILLER_6_77 VPWR VGND VPWR VGND sky130_fd_sc_hd__decap_3
XFILLER_6_88 VPWR VGND VPWR VGND sky130_fd_sc_hd__decap_3
XFILLER_20_3 VPWR VGND VPWR VGND sky130_fd_sc_hd__decap_3
XFILLER_19_193 VPWR VGND VPWR VGND sky130_fd_sc_hd__decap_3
XFILLER_17_119 VPWR VGND VPWR VGND sky130_fd_sc_hd__decap_3
XFILLER_17_108 VPWR VGND VPWR VGND sky130_fd_sc_hd__decap_3
XFILLER_15_75 VPWR VGND VPWR VGND sky130_fd_sc_hd__decap_3
XFILLER_15_42 VPWR VGND VPWR VGND sky130_fd_sc_hd__decap_3
XFILLER_13_314 VPWR VGND VPWR VGND sky130_fd_sc_hd__decap_3
XFILLER_9_329 VPWR VGND VPWR VGND sky130_fd_sc_hd__decap_3
XFILLER_0_284 VPWR VGND VPWR VGND sky130_fd_sc_hd__decap_3
XFILLER_0_262 VPWR VGND VPWR VGND sky130_fd_sc_hd__decap_3
XFILLER_0_240 VPWR VGND VPWR VGND sky130_fd_sc_hd__decap_3
XFILLER_16_174 VPWR VGND VPWR VGND sky130_fd_sc_hd__decap_3
XFILLER_16_141 VPWR VGND VPWR VGND sky130_fd_sc_hd__decap_3
XFILLER_16_130 VPWR VGND VPWR VGND sky130_fd_sc_hd__decap_3
C0 _00_/D clkbuf_1_1__f_clk/a_110_47# 0
C1 VGND misfit01_core_7/HI 0.11835f
C2 misfit01_core_20/HI uo_out[6] 0.01021f
C3 ui_in[7] input2/X 0
C4 uo_out[3] misfit01_core_18/HI 0.00529f
C5 uo_out[1] misfit01_core_18/HI 0
C6 _00_/a_543_47# clkbuf_0_clk/X 0.00735f
C7 ui_in[7] VPWR 0.00222f
C8 ui_in[6] VGND 0.00241f
C9 VPWR uio_oe[6] 0.2448f
C10 VGND misfit01_core_15/HI 0.06837f
C11 _25_/a_27_47# uo_out[1] 0.01303f
C12 _01_/a_1108_47# _24_/A 0
C13 VGND misfit01_core_11/HI 0.00587f
C14 _00_/a_1283_21# inv_a 0.00786f
C15 uio_in[1] clkbuf_1_1__f_clk/a_110_47# 0.0013f
C16 VPWR uio_oe[5] 0.2448f
C17 uio_out[0] VPWR 0.22577f
C18 VPWR _01_/a_1270_413# 0
C19 _25_/A _01_/a_543_47# 0.00691f
C20 VGND _24_/A 0.35092f
C21 VGND uio_out[5] 0.16545f
C22 VPWR misfit01_core_13/HI 0.03766f
C23 misfit01_core_16/HI VPWR 0.03316f
C24 uo_out[2] VGND 0.12996f
C25 VGND misfit01_core_23/HI 0.11931f
C26 _00_/a_651_413# clkbuf_0_clk/a_110_47# 0.00186f
C27 VGND input3/a_244_47# 0.01346f
C28 VPWR input3/a_27_47# 0.04583f
C29 uio_in[3] clkbuf_0_clk/X 0.00159f
C30 VPWR uio_oe[0] 0.23543f
C31 _00_/CLK clk 0.01795f
C32 inv_y VGND 0.15607f
C33 clkbuf_1_1__f_clk/a_110_47# input2/X 0
C34 rst_n input3/a_27_47# 0.00219f
C35 input1/a_244_47# inv_y 0.00707f
C36 ui_in[6] _00_/D 0
C37 uo_out[6] uo_out[5] 0.14639f
C38 VPWR clkbuf_1_1__f_clk/a_110_47# 0.02351f
C39 _01_/a_1283_21# clkbuf_0_clk/X 0.00541f
C40 _00_/a_1283_21# _25_/a_27_47# 0.00621f
C41 uo_out[1] clkbuf_0_clk/X 0.0019f
C42 uo_out[0] _01_/a_543_47# 0.00106f
C43 uio_in[2] clk 0.00114f
C44 inv_a _01_/a_1108_47# 0.00638f
C45 _00_/a_1108_47# _24_/A 0.00407f
C46 uo_out[0] misfit01_core_17/HI 0
C47 misfit01_core_21/HI uo_out[7] 0.01021f
C48 _24_/a_27_47# misfit01_core_16/HI 0
C49 uio_in[0] ui_in[7] 0.03102f
C50 _00_/D _24_/A 0.00248f
C51 _00_/a_1270_413# VPWR 0
C52 _00_/a_639_47# VGND 0.00365f
C53 VPWR uio_out[6] 0.21549f
C54 _00_/a_543_47# _25_/A 0
C55 _00_/D input3/a_244_47# 0.0022f
C56 misfit01_core_6/HI uio_oe[6] 0.01021f
C57 inv_a VGND 3.84328f
C58 inv_a input1/a_244_47# 0
C59 misfit01_core_6/HI uio_oe[5] 0.00529f
C60 VPWR misfit01_core_7/HI 0.03288f
C61 VGND uio_oe[7] 0.12176f
C62 ui_in[6] input2/X 0
C63 clk VGND 2.4131f
C64 misfit01_core_5/HI uio_oe[5] 0.01021f
C65 uo_out[3] uo_out[4] 0.14639f
C66 misfit01_core_8/HI uio_out[0] 0.01021f
C67 _00_/a_27_47# _00_/a_543_47# -0.00802f
C68 uo_out[1] uo_out[4] 0
C69 ui_in[5] VGND 0.00241f
C70 ui_in[6] VPWR 0.00235f
C71 uo_out[1] _01_/a_27_47# 0.00245f
C72 VGND misfit01_core_18/HI 0.11925f
C73 _00_/CLK clkbuf_0_clk/X 0.43758f
C74 VGND uio_out[7] 0.10514f
C75 VPWR misfit01_core_15/HI 0.02592f
C76 _01_/a_448_47# _24_/A 0
C77 VGND uio_out[3] 0.16526f
C78 VPWR misfit01_core_11/HI 0.00315f
C79 _00_/a_1108_47# inv_a 0.0015f
C80 uio_in[0] clkbuf_1_1__f_clk/a_110_47# 0
C81 input2/X _24_/A 0.11694f
C82 VPWR _01_/a_639_47# 0
C83 _25_/a_27_47# VGND 0.02476f
C84 _00_/D inv_a 0
C85 _25_/A _01_/a_1283_21# 0
C86 input3/a_244_47# input2/X 0
C87 VPWR _24_/A 0.32106f
C88 VPWR uio_out[5] 0.29916f
C89 uo_out[2] VPWR 0.22628f
C90 VPWR misfit01_core_23/HI 0.03303f
C91 VGND uio_oe[1] 0.1122f
C92 _25_/A uo_out[1] 0.05379f
C93 VGND input3/a_355_47# 0.01714f
C94 VPWR input3/a_244_47# 0.00801f
C95 misfit01_core_22/HI uio_oe[0] 0.01021f
C96 _00_/D clk 0
C97 inv_y VPWR 0.07372f
C98 rst_n input3/a_244_47# 0.00471f
C99 input1/a_27_47# _25_/A 0
C100 input1/a_355_47# inv_y 0.00349f
C101 ui_in[5] _00_/D 0
C102 _00_/a_1283_21# _01_/a_27_47# 0.00384f
C103 _00_/a_27_47# _01_/a_1283_21# 0.00384f
C104 _01_/a_1108_47# clkbuf_0_clk/X 0.00186f
C105 _00_/a_1108_47# _25_/a_27_47# 0
C106 _00_/a_27_47# uo_out[1] 0
C107 misfit01_core_16/HI clkbuf_1_0__f_clk/a_110_47# 0
C108 uio_in[1] clk 0.00114f
C109 uio_in[5] uio_in[4] 0.03102f
C110 uo_out[0] uo_out[3] 0
C111 inv_a _01_/a_448_47# 0.00476f
C112 _00_/a_448_47# _24_/A 0.0043f
C113 _00_/a_639_47# input2/X 0.00308f
C114 uo_out[1] uo_out[0] 0.10224f
C115 _24_/a_27_47# uo_out[2] 0
C116 _24_/a_27_47# _24_/A 0.01571f
C117 VGND clkbuf_0_clk/X 1.77414f
C118 VGND misfit01_core_10/HI 0.00571f
C119 inv_a input2/X 0.05136f
C120 _00_/a_639_47# VPWR 0
C121 _00_/a_805_47# VGND 0
C122 _00_/a_1283_21# _25_/A 0.00298f
C123 ui_in[2] ui_in[1] 0.03102f
C124 _00_/D input3/a_355_47# 0.00226f
C125 inv_a VPWR 3.19557f
C126 inv_a input1/a_355_47# 0
C127 uio_oe[6] uio_oe[5] 0.14639f
C128 clk input2/X 0
C129 clkbuf_0_clk/a_110_47# _24_/A 0.11589f
C130 VPWR uio_oe[7] 0.17528f
C131 ui_in[5] input2/X 0
C132 clk VPWR 0.03145f
C133 uio_in[7] VGND 0.00105f
C134 clk rst_n 0.10061f
C135 ui_in[4] VGND 0.00241f
C136 ui_in[5] VPWR 0.00235f
C137 uo_out[1] _01_/a_193_47# 0.00322f
C138 ui_in[1] ui_in[0] 0.03102f
C139 VGND misfit01_core_12/HI 0.129f
C140 _00_/a_27_47# _00_/CLK 0.01278f
C141 VPWR misfit01_core_18/HI 0.03305f
C142 VGND uo_out[4] 0.12759f
C143 _00_/D clkbuf_0_clk/X 0.03915f
C144 _00_/a_1283_21# uo_out[0] 0.00483f
C145 VPWR uio_out[7] 0.23431f
C146 _01_/a_805_47# input2/X 0
C147 _25_/a_27_47# input2/X 0
C148 misfit01_core_14/HI uio_out[6] 0.01022f
C149 VPWR uio_out[3] 0.23085f
C150 VGND _01_/a_27_47# 0.04606f
C151 _00_/a_448_47# inv_a 0
C152 _00_/CLK uo_out[0] 0
C153 VPWR _01_/a_805_47# 0
C154 _25_/a_27_47# VPWR 0.04958f
C155 _25_/A _01_/a_1108_47# 0
C156 input3/a_355_47# input2/X 0
C157 VPWR uio_oe[1] 0.23428f
C158 uio_out[5] misfit01_core_22/HI 0
C159 VPWR input3/a_355_47# 0.00914f
C160 uio_out[1] uio_out[2] 0.15169f
C161 _25_/A VGND 11.21056f
C162 rst_n input3/a_355_47# 0.01248f
C163 input2/a_244_47# input2/a_355_47# -0
C164 input1/a_244_47# _25_/A 0.00104f
C165 uio_oe[1] misfit01_core_24/HI 0.00529f
C166 ui_in[4] _00_/D 0
C167 _00_/a_193_47# _01_/a_1283_21# 0.00213f
C168 _00_/a_27_47# _01_/a_1108_47# 0
C169 _00_/a_1283_21# _01_/a_193_47# 0.00213f
C170 _00_/a_1108_47# _01_/a_27_47# 0
C171 misfit01_core_14/HI misfit01_core_15/HI 0.00112f
C172 _01_/a_448_47# clkbuf_0_clk/X 0
C173 clkbuf_0_clk/a_110_47# clk 0.01353f
C174 uo_out[3] _01_/CLK 0
C175 _00_/a_193_47# uo_out[1] 0
C176 input2/X clkbuf_0_clk/X 0.03913f
C177 uo_out[2] clkbuf_1_0__f_clk/a_110_47# 0
C178 uio_in[0] clk 0.00114f
C179 uio_oe[6] misfit01_core_7/HI 0.00529f
C180 inv_a _01_/a_651_413# 0.00761f
C181 _00_/a_651_413# _24_/A 0.00775f
C182 _00_/a_805_47# input2/X 0.00115f
C183 _00_/a_27_47# VGND -0.06066f
C184 VPWR clkbuf_0_clk/X 1.37306f
C185 misfit01_core_13/HI uio_out[6] 0
C186 uio_out[5] misfit01_core_14/HI 0.00396f
C187 VGND uio_out[2] 0.0969f
C188 VPWR misfit01_core_10/HI 0.00284f
C189 ui_in[7] ui_in[6] 0.03102f
C190 _00_/a_805_47# VPWR 0
C191 uo_out[0] VGND 0.13709f
C192 _00_/a_1108_47# _25_/A 0.00228f
C193 uio_out[4] uio_out[1] 0
C194 uo_out[4] misfit01_core_19/HI 0.00529f
C195 ui_in[4] input2/X 0
C196 uio_in[7] VPWR 0.01434f
C197 uio_in[6] VGND 0.01695f
C198 _00_/a_448_47# clkbuf_0_clk/X 0.00793f
C199 ui_in[4] VPWR 0.00235f
C200 ui_in[3] VGND 0.00241f
C201 _01_/a_27_47# input2/X 0
C202 _24_/a_27_47# clkbuf_0_clk/X 0.03223f
C203 VGND uio_out[4] 0.45207f
C204 VPWR misfit01_core_12/HI 0.03305f
C205 _00_/a_27_47# _00_/D 0.15786f
C206 _00_/a_193_47# _00_/CLK 0.0042f
C207 inv_a clkbuf_1_0__f_clk/a_110_47# 0.00522f
C208 VPWR uo_out[4] 0.22522f
C209 _00_/a_1108_47# uo_out[0] 0.00427f
C210 _01_/a_1217_47# input2/X 0
C211 uio_out[7] misfit01_core_22/HI 0.00529f
C212 VPWR _01_/a_27_47# 0.10324f
C213 VGND _01_/a_193_47# 0.00611f
C214 VGND _01_/a_1462_47# 0
C215 misfit01_core_13/HI uio_out[5] 0.0116f
C216 misfit01_core_16/HI _24_/A 0
C217 VPWR _01_/a_1217_47# 0.001f
C218 misfit01_core_16/HI uo_out[2] 0.01021f
C219 _25_/A _01_/a_448_47# 0.01067f
C220 clkbuf_0_clk/a_110_47# clkbuf_0_clk/X 0.24429f
C221 uio_out[5] uio_oe[0] 0
C222 misfit01_core_23/HI uio_oe[0] 0.00529f
C223 _25_/A input2/X 0.00604f
C224 VGND input2/a_27_47# 0.06293f
C225 _25_/A VPWR 5.01153f
C226 uio_in[5] _00_/CLK 0
C227 input1/a_355_47# _25_/A 0.00119f
C228 uio_oe[1] uio_oe[2] 0.14639f
C229 ui_in[3] _00_/D 0
C230 VGND misfit01_core_21/HI 0.11926f
C231 _00_/a_193_47# _01_/a_1108_47# 0
C232 _00_/a_1108_47# _01_/a_193_47# 0
C233 _00_/a_761_289# _01_/a_1283_21# 0.0031f
C234 _00_/a_1283_21# _01_/a_761_289# 0.0031f
C235 _01_/a_651_413# clkbuf_0_clk/X 0
C236 uio_out[6] misfit01_core_15/HI 0.01429f
C237 _25_/a_27_47# clkbuf_1_0__f_clk/a_110_47# 0
C238 _24_/a_27_47# _01_/a_27_47# 0
C239 misfit01_core_14/HI uio_out[3] 0
C240 uio_in[7] clkbuf_0_clk/a_110_47# 0
C241 _00_/a_761_289# uo_out[1] 0
C242 _00_/a_27_47# input2/X 0.30901f
C243 ui_in[7] clk 0.00114f
C244 uio_oe[6] uio_oe[7] 0.14639f
C245 uio_in[4] uio_in[3] 0.03102f
C246 inv_a _01_/a_1270_413# 0
C247 _00_/a_1270_413# _24_/A 0
C248 _00_/a_1217_47# input2/X 0
C249 _00_/a_27_47# VPWR 0.09512f
C250 _00_/a_193_47# VGND 0.03032f
C251 VGND _01_/CLK 0.1395f
C252 uo_out[0] input2/X 0.00191f
C253 uio_out[5] uio_out[6] 0.07467f
C254 VPWR uio_out[2] 0.18346f
C255 _00_/a_1217_47# VPWR 0.001f
C256 uo_out[0] VPWR 0.10033f
C257 _00_/D input2/a_27_47# 0.00246f
C258 uo_out[4] uo_out[5] 0.14639f
C259 clk input3/a_27_47# 0
C260 ui_in[3] input2/X 0
C261 uio_in[5] VGND 0.00233f
C262 clkbuf_1_0__f_clk/a_110_47# clkbuf_0_clk/X 0.00474f
C263 _00_/a_27_47# _00_/a_448_47# -0.00676f
C264 _00_/a_651_413# clkbuf_0_clk/X 0.00128f
C265 ui_in[2] VGND 0.00273f
C266 ui_in[3] VPWR 0.00235f
C267 uio_out[5] misfit01_core_15/HI 0
C268 _01_/a_193_47# input2/X 0.00524f
C269 VPWR uio_out[4] 0.32244f
C270 misfit01_core_13/HI uio_out[3] 0
C271 clk clkbuf_1_1__f_clk/a_110_47# 0.00605f
C272 misfit01_core_17/HI uo_out[3] 0.01021f
C273 _00_/a_761_289# _00_/CLK 0
C274 _00_/a_193_47# _00_/D 0.10963f
C275 uo_out[1] misfit01_core_17/HI 0
C276 _01_/a_639_47# _24_/A 0
C277 _01_/a_1462_47# input2/X 0
C278 uio_out[7] uio_oe[0] 0.14639f
C279 VGND _01_/a_761_289# 0.01482f
C280 _24_/a_27_47# uo_out[0] 0.01226f
C281 VPWR _01_/a_193_47# 0.04462f
C282 uo_out[2] _24_/A 0.00167f
C283 VPWR _01_/a_1462_47# 0.00112f
C284 _25_/A _01_/a_651_413# 0.00128f
C285 _00_/a_27_47# clkbuf_0_clk/a_110_47# 0.02154f
C286 input2/a_27_47# input2/X 0
C287 uio_oe[1] uio_oe[0] 0.14639f
C288 VGND ui_in[0] 0.40741f
C289 clkbuf_0_clk/a_110_47# uo_out[0] 0.00601f
C290 VGND input2/a_244_47# 0.01294f
C291 VPWR input2/a_27_47# 0.09876f
C292 uio_in[4] _00_/CLK 0
C293 uio_in[5] _00_/D 0
C294 input2/a_27_47# rst_n 0.03914f
C295 ui_in[2] _00_/D 0
C296 _01_/a_27_47# clkbuf_1_0__f_clk/a_110_47# 0.00206f
C297 VPWR misfit01_core_21/HI 0.03303f
C298 VGND uo_out[7] 0.12674f
C299 misfit01_core_7/HI uio_oe[7] 0.01022f
C300 _00_/a_761_289# _01_/a_1108_47# 0.00156f
C301 _00_/a_1108_47# _01_/a_761_289# 0.00156f
C302 _00_/a_1283_21# _01_/a_543_47# 0.00231f
C303 _00_/a_543_47# _01_/a_1283_21# 0.00231f
C304 uio_out[6] uio_out[7] 0.14639f
C305 _01_/a_1270_413# clkbuf_0_clk/X 0
C306 uio_out[6] uio_out[3] 0.00986f
C307 _24_/a_27_47# _01_/a_193_47# 0
C308 uio_in[6] clkbuf_0_clk/a_110_47# 0
C309 _00_/a_543_47# uo_out[1] 0
C310 _00_/a_193_47# input2/X 0.03181f
C311 misfit01_core_16/HI clkbuf_0_clk/X 0
C312 uo_out[0] _01_/a_651_413# 0
C313 ui_in[6] clk 0.00114f
C314 inv_a _01_/a_639_47# 0.00221f
C315 _00_/a_639_47# _24_/A 0.00229f
C316 _00_/a_1462_47# input2/X 0
C317 _00_/a_761_289# VGND 0.00369f
C318 _00_/a_193_47# VPWR 0.05084f
C319 VPWR _01_/CLK 0.76855f
C320 ui_in[6] ui_in[5] 0.03102f
C321 _25_/A clkbuf_1_0__f_clk/a_110_47# 0.05326f
C322 inv_a _24_/A 0.00128f
C323 _00_/a_1462_47# VPWR 0
C324 _00_/D ui_in[0] 0.00447f
C325 _00_/D input2/a_244_47# 0.00773f
C326 clkbuf_1_1__f_clk/a_110_47# clkbuf_0_clk/X 0.01729f
C327 inv_a inv_y 0.05527f
C328 clk _24_/A 0
C329 uio_in[5] input2/X 0
C330 misfit01_core_15/HI uio_out[7] 0.01021f
C331 misfit01_core_11/HI uio_out[3] 0.01021f
C332 clk input3/a_244_47# 0
C333 ui_in[2] input2/X 0
C334 uio_in[4] VGND 0.00246f
C335 uio_in[5] VPWR 0
C336 ui_in[2] VPWR 0.00308f
C337 ui_in[1] VGND 0
C338 uio_out[5] uio_out[7] 0
C339 _01_/a_761_289# input2/X 0
C340 uio_out[5] uio_out[3] 0
C341 _00_/a_543_47# _00_/CLK 0
C342 _00_/a_761_289# _00_/D 0
C343 uo_out[1] uo_out[3] 0.00167f
C344 _01_/a_805_47# _24_/A 0
C345 _25_/a_27_47# _24_/A 0
C346 VPWR _01_/a_761_289# 0.00374f
C347 VGND _01_/a_543_47# 0.01642f
C348 _00_/a_639_47# inv_a 0
C349 VGND misfit01_core_17/HI 0.11925f
C350 misfit01_core_23/HI uio_oe[1] 0.01021f
C351 _00_/a_193_47# clkbuf_0_clk/a_110_47# 0.00853f
C352 ui_in[0] input2/X 0
C353 input2/a_244_47# input2/X 0.00104f
C354 VPWR ui_in[0] 0.09202f
C355 VGND input2/a_355_47# 0.01231f
C356 VPWR input2/a_244_47# 0.03477f
C357 uio_in[3] _00_/CLK 0
C358 uio_in[4] _00_/D 0
C359 rst_n ui_in[0] 0.08306f
C360 input2/a_244_47# rst_n 0.01632f
C361 misfit01_core_12/HI uio_out[6] 0
C362 VPWR uo_out[7] 0.22577f
C363 misfit01_core_10/HI misfit01_core_11/HI 0.0748f
C364 _00_/a_1283_21# _01_/a_1283_21# 0.00381f
C365 _00_/a_1108_47# _01_/a_543_47# 0.00224f
C366 _00_/a_543_47# _01_/a_1108_47# 0.00224f
C367 _24_/a_27_47# _01_/a_761_289# 0
C368 uio_in[5] clkbuf_0_clk/a_110_47# 0
C369 _00_/a_1283_21# uo_out[1] 0.00221f
C370 _00_/a_761_289# input2/X 0.00903f
C371 _24_/A clkbuf_0_clk/X 0.35285f
C372 uo_out[2] clkbuf_0_clk/X 0
C373 ui_in[5] clk 0.00114f
C374 uio_in[3] uio_in[2] 0.03102f
C375 inv_a _25_/a_27_47# 0
C376 inv_a _01_/a_805_47# 0
C377 _00_/a_805_47# _24_/A 0
C378 _00_/a_761_289# VPWR 0.01704f
C379 _00_/a_543_47# VGND 0.03252f
C380 misfit01_core_9/HI uio_out[1] 0.01022f
C381 uo_out[0] misfit01_core_16/HI 0
C382 misfit01_core_4/HI misfit01_core/HI 0.00112f
C383 uo_out[6] misfit01_core_21/HI 0.00529f
C384 _00_/D input2/a_355_47# 0.02554f
C385 uio_in[4] input2/X 0
C386 clk input3/a_355_47# 0
C387 uio_in[4] VPWR 0.00164f
C388 uio_in[3] VGND 0.00214f
C389 clkbuf_1_0__f_clk/a_110_47# _01_/CLK 0.08784f
C390 VGND misfit01_core_9/HI 0.11828f
C391 uio_out[4] misfit01_core_13/HI 0.01511f
C392 _00_/a_639_47# clkbuf_0_clk/X 0.00105f
C393 ui_in[1] VPWR 0.01453f
C394 ena VGND 0.00481f
C395 _01_/a_543_47# input2/X 0
C396 _01_/a_27_47# _24_/A 0
C397 _00_/a_543_47# _00_/D 0
C398 _00_/a_1283_21# _00_/CLK 0
C399 inv_a clkbuf_0_clk/X 0.05881f
C400 misfit01_core_4/HI uio_oe[4] 0.01021f
C401 _01_/a_1217_47# _24_/A 0
C402 VPWR _01_/a_543_47# 0.0085f
C403 VGND _01_/a_1283_21# 0.04417f
C404 _00_/a_805_47# inv_a 0
C405 VPWR misfit01_core_17/HI 0.03305f
C406 VGND uo_out[3] 0.12759f
C407 misfit01_core_4/HI VGND 0.02876f
C408 uo_out[1] VGND 0.05274f
C409 _25_/A _01_/a_639_47# 0.00105f
C410 _00_/a_761_289# clkbuf_0_clk/a_110_47# 0.00353f
C411 clk clkbuf_0_clk/X 0.067f
C412 input2/a_355_47# input2/X 0.00119f
C413 misfit01_core_8/HI uo_out[7] 0.00529f
C414 _25_/A _24_/A 0.00232f
C415 input1/a_27_47# VGND 0.05773f
C416 VPWR input2/a_355_47# 0.0092f
C417 uio_in[3] _00_/D 0
C418 uio_in[2] _00_/CLK 0.00165f
C419 input2/a_355_47# rst_n 0.01051f
C420 inv_y _25_/A 0.00203f
C421 uio_out[4] uio_out[6] 0
C422 misfit01_core_10/HI uio_out[3] 0.00499f
C423 uio_out[2] misfit01_core_11/HI 0.0052f
C424 _00_/a_1108_47# _01_/a_1283_21# 0.00107f
C425 _00_/a_1283_21# _01_/a_1108_47# 0.00107f
C426 _25_/a_27_47# clkbuf_0_clk/X 0.00193f
C427 _24_/a_27_47# _01_/a_543_47# 0
C428 uio_in[4] clkbuf_0_clk/a_110_47# 0
C429 inv_a _01_/a_27_47# 0.03146f
C430 _00_/a_1108_47# uo_out[1] 0.00129f
C431 _00_/a_543_47# input2/X 0.02513f
C432 _00_/a_27_47# _24_/A 0.03036f
C433 ui_in[4] clk 0.00114f
C434 inv_a _01_/a_1217_47# 0
C435 _00_/a_543_47# VPWR 0.00913f
C436 _00_/a_1283_21# VGND 0.02554f
C437 uo_out[0] _24_/A 0.00312f
C438 uo_out[0] uo_out[2] 0
C439 ui_in[5] ui_in[4] 0.03102f
C440 _00_/CLK VGND 0.26892f
C441 misfit01_core_4/HI uio_oe[3] 0.01426f
C442 uo_out[6] uo_out[7] 0.14639f
C443 inv_a _25_/A 1.22734f
C444 VGND misfit01_core/HI 0.11755f
C445 misfit01_core_18/HI uo_out[4] 0.01021f
C446 misfit01_core_12/HI uio_out[3] 0.00484f
C447 uio_out[4] misfit01_core_11/HI 0
C448 uio_in[3] input2/X 0
C449 uio_in[3] VPWR 0.00168f
C450 uio_in[2] VGND 0.00197f
C451 VGND uio_out[1] 0.11973f
C452 VPWR misfit01_core_9/HI 0.03288f
C453 uio_out[4] uio_out[5] 0.17655f
C454 _25_/a_27_47# _01_/a_27_47# 0.00903f
C455 _00_/a_1283_21# _00_/a_1108_47# 0
C456 _00_/a_27_47# _00_/a_639_47# -0.00188f
C457 ena VPWR 0.00224f
C458 _01_/a_193_47# _24_/A 0
C459 _01_/a_1283_21# input2/X 0.0362f
C460 _00_/a_27_47# inv_a 0
C461 _00_/a_1108_47# _00_/CLK 0
C462 _00_/a_1283_21# _00_/D 0
C463 _01_/a_1462_47# _24_/A 0
C464 uo_out[1] input2/X 0
C465 VGND _01_/a_1108_47# 0.00489f
C466 VPWR _01_/a_1283_21# 0.0376f
C467 _00_/a_1217_47# inv_a 0
C468 _00_/CLK _00_/D 0.09053f
C469 inv_a uo_out[0] 0.00105f
C470 uio_oe[4] VGND 0.0868f
C471 misfit01_core_4/HI VPWR 0.01209f
C472 VPWR uo_out[3] 0.22411f
C473 uo_out[1] VPWR 0.26809f
C474 _25_/A _25_/a_27_47# 0.06047f
C475 _00_/a_543_47# clkbuf_0_clk/a_110_47# 0.01201f
C476 uio_out[0] uo_out[7] 0.14639f
C477 input3/a_27_47# ui_in[0] 0.07847f
C478 input1/a_244_47# VGND 0.02401f
C479 input1/a_27_47# VPWR 0.09749f
C480 uio_in[2] _00_/D 0
C481 uio_in[1] _00_/CLK 0.00128f
C482 misfit01_core/HI uio_oe[3] 0.01021f
C483 _01_/a_27_47# clkbuf_0_clk/X 0.00417f
C484 uio_out[2] uio_out[3] 0.14867f
C485 _00_/a_27_47# _25_/a_27_47# 0
C486 inv_a _01_/a_193_47# 0.03742f
C487 _00_/a_193_47# _24_/A 0.03562f
C488 _00_/a_1283_21# input2/X 0.00489f
C489 uo_out[2] _01_/CLK 0
C490 uo_out[1] _24_/a_27_47# 0.00241f
C491 uo_out[0] _01_/a_805_47# 0
C492 ui_in[3] clk 0.00114f
C493 uio_in[2] uio_in[1] 0.03102f
C494 inv_a _01_/a_1462_47# 0
C495 _00_/CLK input2/X 0.0215f
C496 _00_/a_1283_21# VPWR 0.02918f
C497 _00_/a_1108_47# VGND 0
C498 _25_/A clkbuf_0_clk/X 0.03676f
C499 _00_/CLK VPWR 1.64169f
C500 _00_/D VGND 0.50179f
C501 clkbuf_0_clk/a_110_47# _01_/a_1283_21# 0.00169f
C502 uio_oe[4] uio_oe[3] 0.14639f
C503 VPWR misfit01_core/HI 0.03269f
C504 VGND uio_oe[3] 0.08834f
C505 uio_out[4] uio_out[3] 0.0714f
C506 uio_in[2] input2/X 0
C507 clk input2/a_27_47# 0.00106f
C508 _00_/a_27_47# clkbuf_0_clk/X 0.03891f
C509 uio_in[1] VGND 0.00197f
C510 uio_in[2] VPWR 0.00153f
C511 VPWR uio_out[1] 0.14573f
C512 _25_/a_27_47# _01_/a_193_47# 0
C513 misfit01_core_10/HI uio_out[2] 0.01038f
C514 _00_/a_1283_21# _24_/a_27_47# 0.00245f
C515 uo_out[0] clkbuf_0_clk/X 0.00351f
C516 _01_/a_761_289# _24_/A 0
C517 _01_/a_1108_47# input2/X 0.00946f
C518 _00_/a_193_47# inv_a 0
C519 _00_/a_1108_47# _00_/D 0
C520 _00_/a_448_47# _00_/CLK 0
C521 inv_a _01_/CLK 0
C522 _00_/CLK _24_/a_27_47# 0
C523 VGND misfit01_core_19/HI 0.11749f
C524 VGND _01_/a_448_47# 0
C525 VPWR _01_/a_1108_47# 0.05525f
C526 _00_/a_1462_47# inv_a 0
C527 _25_/A _01_/a_27_47# 0.0736f
C528 uio_oe[4] VPWR 0.24214f
C529 VGND input2/X 5.78419f
C530 uio_in[7] _00_/a_27_47# 0
C531 VGND VPWR 0.2036p
C532 _00_/CLK clkbuf_0_clk/a_110_47# 0.06279f
C533 input3/a_244_47# ui_in[0] 0.05182f
C534 input1/a_244_47# VPWR 0
C535 input1/a_355_47# VGND 0.01515f
C536 uio_in[7] uo_out[0] 0.03102f
C537 VGND rst_n 0.24342f
C538 uio_in[1] _00_/D 0
C539 uio_in[0] _00_/CLK 0.00118f
C540 uio_out[4] misfit01_core_10/HI 0
C541 VGND misfit01_core_24/HI 0.11931f
C542 _01_/a_193_47# clkbuf_0_clk/X 0.00316f
C543 _00_/a_651_413# _01_/a_1283_21# 0
C544 uo_out[3] clkbuf_1_0__f_clk/a_110_47# 0
C545 _00_/a_1283_21# _01_/a_651_413# 0
C546 _00_/a_193_47# _25_/a_27_47# 0
C547 _25_/a_27_47# _01_/CLK 0.00191f
C548 uo_out[1] clkbuf_1_0__f_clk/a_110_47# 0.00216f
C549 uo_out[0] _01_/a_27_47# 0
C550 uio_in[7] uio_in[6] 0.03102f
C551 inv_a _01_/a_761_289# 0.01735f
C552 misfit01_core_20/HI VGND 0.02869f
C553 _00_/a_651_413# uo_out[1] 0
C554 _00_/a_761_289# _24_/A 0.01548f
C555 _00_/a_1108_47# input2/X 0.00537f
C556 ui_in[2] clk 0.00114f
C557 _00_/D input2/X 1.23624f
C558 _00_/a_1108_47# VPWR 0.05182f
C559 _00_/a_448_47# VGND 0.01426f
C560 _24_/a_27_47# VGND 0.02115f
C561 _00_/a_27_47# _25_/A 0
C562 ui_in[4] ui_in[3] 0.03102f
C563 _00_/D VPWR 5.27883f
C564 clkbuf_0_clk/a_110_47# _01_/a_1108_47# 0
C565 _00_/D rst_n 0.05854f
C566 misfit01_core_12/HI uio_out[4] 0.00622f
C567 uio_out[0] misfit01_core_9/HI 0.00529f
C568 VPWR uio_oe[3] 0.18847f
C569 uio_in[1] input2/X 0
C570 clkbuf_0_clk/a_110_47# VGND 0.07969f
C571 _01_/a_27_47# _01_/a_193_47# -0.01782f
C572 clk ui_in[0] 0.06288f
C573 clk input2/a_244_47# 0
C574 _00_/a_193_47# clkbuf_0_clk/X 0.03565f
C575 uio_in[1] VPWR 0.00148f
C576 uio_in[0] VGND 0.00234f
C577 clkbuf_0_clk/X _01_/CLK 0.00367f
C578 VGND misfit01_core_6/HI 0.11933f
C579 uio_oe[4] misfit01_core_5/HI 0.00529f
C580 uio_oe[2] misfit01_core/HI 0.00529f
C581 _00_/a_1108_47# _24_/a_27_47# 0.00315f
C582 _01_/a_543_47# _24_/A 0
C583 _01_/a_448_47# input2/X 0
C584 _00_/a_761_289# inv_a 0
C585 _00_/a_448_47# _00_/D 0.00211f
C586 uio_in[3] clkbuf_1_1__f_clk/a_110_47# 0
C587 VGND misfit01_core_5/HI 0.11933f
C588 misfit01_core_8/HI VGND 0.11926f
C589 uo_out[2] misfit01_core_17/HI 0.00529f
C590 VGND uo_out[5] 0.10375f
C591 VPWR misfit01_core_19/HI 0.0327f
C592 uo_out[1] misfit01_core_16/HI 0.00411f
C593 VPWR _01_/a_448_47# 0.00185f
C594 VGND _01_/a_651_413# 0.00129f
C595 _25_/A _01_/a_193_47# 0.06868f
C596 VPWR input2/X 0.57751f
C597 _00_/a_1108_47# clkbuf_0_clk/a_110_47# 0
C598 uio_in[5] clkbuf_0_clk/X 0.00165f
C599 rst_n input2/X 0.00374f
C600 VGND misfit01_core_22/HI 0.11931f
C601 _00_/D clkbuf_0_clk/a_110_47# 0.00808f
C602 input3/a_355_47# ui_in[0] 0.00936f
C603 input1/a_355_47# VPWR 0.01523f
C604 VPWR rst_n 0.33137f
C605 uio_in[0] _00_/D 0
C606 uio_out[4] uio_out[2] 0
C607 misfit01_core_20/HI misfit01_core_19/HI 0.00112f
C608 VPWR misfit01_core_24/HI 0.03303f
C609 VGND uio_oe[2] 0.1122f
C610 _01_/a_27_47# _01_/CLK 0.02059f
C611 _01_/a_761_289# clkbuf_0_clk/X 0
C612 uo_out[0] _01_/a_193_47# 0
C613 uio_in[4] clk 0.00211f
C614 inv_a _01_/a_543_47# 0.01948f
C615 misfit01_core_20/HI VPWR 0.01209f
C616 uo_out[6] VGND 0.11935f
C617 _00_/a_1270_413# uo_out[1] 0
C618 _00_/a_543_47# _24_/A 0.01819f
C619 _00_/a_448_47# input2/X 0.02509f
C620 VGND clkbuf_1_0__f_clk/a_110_47# 0.13163f
C621 _24_/a_27_47# input2/X 0.00272f
C622 ui_in[1] clk 0.00114f
C623 uio_in[1] uio_in[0] 0.03102f
C624 _00_/a_651_413# VGND 0.00575f
C625 _00_/a_448_47# VPWR 0
C626 VGND misfit01_core_14/HI 0.11671f
C627 _24_/a_27_47# VPWR 0.07779f
C628 _00_/a_193_47# _25_/A 0
C629 _25_/A _01_/CLK 0.11216f
C630 uio_out[0] uio_out[1] 0.14639f
C631 clkbuf_0_clk/a_110_47# input2/X 0.00303f
C632 _00_/CLK clkbuf_1_1__f_clk/a_110_47# 0.13304f
C633 uio_in[0] input2/X 0
C634 clkbuf_0_clk/a_110_47# VPWR 0.04065f
C635 _00_/a_27_47# _00_/a_193_47# -0.05875f
C636 clk input2/a_355_47# 0
C637 uio_in[0] VPWR 0.00185f
C638 ui_in[7] VGND 0.0024f
C639 misfit01_core_19/HI uo_out[5] 0.01021f
C640 _00_/a_761_289# clkbuf_0_clk/X 0.00195f
C641 VPWR misfit01_core_6/HI 0.03303f
C642 VGND uio_oe[6] 0.09419f
C643 uio_oe[4] uio_oe[5] 0.14639f
C644 uio_oe[2] uio_oe[3] 0.14639f
C645 _01_/a_1283_21# _24_/A 0.00645f
C646 _00_/a_543_47# inv_a 0
C647 uio_in[2] clkbuf_1_1__f_clk/a_110_47# 0
C648 VPWR misfit01_core_5/HI 0.03303f
C649 VGND uio_oe[5] 0.09419f
C650 _00_/a_1462_47# uo_out[0] 0
C651 uio_out[0] VGND 0.12674f
C652 misfit01_core_8/HI VPWR 0.03303f
C653 uo_out[2] uo_out[3] 0.14639f
C654 VPWR uo_out[5] 0.17923f
C655 uo_out[1] _24_/A 0.00357f
C656 VPWR _01_/a_651_413# 0.00176f
C657 uo_out[1] uo_out[2] 0.12575f
C658 _25_/A _01_/a_761_289# 0
C659 VGND misfit01_core_13/HI 0.12379f
C660 misfit01_core_16/HI VGND 0.11546f
C661 _00_/a_448_47# clkbuf_0_clk/a_110_47# 0.00121f
C662 uio_in[5] _00_/a_27_47# 0
C663 VGND input3/a_27_47# 0.07172f
C664 uio_in[4] clkbuf_0_clk/X 0
C665 clkbuf_0_clk/a_110_47# _24_/a_27_47# 0.00178f
C666 VGND uio_oe[0] 0.1122f
C667 VPWR misfit01_core_22/HI 0.03361f
C668 input2/a_355_47# input3/a_355_47# 0.00914f
C669 input1/a_27_47# inv_y 0.02663f
C670 ui_in[7] _00_/D 0
C671 VGND clkbuf_1_1__f_clk/a_110_47# 0.12613f
C672 misfit01_core_20/HI uo_out[5] 0.01426f
C673 VPWR uio_oe[2] 0.23428f
C674 _01_/a_193_47# _01_/CLK 0.00559f
C675 _01_/a_543_47# clkbuf_0_clk/X 0
C676 uo_out[0] _01_/a_761_289# 0.00132f
C677 uio_in[3] clk 0.00114f
C678 uio_in[6] uio_in[5] 0.03102f
C679 inv_a _01_/a_1283_21# 0.00358f
C680 uo_out[6] VPWR 0.2231f
C681 _00_/a_1283_21# _24_/A 0.00553f
C682 misfit01_core_24/HI uio_oe[2] 0.01021f
C683 VPWR clkbuf_1_0__f_clk/a_110_47# 0.18686f
C684 ena clk 0.03102f
C685 inv_a uo_out[1] 0.0066f
C686 _00_/CLK _24_/A 0
C687 _00_/a_651_413# VPWR 0.00116f
C688 VPWR misfit01_core_14/HI 0.03751f
C689 VGND uio_out[6] 0.08074f
C690 _00_/a_761_289# _25_/A 0
C691 _00_/D input3/a_27_47# 0
C692 ui_in[3] ui_in[2] 0.03102f
C693 inv_a input1/a_27_47# 0
C694 ena 0 0.06927f
C695 ui_in[1] 0 0.03342f
C696 ui_in[2] 0 0.04143f
C697 ui_in[3] 0 0.04143f
C698 ui_in[4] 0 0.04143f
C699 ui_in[5] 0 0.04143f
C700 ui_in[6] 0 0.04143f
C701 ui_in[7] 0 0.04143f
C702 uio_in[0] 0 0.04143f
C703 uio_in[1] 0 0.04132f
C704 uio_in[2] 0 0.04132f
C705 uio_in[3] 0 0.04127f
C706 uio_in[4] 0 0.04118f
C707 uio_in[5] 0 0.04135f
C708 uio_in[6] 0 0.03358f
C709 uio_in[7] 0 0.03358f
C710 uo_out[5] 0 0.20506f
C711 misfit01_core_19/HI 0 0.24957f
C712 clkbuf_1_1__f_clk/a_110_47# 0 1.73295f
C713 uo_out[4] 0 0.18714f
C714 misfit01_core_18/HI 0 0.24957f
C715 uo_out[3] 0 0.18719f
C716 misfit01_core_17/HI 0 0.24957f
C717 VPWR 0 1.03177p
C718 VGND 0 0.33927p
C719 uo_out[2] 0 0.20571f
C720 misfit01_core_16/HI 0 0.24957f
C721 uio_out[7] 0 0.19443f
C722 misfit01_core_15/HI 0 0.24957f
C723 uio_out[6] 0 0.21274f
C724 misfit01_core_14/HI 0 0.24957f
C725 uio_oe[2] 0 0.18728f
C726 misfit01_core_24/HI 0 0.24957f
C727 uio_out[5] 0 0.23652f
C728 misfit01_core_13/HI 0 0.24957f
C729 uio_oe[1] 0 0.18728f
C730 misfit01_core_23/HI 0 0.24957f
C731 uio_out[4] 0 0.28066f
C732 misfit01_core_12/HI 0 0.24957f
C733 _01_/CLK 0 0.23283f
C734 clkbuf_0_clk/X 0 1.05047f
C735 clkbuf_1_0__f_clk/a_110_47# 0 1.73295f
C736 uio_oe[0] 0 0.18728f
C737 misfit01_core_22/HI 0 0.24957f
C738 uio_out[3] 0 0.20048f
C739 misfit01_core_11/HI 0 0.24957f
C740 uio_out[2] 0 0.20231f
C741 misfit01_core_10/HI 0 0.24957f
C742 uo_out[7] 0 0.18723f
C743 misfit01_core_21/HI 0 0.24957f
C744 uo_out[6] 0 0.19457f
C745 misfit01_core_20/HI 0 0.24957f
C746 inv_a 0 7.38629f
C747 _00_/D 0 0.27492f
C748 _00_/CLK 0 0.23132f
C749 _00_/a_651_413# 0 0.00469f
C750 _00_/a_448_47# 0 0.0139f
C751 _00_/a_1108_47# 0 0.13732f
C752 _00_/a_1283_21# 0 0.38926f
C753 _00_/a_543_47# 0 0.15787f
C754 _00_/a_761_289# 0 0.12085f
C755 _00_/a_193_47# 0 0.27321f
C756 _00_/a_27_47# 0 0.49575f
C757 _24_/A 0 0.22444f
C758 input2/X 0 -0.97013f
C759 _01_/a_651_413# 0 0.00469f
C760 _01_/a_448_47# 0 0.0139f
C761 _01_/a_1108_47# 0 0.13732f
C762 _01_/a_1283_21# 0 0.38926f
C763 _01_/a_543_47# 0 0.15787f
C764 _01_/a_761_289# 0 0.12085f
C765 _01_/a_193_47# 0 0.27321f
C766 _01_/a_27_47# 0 0.49575f
C767 ui_in[0] 0 0.4692f
C768 input3/a_355_47# 0 0.16237f
C769 input3/a_244_47# 0 0.18969f
C770 input3/a_27_47# 0 0.22821f
C771 rst_n 0 0.53935f
C772 input2/a_355_47# 0 0.16237f
C773 input2/a_244_47# 0 0.18969f
C774 input2/a_27_47# 0 0.22821f
C775 _25_/A 0 0.55524f
C776 inv_y 0 0.41763f
C777 input1/a_355_47# 0 0.16237f
C778 input1/a_244_47# 0 0.18969f
C779 input1/a_27_47# 0 0.22821f
C780 uio_oe[3] 0 0.20472f
C781 misfit01_core/HI 0 0.24957f
C782 uo_out[0] 0 0.26804f
C783 _24_/a_27_47# 0 0.28447f
C784 clk 0 1.03315f
C785 clkbuf_0_clk/a_110_47# 0 1.73295f
C786 uo_out[1] 0 0.20703f
C787 _25_/a_27_47# 0 0.28447f
C788 uio_out[1] 0 0.19663f
C789 misfit01_core_9/HI 0 0.24957f
C790 uio_out[0] 0 0.18723f
C791 misfit01_core_8/HI 0 0.24957f
C792 uio_oe[7] 0 0.28847f
C793 misfit01_core_7/HI 0 0.24957f
C794 uio_oe[6] 0 0.18748f
C795 misfit01_core_6/HI 0 0.24957f
C796 uio_oe[5] 0 0.18748f
C797 misfit01_core_5/HI 0 0.24957f
C798 uio_oe[4] 0 0.19482f
C799 misfit01_core_4/HI 0 0.24957f
.ends

.subckt tt_um_misfit01b clk ena rst_n ui_in[0] ui_in[1] ui_in[2] ui_in[3] ui_in[4]
+ ui_in[5] ui_in[6] ui_in[7] uio_in[0] uio_in[1] uio_in[2] uio_in[3] uio_in[4] uio_in[5]
+ uio_in[6] uio_in[7] uio_oe[0] uio_oe[1] uio_oe[2] uio_oe[3] uio_oe[4] uio_oe[5]
+ uio_oe[6] uio_oe[7] uio_out[0] uio_out[1] uio_out[2] uio_out[3] uio_out[4] uio_out[5]
+ uio_out[6] uio_out[7] uo_out[0] uo_out[1] uo_out[2] uo_out[3] uo_out[4] uo_out[5]
+ uo_out[6] uo_out[7] VPWR VGND
Xmisfit_inv_m4_0 misfit_inv_m4_0/A misfit_inv_m4_0/Y VGND VPWR misfit_inv_m4
Xmisfit01_core_0 clk ena misfit_inv_m4_0/A misfit_inv_m4_0/Y ui_in[1] ui_in[2] ui_in[3]
+ ui_in[4] ui_in[5] ui_in[6] ui_in[7] uio_in[0] uio_in[1] uio_in[2] uio_in[3] uio_in[4]
+ uio_in[5] uio_in[6] uio_in[7] uio_oe[1] uio_oe[3] uio_oe[4] uio_oe[6] uio_out[1]
+ uio_out[4] uio_out[6] uio_out[7] uo_out[1] uo_out[3] uo_out[4] uo_out[6] ui_in[0]
+ uo_out[0] uio_oe[0] uio_out[3] uio_out[0] uio_oe[5] uo_out[5] uio_oe[2] uo_out[7]
+ uo_out[2] uio_out[5] uio_out[2] rst_n uio_oe[7] VPWR VGND misfit01_core
C0 misfit_inv_m4_0/A VGND 0.31278f
C1 uo_out[7] uio_out[0] -0
C2 uio_oe[4] uio_oe[5] -0
C3 clk rst_n -0
C4 misfit_inv_m4_0/A misfit_inv_m4_0/Y 0.00515f
C5 ui_in[4] ui_in[3] -0
C6 VPWR VGND 9.9692f
C7 uio_in[1] uio_in[0] -0
C8 uio_in[6] uio_in[5] -0
C9 VPWR misfit_inv_m4_0/Y 0.14276f
C10 uio_out[3] uio_out[2] -0
C11 VPWR misfit_inv_m4_0/A 0.32099f
C12 uio_out[5] uio_out[4] 0.01551f
C13 ui_in[7] ui_in[6] -0
C14 VPWR ui_in[1] 0
C15 uio_out[7] uio_oe[0] -0
C16 uo_out[6] uo_out[5] -0
C17 uio_in[4] uio_in[3] -0
C18 uo_out[2] uo_out[3] -0
C19 uo_out[1] uo_out[0] -0
C20 VGND misfit_inv_m4_0/Y 0.09685f
C21 ena 0 0.06927f
C22 ui_in[1] 0 0.03342f
C23 ui_in[2] 0 0.04143f
C24 ui_in[3] 0 0.04143f
C25 ui_in[4] 0 0.04143f
C26 ui_in[5] 0 0.04143f
C27 ui_in[6] 0 0.04143f
C28 ui_in[7] 0 0.04143f
C29 uio_in[0] 0 0.04143f
C30 uio_in[1] 0 0.04132f
C31 uio_in[2] 0 0.04132f
C32 uio_in[3] 0 0.04127f
C33 uio_in[4] 0 0.04118f
C34 uio_in[5] 0 0.04135f
C35 uio_in[6] 0 0.03358f
C36 uio_in[7] 0 0.03358f
C37 uo_out[5] 0 0.20506f
C38 misfit01_core_0/misfit01_core_19/HI 0 0.24957f
C39 misfit01_core_0/clkbuf_1_1__f_clk/a_110_47# 0 1.73295f
C40 uo_out[4] 0 0.18714f
C41 misfit01_core_0/misfit01_core_18/HI 0 0.24957f
C42 uo_out[3] 0 0.18719f
C43 misfit01_core_0/misfit01_core_17/HI 0 0.24957f
C44 VPWR 0 1.0457p
C45 VGND 0 0.34752p
C46 uo_out[2] 0 0.20571f
C47 misfit01_core_0/misfit01_core_16/HI 0 0.24957f
C48 uio_out[7] 0 0.19443f
C49 misfit01_core_0/misfit01_core_15/HI 0 0.24957f
C50 uio_out[6] 0 0.21274f
C51 misfit01_core_0/misfit01_core_14/HI 0 0.24957f
C52 uio_oe[2] 0 0.18728f
C53 misfit01_core_0/misfit01_core_24/HI 0 0.24957f
C54 uio_out[5] 0 0.17233f
C55 misfit01_core_0/misfit01_core_13/HI 0 0.24957f
C56 uio_oe[1] 0 0.18728f
C57 misfit01_core_0/misfit01_core_23/HI 0 0.24957f
C58 uio_out[4] 0 0.28066f
C59 misfit01_core_0/misfit01_core_12/HI 0 0.24957f
C60 misfit01_core_0/_01_/CLK 0 0.23283f
C61 misfit01_core_0/clkbuf_0_clk/X 0 1.05047f
C62 misfit01_core_0/clkbuf_1_0__f_clk/a_110_47# 0 1.73295f
C63 uio_oe[0] 0 0.18728f
C64 misfit01_core_0/misfit01_core_22/HI 0 0.24957f
C65 uio_out[3] 0 0.20048f
C66 misfit01_core_0/misfit01_core_11/HI 0 0.24957f
C67 uio_out[2] 0 0.20231f
C68 misfit01_core_0/misfit01_core_10/HI 0 0.24957f
C69 uo_out[7] 0 0.18723f
C70 misfit01_core_0/misfit01_core_21/HI 0 0.24957f
C71 uo_out[6] 0 0.19457f
C72 misfit01_core_0/misfit01_core_20/HI 0 0.24957f
C73 misfit_inv_m4_0/A 0 10.27443f
C74 misfit01_core_0/_00_/D 0 0.27492f
C75 misfit01_core_0/_00_/CLK 0 0.23132f
C76 misfit01_core_0/_00_/a_651_413# 0 0.00469f
C77 misfit01_core_0/_00_/a_448_47# 0 0.0139f
C78 misfit01_core_0/_00_/a_1108_47# 0 0.13732f
C79 misfit01_core_0/_00_/a_1283_21# 0 0.38926f
C80 misfit01_core_0/_00_/a_543_47# 0 0.15787f
C81 misfit01_core_0/_00_/a_761_289# 0 0.12085f
C82 misfit01_core_0/_00_/a_193_47# 0 0.27321f
C83 misfit01_core_0/_00_/a_27_47# 0 0.49575f
C84 misfit01_core_0/_24_/A 0 0.22444f
C85 misfit01_core_0/input2/X 0 -0.97013f
C86 misfit01_core_0/_01_/a_651_413# 0 0.00469f
C87 misfit01_core_0/_01_/a_448_47# 0 0.0139f
C88 misfit01_core_0/_01_/a_1108_47# 0 0.13732f
C89 misfit01_core_0/_01_/a_1283_21# 0 0.38926f
C90 misfit01_core_0/_01_/a_543_47# 0 0.15787f
C91 misfit01_core_0/_01_/a_761_289# 0 0.12085f
C92 misfit01_core_0/_01_/a_193_47# 0 0.27321f
C93 misfit01_core_0/_01_/a_27_47# 0 0.49575f
C94 ui_in[0] 0 0.4692f
C95 misfit01_core_0/input3/a_355_47# 0 0.16237f
C96 misfit01_core_0/input3/a_244_47# 0 0.18969f
C97 misfit01_core_0/input3/a_27_47# 0 0.22821f
C98 rst_n 0 0.53935f
C99 misfit01_core_0/input2/a_355_47# 0 0.16237f
C100 misfit01_core_0/input2/a_244_47# 0 0.18969f
C101 misfit01_core_0/input2/a_27_47# 0 0.22821f
C102 misfit01_core_0/_25_/A 0 0.55524f
C103 misfit_inv_m4_0/Y 0 2.84546f
C104 misfit01_core_0/input1/a_355_47# 0 0.16237f
C105 misfit01_core_0/input1/a_244_47# 0 0.18969f
C106 misfit01_core_0/input1/a_27_47# 0 0.22821f
C107 uio_oe[3] 0 0.20472f
C108 misfit01_core_0/misfit01_core/HI 0 0.24957f
C109 uo_out[0] 0 0.26804f
C110 misfit01_core_0/_24_/a_27_47# 0 0.28447f
C111 clk 0 1.03315f
C112 misfit01_core_0/clkbuf_0_clk/a_110_47# 0 1.73295f
C113 uo_out[1] 0 0.20703f
C114 misfit01_core_0/_25_/a_27_47# 0 0.28447f
C115 uio_out[1] 0 0.19663f
C116 misfit01_core_0/misfit01_core_9/HI 0 0.24957f
C117 uio_out[0] 0 0.18723f
C118 misfit01_core_0/misfit01_core_8/HI 0 0.24957f
C119 uio_oe[7] 0 0.28847f
C120 misfit01_core_0/misfit01_core_7/HI 0 0.24957f
C121 uio_oe[6] 0 0.18748f
C122 misfit01_core_0/misfit01_core_6/HI 0 0.24957f
C123 uio_oe[5] 0 0.18748f
C124 misfit01_core_0/misfit01_core_5/HI 0 0.24957f
C125 uio_oe[4] 0 0.19482f
C126 misfit01_core_0/misfit01_core_4/HI 0 0.24957f
.ends
