* NGSPICE file created from tt_um_misfit01b.ext - technology: sky130A

.subckt misfit_inv_m4 A Y VGND VPWR
X0 Y A VPWR VPWR sky130_fd_pr__pfet_01v8 ad=0.58 pd=3.16 as=0.58 ps=3.16 w=1 l=0.5
X1 Y A VGND VGND sky130_fd_pr__nfet_01v8 ad=0.377 pd=2.46 as=0.377 ps=2.46 w=0.65 l=0.5
.ends

.subckt sky130_fd_sc_hd__decap_3 VPWR VGND VPB VNB
X0 VPWR VGND VPWR VPB sky130_fd_pr__pfet_01v8_hvt ad=0.2262 pd=2.26 as=0.4524 ps=4.52 w=0.87 l=0.59
X1 VGND VPWR VGND VNB sky130_fd_pr__nfet_01v8 ad=0.143 pd=1.62 as=0.286 ps=3.24 w=0.55 l=0.59
.ends

.subckt sky130_fd_sc_hd__conb_1 LO HI VPB VNB VGND VPWR
X0 VPWR HI sky130_fd_pr__res_generic_po w=0.48 l=0.045
X1 LO VGND sky130_fd_pr__res_generic_po w=0.48 l=0.045
.ends

.subckt sky130_fd_sc_hd__buf_2 VPWR VGND X A VPB VNB
X0 VPWR a_27_47# X VPB sky130_fd_pr__pfet_01v8_hvt ad=0.265 pd=2.53 as=0.135 ps=1.27 w=1 l=0.15
X1 X a_27_47# VPWR VPB sky130_fd_pr__pfet_01v8_hvt ad=0.135 pd=1.27 as=0.149 ps=1.325 w=1 l=0.15
X2 VPWR A a_27_47# VPB sky130_fd_pr__pfet_01v8_hvt ad=0.149 pd=1.325 as=0.1664 ps=1.8 w=0.64 l=0.15
X3 X a_27_47# VGND VNB sky130_fd_pr__nfet_01v8 ad=0.08775 pd=0.92 as=0.097 ps=0.975 w=0.65 l=0.15
X4 VGND a_27_47# X VNB sky130_fd_pr__nfet_01v8 ad=0.17225 pd=1.83 as=0.08775 ps=0.92 w=0.65 l=0.15
X5 VGND A a_27_47# VNB sky130_fd_pr__nfet_01v8 ad=0.097 pd=0.975 as=0.1092 ps=1.36 w=0.42 l=0.15
.ends

.subckt sky130_fd_sc_hd__clkbuf_16 VNB VPB VGND VPWR A X
X0 VPWR A a_110_47# VPB sky130_fd_pr__pfet_01v8_hvt ad=0.14 pd=1.28 as=0.14 ps=1.28 w=1 l=0.15
X1 VPWR a_110_47# X VPB sky130_fd_pr__pfet_01v8_hvt ad=0.14 pd=1.28 as=0.14 ps=1.28 w=1 l=0.15
X2 X a_110_47# VPWR VPB sky130_fd_pr__pfet_01v8_hvt ad=0.14 pd=1.28 as=0.14 ps=1.28 w=1 l=0.15
X3 X a_110_47# VPWR VPB sky130_fd_pr__pfet_01v8_hvt ad=0.14 pd=1.28 as=0.14 ps=1.28 w=1 l=0.15
X4 VPWR a_110_47# X VPB sky130_fd_pr__pfet_01v8_hvt ad=0.14 pd=1.28 as=0.14 ps=1.28 w=1 l=0.15
X5 VPWR a_110_47# X VPB sky130_fd_pr__pfet_01v8_hvt ad=0.265 pd=2.53 as=0.14 ps=1.28 w=1 l=0.15
X6 a_110_47# A VPWR VPB sky130_fd_pr__pfet_01v8_hvt ad=0.14 pd=1.28 as=0.265 ps=2.53 w=1 l=0.15
X7 a_110_47# A VGND VNB sky130_fd_pr__nfet_01v8 ad=0.0588 pd=0.7 as=0.0588 ps=0.7 w=0.42 l=0.15
X8 VGND a_110_47# X VNB sky130_fd_pr__nfet_01v8 ad=0.0588 pd=0.7 as=0.0588 ps=0.7 w=0.42 l=0.15
X9 X a_110_47# VGND VNB sky130_fd_pr__nfet_01v8 ad=0.0588 pd=0.7 as=0.0588 ps=0.7 w=0.42 l=0.15
X10 VGND a_110_47# X VNB sky130_fd_pr__nfet_01v8 ad=0.0588 pd=0.7 as=0.0588 ps=0.7 w=0.42 l=0.15
X11 a_110_47# A VPWR VPB sky130_fd_pr__pfet_01v8_hvt ad=0.14 pd=1.28 as=0.14 ps=1.28 w=1 l=0.15
X12 VGND A a_110_47# VNB sky130_fd_pr__nfet_01v8 ad=0.0588 pd=0.7 as=0.0588 ps=0.7 w=0.42 l=0.15
X13 VGND a_110_47# X VNB sky130_fd_pr__nfet_01v8 ad=0.05775 pd=0.695 as=0.0588 ps=0.7 w=0.42 l=0.15
X14 VPWR a_110_47# X VPB sky130_fd_pr__pfet_01v8_hvt ad=0.14 pd=1.28 as=0.14 ps=1.28 w=1 l=0.15
X15 X a_110_47# VPWR VPB sky130_fd_pr__pfet_01v8_hvt ad=0.14 pd=1.28 as=0.14 ps=1.28 w=1 l=0.15
X16 VGND A a_110_47# VNB sky130_fd_pr__nfet_01v8 ad=0.0588 pd=0.7 as=0.0588 ps=0.7 w=0.42 l=0.15
X17 VGND a_110_47# X VNB sky130_fd_pr__nfet_01v8 ad=0.1113 pd=1.37 as=0.0588 ps=0.7 w=0.42 l=0.15
X18 VPWR a_110_47# X VPB sky130_fd_pr__pfet_01v8_hvt ad=0.1375 pd=1.275 as=0.14 ps=1.28 w=1 l=0.15
X19 VGND a_110_47# X VNB sky130_fd_pr__nfet_01v8 ad=0.0588 pd=0.7 as=0.0588 ps=0.7 w=0.42 l=0.15
X20 X a_110_47# VPWR VPB sky130_fd_pr__pfet_01v8_hvt ad=0.14 pd=1.28 as=0.1375 ps=1.275 w=1 l=0.15
X21 a_110_47# A VGND VNB sky130_fd_pr__nfet_01v8 ad=0.0588 pd=0.7 as=0.1113 ps=1.37 w=0.42 l=0.15
X22 VPWR A a_110_47# VPB sky130_fd_pr__pfet_01v8_hvt ad=0.14 pd=1.28 as=0.14 ps=1.28 w=1 l=0.15
X23 VPWR a_110_47# X VPB sky130_fd_pr__pfet_01v8_hvt ad=0.14 pd=1.28 as=0.14 ps=1.28 w=1 l=0.15
X24 VPWR a_110_47# X VPB sky130_fd_pr__pfet_01v8_hvt ad=0.14 pd=1.28 as=0.14 ps=1.28 w=1 l=0.15
X25 VGND a_110_47# X VNB sky130_fd_pr__nfet_01v8 ad=0.0588 pd=0.7 as=0.0588 ps=0.7 w=0.42 l=0.15
X26 X a_110_47# VPWR VPB sky130_fd_pr__pfet_01v8_hvt ad=0.14 pd=1.28 as=0.14 ps=1.28 w=1 l=0.15
X27 VGND a_110_47# X VNB sky130_fd_pr__nfet_01v8 ad=0.0588 pd=0.7 as=0.0588 ps=0.7 w=0.42 l=0.15
X28 VGND a_110_47# X VNB sky130_fd_pr__nfet_01v8 ad=0.0588 pd=0.7 as=0.0588 ps=0.7 w=0.42 l=0.15
X29 X a_110_47# VGND VNB sky130_fd_pr__nfet_01v8 ad=0.0588 pd=0.7 as=0.0588 ps=0.7 w=0.42 l=0.15
X30 X a_110_47# VPWR VPB sky130_fd_pr__pfet_01v8_hvt ad=0.14 pd=1.28 as=0.14 ps=1.28 w=1 l=0.15
X31 X a_110_47# VPWR VPB sky130_fd_pr__pfet_01v8_hvt ad=0.14 pd=1.28 as=0.14 ps=1.28 w=1 l=0.15
X32 X a_110_47# VGND VNB sky130_fd_pr__nfet_01v8 ad=0.0588 pd=0.7 as=0.0588 ps=0.7 w=0.42 l=0.15
X33 VPWR a_110_47# X VPB sky130_fd_pr__pfet_01v8_hvt ad=0.14 pd=1.28 as=0.14 ps=1.28 w=1 l=0.15
X34 X a_110_47# VPWR VPB sky130_fd_pr__pfet_01v8_hvt ad=0.14 pd=1.28 as=0.14 ps=1.28 w=1 l=0.15
X35 X a_110_47# VGND VNB sky130_fd_pr__nfet_01v8 ad=0.0588 pd=0.7 as=0.0588 ps=0.7 w=0.42 l=0.15
X36 X a_110_47# VGND VNB sky130_fd_pr__nfet_01v8 ad=0.0588 pd=0.7 as=0.0588 ps=0.7 w=0.42 l=0.15
X37 X a_110_47# VGND VNB sky130_fd_pr__nfet_01v8 ad=0.0588 pd=0.7 as=0.0588 ps=0.7 w=0.42 l=0.15
X38 X a_110_47# VGND VNB sky130_fd_pr__nfet_01v8 ad=0.0588 pd=0.7 as=0.0588 ps=0.7 w=0.42 l=0.15
X39 X a_110_47# VGND VNB sky130_fd_pr__nfet_01v8 ad=0.0588 pd=0.7 as=0.05775 ps=0.695 w=0.42 l=0.15
.ends

.subckt sky130_fd_sc_hd__clkdlybuf4s25_1 VNB VPB VPWR VGND A X
X0 a_244_47# a_27_47# VPWR VPB sky130_fd_pr__pfet_01v8_hvt ad=0.2173 pd=2.17 as=0.19265 ps=1.415 w=0.82 l=0.25
X1 VPWR a_244_47# a_355_47# VPB sky130_fd_pr__pfet_01v8_hvt ad=0.2726 pd=1.61 as=0.2173 ps=2.17 w=0.82 l=0.25
X2 X a_355_47# VPWR VPB sky130_fd_pr__pfet_01v8_hvt ad=0.495 pd=2.99 as=0.2726 ps=1.61 w=1 l=0.15
X3 VPWR A a_27_47# VPB sky130_fd_pr__pfet_01v8_hvt ad=0.19265 pd=1.415 as=0.27 ps=2.54 w=1 l=0.15
X4 VGND A a_27_47# VNB sky130_fd_pr__nfet_01v8 ad=0.1228 pd=1.065 as=0.1134 ps=1.38 w=0.42 l=0.15
X5 VGND a_244_47# a_355_47# VNB sky130_fd_pr__nfet_01v8 ad=0.1856 pd=1.26 as=0.17225 ps=1.83 w=0.65 l=0.25
X6 X a_355_47# VGND VNB sky130_fd_pr__nfet_01v8 ad=0.2079 pd=1.83 as=0.1856 ps=1.26 w=0.42 l=0.15
X7 a_244_47# a_27_47# VGND VNB sky130_fd_pr__nfet_01v8 ad=0.17225 pd=1.83 as=0.1228 ps=1.065 w=0.65 l=0.25
.ends

.subckt sky130_fd_sc_hd__dfrtp_2 VGND VPWR VPB VNB CLK D RESET_B Q
X0 a_805_47# a_761_289# a_639_47# VNB sky130_fd_pr__nfet_01v8 ad=0.0441 pd=0.63 as=0.1401 ps=1.1 w=0.42 l=0.15
X1 a_1217_47# a_27_47# a_1108_47# VNB sky130_fd_pr__special_nfet_01v8 ad=0.0669 pd=0.75 as=0.0711 ps=0.755 w=0.36 l=0.15
X2 VGND a_1283_21# Q VNB sky130_fd_pr__nfet_01v8 ad=0.169 pd=1.82 as=0.08775 ps=0.92 w=0.65 l=0.15
X3 a_1283_21# a_1108_47# a_1462_47# VNB sky130_fd_pr__nfet_01v8 ad=0.1092 pd=1.36 as=0.06405 ps=0.725 w=0.42 l=0.15
X4 a_651_413# a_27_47# a_543_47# VPB sky130_fd_pr__pfet_01v8_hvt ad=0.1155 pd=0.97 as=0.07245 ps=0.765 w=0.42 l=0.15
X5 VPWR a_1283_21# Q VPB sky130_fd_pr__pfet_01v8_hvt ad=0.26 pd=2.52 as=0.135 ps=1.27 w=1 l=0.15
X6 a_1108_47# a_193_47# a_761_289# VNB sky130_fd_pr__special_nfet_01v8 ad=0.0711 pd=0.755 as=0.0999 ps=0.985 w=0.36 l=0.15
X7 VGND RESET_B a_805_47# VNB sky130_fd_pr__nfet_01v8 ad=0.1346 pd=1.15 as=0.0441 ps=0.63 w=0.42 l=0.15
X8 Q a_1283_21# VPWR VPB sky130_fd_pr__pfet_01v8_hvt ad=0.135 pd=1.27 as=0.3012 ps=2.66 w=1 l=0.15
X9 VPWR CLK a_27_47# VPB sky130_fd_pr__pfet_01v8_hvt ad=0.0864 pd=0.91 as=0.1664 ps=1.8 w=0.64 l=0.15
X10 a_448_47# D VPWR VPB sky130_fd_pr__pfet_01v8_hvt ad=0.0651 pd=0.73 as=0.1092 ps=1.36 w=0.42 l=0.15
X11 a_761_289# a_543_47# VGND VNB sky130_fd_pr__nfet_01v8 ad=0.0999 pd=0.985 as=0.1346 ps=1.15 w=0.64 l=0.15
X12 a_193_47# a_27_47# VGND VNB sky130_fd_pr__nfet_01v8 ad=0.1092 pd=1.36 as=0.0567 ps=0.69 w=0.42 l=0.15
X13 a_1108_47# a_27_47# a_761_289# VPB sky130_fd_pr__pfet_01v8_hvt ad=0.0588 pd=0.7 as=0.12915 ps=1.185 w=0.42 l=0.15
X14 a_1462_47# RESET_B VGND VNB sky130_fd_pr__nfet_01v8 ad=0.06405 pd=0.725 as=0.12495 ps=1.015 w=0.42 l=0.15
X15 a_543_47# a_27_47# a_448_47# VNB sky130_fd_pr__special_nfet_01v8 ad=0.0594 pd=0.69 as=0.066 ps=0.745 w=0.36 l=0.15
X16 a_543_47# a_193_47# a_448_47# VPB sky130_fd_pr__pfet_01v8_hvt ad=0.07245 pd=0.765 as=0.0651 ps=0.73 w=0.42 l=0.15
X17 a_448_47# D VGND VNB sky130_fd_pr__nfet_01v8 ad=0.066 pd=0.745 as=0.2205 ps=1.89 w=0.42 l=0.15
X18 VPWR a_1283_21# a_1270_413# VPB sky130_fd_pr__pfet_01v8_hvt ad=0.0819 pd=0.81 as=0.0567 ps=0.69 w=0.42 l=0.15
X19 VPWR a_1108_47# a_1283_21# VPB sky130_fd_pr__pfet_01v8_hvt ad=0.1134 pd=1.38 as=0.0567 ps=0.69 w=0.42 l=0.15
X20 a_1270_413# a_193_47# a_1108_47# VPB sky130_fd_pr__pfet_01v8_hvt ad=0.0567 pd=0.69 as=0.0588 ps=0.7 w=0.42 l=0.15
X21 a_193_47# a_27_47# VPWR VPB sky130_fd_pr__pfet_01v8_hvt ad=0.1664 pd=1.8 as=0.0864 ps=0.91 w=0.64 l=0.15
X22 a_1283_21# RESET_B VPWR VPB sky130_fd_pr__pfet_01v8_hvt ad=0.0567 pd=0.69 as=0.0819 ps=0.81 w=0.42 l=0.15
X23 VPWR a_761_289# a_651_413# VPB sky130_fd_pr__pfet_01v8_hvt ad=0.07035 pd=0.755 as=0.1155 ps=0.97 w=0.42 l=0.15
X24 Q a_1283_21# VGND VNB sky130_fd_pr__nfet_01v8 ad=0.08775 pd=0.92 as=0.2087 ps=2.02 w=0.65 l=0.15
X25 a_639_47# a_193_47# a_543_47# VNB sky130_fd_pr__special_nfet_01v8 ad=0.1401 pd=1.1 as=0.0594 ps=0.69 w=0.36 l=0.15
X26 VGND a_1283_21# a_1217_47# VNB sky130_fd_pr__nfet_01v8 ad=0.12495 pd=1.015 as=0.0669 ps=0.75 w=0.42 l=0.15
X27 a_651_413# RESET_B VPWR VPB sky130_fd_pr__pfet_01v8_hvt ad=0.1092 pd=1.36 as=0.07035 ps=0.755 w=0.42 l=0.15
X28 VGND CLK a_27_47# VNB sky130_fd_pr__nfet_01v8 ad=0.0567 pd=0.69 as=0.1092 ps=1.36 w=0.42 l=0.15
X29 a_761_289# a_543_47# VPWR VPB sky130_fd_pr__pfet_01v8_hvt ad=0.12915 pd=1.185 as=0.2184 ps=2.2 w=0.84 l=0.15
.ends

.subckt misfit01_core clk ena inv_a inv_y ui_in[1] ui_in[2] ui_in[3] ui_in[4] ui_in[5]
+ ui_in[6] ui_in[7] uio_in[0] uio_in[1] uio_in[2] uio_in[3] uio_in[4] uio_in[5] uio_in[6]
+ uio_in[7] uio_oe[1] uio_oe[3] uio_oe[4] uio_oe[6] uio_out[1] uio_out[4] uio_out[6]
+ uio_out[7] uo_out[1] uo_out[3] uo_out[4] uo_out[6] ui_in[0] uo_out[0] uio_oe[0]
+ uio_out[3] uio_out[0] uio_oe[5] uo_out[5] uio_oe[2] uo_out[7] uo_out[2] uio_out[5]
+ uio_out[2] rst_n uio_oe[7] VPWR VGND
XFILLER_22_177 VPWR VGND VPWR VGND sky130_fd_sc_hd__decap_3
XFILLER_22_144 VPWR VGND VPWR VGND sky130_fd_sc_hd__decap_3
XFILLER_22_133 VPWR VGND VPWR VGND sky130_fd_sc_hd__decap_3
XFILLER_22_100 VPWR VGND VPWR VGND sky130_fd_sc_hd__decap_3
XFILLER_13_122 VPWR VGND VPWR VGND sky130_fd_sc_hd__decap_3
XFILLER_13_199 VPWR VGND VPWR VGND sky130_fd_sc_hd__decap_3
XFILLER_13_155 VPWR VGND VPWR VGND sky130_fd_sc_hd__decap_3
XFILLER_9_137 VPWR VGND VPWR VGND sky130_fd_sc_hd__decap_3
XFILLER_3_45 VPWR VGND VPWR VGND sky130_fd_sc_hd__decap_3
XFILLER_3_12 VPWR VGND VPWR VGND sky130_fd_sc_hd__decap_3
XFILLER_5_332 VPWR VGND VPWR VGND sky130_fd_sc_hd__decap_3
XFILLER_3_78 VPWR VGND VPWR VGND sky130_fd_sc_hd__decap_3
XFILLER_8_192 VPWR VGND VPWR VGND sky130_fd_sc_hd__decap_3
XFILLER_6_118 VPWR VGND VPWR VGND sky130_fd_sc_hd__decap_3
XFILLER_10_103 VPWR VGND VPWR VGND sky130_fd_sc_hd__decap_3
XFILLER_10_136 VPWR VGND VPWR VGND sky130_fd_sc_hd__decap_3
XFILLER_10_147 VPWR VGND VPWR VGND sky130_fd_sc_hd__decap_3
XFILLER_12_21 VPWR VGND VPWR VGND sky130_fd_sc_hd__decap_3
XFILLER_12_32 VPWR VGND VPWR VGND sky130_fd_sc_hd__decap_3
XFILLER_2_324 VPWR VGND VPWR VGND sky130_fd_sc_hd__decap_3
XFILLER_12_65 VPWR VGND VPWR VGND sky130_fd_sc_hd__decap_3
XFILLER_18_236 VPWR VGND VPWR VGND sky130_fd_sc_hd__decap_3
XFILLER_18_203 VPWR VGND VPWR VGND sky130_fd_sc_hd__decap_3
XFILLER_5_140 VPWR VGND VPWR VGND sky130_fd_sc_hd__decap_3
XFILLER_5_184 VPWR VGND VPWR VGND sky130_fd_sc_hd__decap_3
XFILLER_15_228 VPWR VGND VPWR VGND sky130_fd_sc_hd__decap_3
XFILLER_15_217 VPWR VGND VPWR VGND sky130_fd_sc_hd__decap_3
XFILLER_23_64 VPWR VGND VPWR VGND sky130_fd_sc_hd__decap_3
XFILLER_23_53 VPWR VGND VPWR VGND sky130_fd_sc_hd__decap_3
XFILLER_2_165 VPWR VGND VPWR VGND sky130_fd_sc_hd__decap_3
XFILLER_2_121 VPWR VGND VPWR VGND sky130_fd_sc_hd__decap_3
XFILLER_17_9 VPWR VGND VPWR VGND sky130_fd_sc_hd__decap_3
XFILLER_0_24 VPWR VGND VPWR VGND sky130_fd_sc_hd__decap_3
XFILLER_0_35 VPWR VGND VPWR VGND sky130_fd_sc_hd__decap_3
XFILLER_0_57 VPWR VGND VPWR VGND sky130_fd_sc_hd__decap_3
XFILLER_0_68 VPWR VGND VPWR VGND sky130_fd_sc_hd__decap_3
XFILLER_14_283 VPWR VGND VPWR VGND sky130_fd_sc_hd__decap_3
XFILLER_9_33 VPWR VGND VPWR VGND sky130_fd_sc_hd__decap_3
XFILLER_9_66 VPWR VGND VPWR VGND sky130_fd_sc_hd__decap_3
XFILLER_9_99 VPWR VGND VPWR VGND sky130_fd_sc_hd__decap_3
XFILLER_12_209 VPWR VGND VPWR VGND sky130_fd_sc_hd__decap_3
XFILLER_20_286 VPWR VGND VPWR VGND sky130_fd_sc_hd__decap_3
XFILLER_20_253 VPWR VGND VPWR VGND sky130_fd_sc_hd__decap_3
XFILLER_20_242 VPWR VGND VPWR VGND sky130_fd_sc_hd__decap_3
XFILLER_18_97 VPWR VGND VPWR VGND sky130_fd_sc_hd__decap_3
XFILLER_18_53 VPWR VGND VPWR VGND sky130_fd_sc_hd__decap_3
XFILLER_7_202 VPWR VGND VPWR VGND sky130_fd_sc_hd__decap_3
XFILLER_11_220 VPWR VGND VPWR VGND sky130_fd_sc_hd__decap_3
XFILLER_11_231 VPWR VGND VPWR VGND sky130_fd_sc_hd__decap_3
XFILLER_11_264 VPWR VGND VPWR VGND sky130_fd_sc_hd__decap_3
XFILLER_7_246 VPWR VGND VPWR VGND sky130_fd_sc_hd__decap_3
XFILLER_19_320 VPWR VGND VPWR VGND sky130_fd_sc_hd__decap_3
XFILLER_15_6 VPWR VGND VPWR VGND sky130_fd_sc_hd__decap_3
XPHY_EDGE_ROW_12_Left_36 VPWR VGND VPWR VGND sky130_fd_sc_hd__decap_3
XFILLER_20_65 VPWR VGND VPWR VGND sky130_fd_sc_hd__decap_3
XFILLER_20_32 VPWR VGND VPWR VGND sky130_fd_sc_hd__decap_3
XFILLER_20_21 VPWR VGND VPWR VGND sky130_fd_sc_hd__decap_3
XFILLER_4_227 VPWR VGND VPWR VGND sky130_fd_sc_hd__decap_3
XFILLER_16_312 VPWR VGND VPWR VGND sky130_fd_sc_hd__decap_3
XFILLER_16_301 VPWR VGND VPWR VGND sky130_fd_sc_hd__decap_3
XFILLER_6_12 VPWR VGND VPWR VGND sky130_fd_sc_hd__decap_3
XFILLER_3_293 VPWR VGND VPWR VGND sky130_fd_sc_hd__decap_3
XFILLER_6_56 VPWR VGND VPWR VGND sky130_fd_sc_hd__decap_3
XFILLER_19_172 VPWR VGND VPWR VGND sky130_fd_sc_hd__decap_3
XFILLER_19_161 VPWR VGND VPWR VGND sky130_fd_sc_hd__decap_3
XFILLER_13_3 VPWR VGND VPWR VGND sky130_fd_sc_hd__decap_3
XFILLER_22_315 VPWR VGND VPWR VGND sky130_fd_sc_hd__decap_3
XFILLER_1_208 VPWR VGND VPWR VGND sky130_fd_sc_hd__decap_3
XFILLER_15_21 VPWR VGND VPWR VGND sky130_fd_sc_hd__decap_3
XFILLER_15_87 VPWR VGND VPWR VGND sky130_fd_sc_hd__decap_3
XFILLER_13_326 VPWR VGND VPWR VGND sky130_fd_sc_hd__decap_3
XFILLER_9_308 VPWR VGND VPWR VGND sky130_fd_sc_hd__decap_3
XFILLER_0_296 VPWR VGND VPWR VGND sky130_fd_sc_hd__decap_3
XFILLER_0_274 VPWR VGND VPWR VGND sky130_fd_sc_hd__decap_3
XFILLER_16_197 VPWR VGND VPWR VGND sky130_fd_sc_hd__decap_3
XFILLER_16_186 VPWR VGND VPWR VGND sky130_fd_sc_hd__decap_3
XFILLER_16_153 VPWR VGND VPWR VGND sky130_fd_sc_hd__decap_3
XFILLER_8_330 VPWR VGND VPWR VGND sky130_fd_sc_hd__decap_3
XFILLER_22_156 VPWR VGND VPWR VGND sky130_fd_sc_hd__decap_3
XFILLER_22_112 VPWR VGND VPWR VGND sky130_fd_sc_hd__decap_3
XFILLER_10_318 VPWR VGND VPWR VGND sky130_fd_sc_hd__decap_3
XFILLER_13_134 VPWR VGND VPWR VGND sky130_fd_sc_hd__decap_3
XFILLER_9_105 VPWR VGND VPWR VGND sky130_fd_sc_hd__decap_3
XFILLER_9_116 VPWR VGND VPWR VGND sky130_fd_sc_hd__decap_3
XFILLER_13_178 VPWR VGND VPWR VGND sky130_fd_sc_hd__decap_3
XFILLER_5_311 VPWR VGND VPWR VGND sky130_fd_sc_hd__decap_3
XFILLER_9_149 VPWR VGND VPWR VGND sky130_fd_sc_hd__decap_3
XFILLER_3_57 VPWR VGND VPWR VGND sky130_fd_sc_hd__decap_3
XFILLER_3_24 VPWR VGND VPWR VGND sky130_fd_sc_hd__decap_3
XFILLER_8_171 VPWR VGND VPWR VGND sky130_fd_sc_hd__decap_3
XFILLER_10_115 VPWR VGND VPWR VGND sky130_fd_sc_hd__decap_3
XFILLER_10_159 VPWR VGND VPWR VGND sky130_fd_sc_hd__decap_3
XFILLER_12_44 VPWR VGND VPWR VGND sky130_fd_sc_hd__decap_3
XFILLER_12_77 VPWR VGND VPWR VGND sky130_fd_sc_hd__decap_3
XFILLER_12_88 VPWR VGND VPWR VGND sky130_fd_sc_hd__decap_3
XPHY_EDGE_ROW_0_Left_24 VPWR VGND VPWR VGND sky130_fd_sc_hd__decap_3
XFILLER_18_259 VPWR VGND VPWR VGND sky130_fd_sc_hd__decap_3
XFILLER_18_248 VPWR VGND VPWR VGND sky130_fd_sc_hd__decap_3
XFILLER_18_215 VPWR VGND VPWR VGND sky130_fd_sc_hd__decap_3
XFILLER_5_152 VPWR VGND VPWR VGND sky130_fd_sc_hd__decap_3
XFILLER_5_196 VPWR VGND VPWR VGND sky130_fd_sc_hd__decap_3
XFILLER_17_281 VPWR VGND VPWR VGND sky130_fd_sc_hd__decap_3
XFILLER_17_270 VPWR VGND VPWR VGND sky130_fd_sc_hd__decap_3
XPHY_EDGE_ROW_12_Right_12 VPWR VGND VPWR VGND sky130_fd_sc_hd__decap_3
XPHY_EDGE_ROW_21_Right_21 VPWR VGND VPWR VGND sky130_fd_sc_hd__decap_3
XFILLER_23_284 VPWR VGND VPWR VGND sky130_fd_sc_hd__decap_3
XFILLER_23_262 VPWR VGND VPWR VGND sky130_fd_sc_hd__decap_3
XFILLER_23_32 VPWR VGND VPWR VGND sky130_fd_sc_hd__decap_3
XFILLER_23_21 VPWR VGND VPWR VGND sky130_fd_sc_hd__decap_3
XFILLER_23_76 VPWR VGND VPWR VGND sky130_fd_sc_hd__decap_3
XFILLER_2_100 VPWR VGND VPWR VGND sky130_fd_sc_hd__decap_3
XFILLER_2_177 VPWR VGND VPWR VGND sky130_fd_sc_hd__decap_3
XFILLER_2_144 VPWR VGND VPWR VGND sky130_fd_sc_hd__decap_3
XFILLER_2_133 VPWR VGND VPWR VGND sky130_fd_sc_hd__decap_3
XFILLER_0_47 VPWR VGND VPWR VGND sky130_fd_sc_hd__decap_3
XFILLER_9_12 VPWR VGND VPWR VGND sky130_fd_sc_hd__decap_3
Xmisfit01_core_4 uio_oe[4] misfit01_core_4/HI VPWR VGND VGND VPWR sky130_fd_sc_hd__conb_1
XFILLER_14_295 VPWR VGND VPWR VGND sky130_fd_sc_hd__decap_3
XFILLER_14_262 VPWR VGND VPWR VGND sky130_fd_sc_hd__decap_3
XFILLER_9_45 VPWR VGND VPWR VGND sky130_fd_sc_hd__decap_3
XFILLER_9_78 VPWR VGND VPWR VGND sky130_fd_sc_hd__decap_3
XFILLER_20_221 VPWR VGND VPWR VGND sky130_fd_sc_hd__decap_3
XFILLER_20_298 VPWR VGND VPWR VGND sky130_fd_sc_hd__decap_3
XFILLER_20_265 VPWR VGND VPWR VGND sky130_fd_sc_hd__decap_3
XFILLER_18_65 VPWR VGND VPWR VGND sky130_fd_sc_hd__decap_3
XFILLER_18_32 VPWR VGND VPWR VGND sky130_fd_sc_hd__decap_3
XFILLER_18_21 VPWR VGND VPWR VGND sky130_fd_sc_hd__decap_3
XFILLER_7_214 VPWR VGND VPWR VGND sky130_fd_sc_hd__decap_3
XFILLER_7_225 VPWR VGND VPWR VGND sky130_fd_sc_hd__decap_3
XFILLER_11_243 VPWR VGND VPWR VGND sky130_fd_sc_hd__decap_3
XFILLER_11_276 VPWR VGND VPWR VGND sky130_fd_sc_hd__decap_3
XFILLER_11_287 VPWR VGND VPWR VGND sky130_fd_sc_hd__decap_3
XFILLER_7_258 VPWR VGND VPWR VGND sky130_fd_sc_hd__decap_3
XFILLER_19_332 VPWR VGND VPWR VGND sky130_fd_sc_hd__decap_3
XFILLER_6_280 VPWR VGND VPWR VGND sky130_fd_sc_hd__decap_3
XFILLER_1_90 VPWR VGND VPWR VGND sky130_fd_sc_hd__decap_3
XFILLER_20_88 VPWR VGND VPWR VGND sky130_fd_sc_hd__decap_3
XFILLER_20_77 VPWR VGND VPWR VGND sky130_fd_sc_hd__decap_3
XFILLER_20_44 VPWR VGND VPWR VGND sky130_fd_sc_hd__decap_3
XFILLER_4_206 VPWR VGND VPWR VGND sky130_fd_sc_hd__decap_3
XFILLER_4_239 VPWR VGND VPWR VGND sky130_fd_sc_hd__decap_3
XFILLER_16_324 VPWR VGND VPWR VGND sky130_fd_sc_hd__decap_3
XFILLER_6_24 VPWR VGND VPWR VGND sky130_fd_sc_hd__decap_3
XFILLER_6_35 VPWR VGND VPWR VGND sky130_fd_sc_hd__decap_3
XFILLER_3_261 VPWR VGND VPWR VGND sky130_fd_sc_hd__decap_3
XFILLER_6_68 VPWR VGND VPWR VGND sky130_fd_sc_hd__decap_3
XFILLER_19_184 VPWR VGND VPWR VGND sky130_fd_sc_hd__decap_3
XFILLER_19_140 VPWR VGND VPWR VGND sky130_fd_sc_hd__decap_3
XFILLER_22_327 VPWR VGND VPWR VGND sky130_fd_sc_hd__decap_3
XPHY_EDGE_ROW_6_Right_6 VPWR VGND VPWR VGND sky130_fd_sc_hd__decap_3
XFILLER_15_66 VPWR VGND VPWR VGND sky130_fd_sc_hd__decap_3
XFILLER_15_33 VPWR VGND VPWR VGND sky130_fd_sc_hd__decap_3
XFILLER_13_305 VPWR VGND VPWR VGND sky130_fd_sc_hd__decap_3
XFILLER_15_99 VPWR VGND VPWR VGND sky130_fd_sc_hd__decap_3
XFILLER_0_253 VPWR VGND VPWR VGND sky130_fd_sc_hd__decap_3
XFILLER_0_231 VPWR VGND VPWR VGND sky130_fd_sc_hd__decap_3
XFILLER_16_121 VPWR VGND VPWR VGND sky130_fd_sc_hd__decap_3
XFILLER_16_165 VPWR VGND VPWR VGND sky130_fd_sc_hd__decap_3
XFILLER_22_124 VPWR VGND VPWR VGND sky130_fd_sc_hd__decap_3
XFILLER_22_168 VPWR VGND VPWR VGND sky130_fd_sc_hd__decap_3
XFILLER_7_9 VPWR VGND VPWR VGND sky130_fd_sc_hd__decap_3
XFILLER_13_146 VPWR VGND VPWR VGND sky130_fd_sc_hd__decap_3
XFILLER_13_113 VPWR VGND VPWR VGND sky130_fd_sc_hd__decap_3
XFILLER_13_102 VPWR VGND VPWR VGND sky130_fd_sc_hd__decap_3
XFILLER_9_128 VPWR VGND VPWR VGND sky130_fd_sc_hd__decap_3
XFILLER_5_323 VPWR VGND VPWR VGND sky130_fd_sc_hd__decap_3
XFILLER_3_36 VPWR VGND VPWR VGND sky130_fd_sc_hd__decap_3
XFILLER_3_69 VPWR VGND VPWR VGND sky130_fd_sc_hd__decap_3
XFILLER_8_150 VPWR VGND VPWR VGND sky130_fd_sc_hd__decap_3
XFILLER_8_183 VPWR VGND VPWR VGND sky130_fd_sc_hd__decap_3
XFILLER_2_304 VPWR VGND VPWR VGND sky130_fd_sc_hd__decap_3
XFILLER_6_109 VPWR VGND VPWR VGND sky130_fd_sc_hd__decap_3
XFILLER_10_127 VPWR VGND VPWR VGND sky130_fd_sc_hd__decap_3
XFILLER_12_12 VPWR VGND VPWR VGND sky130_fd_sc_hd__decap_3
XFILLER_12_56 VPWR VGND VPWR VGND sky130_fd_sc_hd__decap_3
XFILLER_2_315 VPWR VGND VPWR VGND sky130_fd_sc_hd__decap_3
XFILLER_5_6 VPWR VGND VPWR VGND sky130_fd_sc_hd__decap_3
XFILLER_18_227 VPWR VGND VPWR VGND sky130_fd_sc_hd__decap_3
XFILLER_5_131 VPWR VGND VPWR VGND sky130_fd_sc_hd__decap_3
XFILLER_5_164 VPWR VGND VPWR VGND sky130_fd_sc_hd__decap_3
XFILLER_5_175 VPWR VGND VPWR VGND sky130_fd_sc_hd__decap_3
XFILLER_17_293 VPWR VGND VPWR VGND sky130_fd_sc_hd__decap_3
XFILLER_15_208 VPWR VGND VPWR VGND sky130_fd_sc_hd__decap_3
XFILLER_23_274 VPWR VGND VPWR VGND sky130_fd_sc_hd__decap_3
XFILLER_23_88 VPWR VGND VPWR VGND sky130_fd_sc_hd__decap_3
XFILLER_23_44 VPWR VGND VPWR VGND sky130_fd_sc_hd__decap_3
XFILLER_3_3 VPWR VGND VPWR VGND sky130_fd_sc_hd__decap_3
XFILLER_2_156 VPWR VGND VPWR VGND sky130_fd_sc_hd__decap_3
XFILLER_2_112 VPWR VGND VPWR VGND sky130_fd_sc_hd__decap_3
XFILLER_2_189 VPWR VGND VPWR VGND sky130_fd_sc_hd__decap_3
XFILLER_0_15 VPWR VGND VPWR VGND sky130_fd_sc_hd__decap_3
XFILLER_14_274 VPWR VGND VPWR VGND sky130_fd_sc_hd__decap_3
XFILLER_14_230 VPWR VGND VPWR VGND sky130_fd_sc_hd__decap_3
XFILLER_9_24 VPWR VGND VPWR VGND sky130_fd_sc_hd__decap_3
Xmisfit01_core_5 uio_oe[5] misfit01_core_5/HI VPWR VGND VGND VPWR sky130_fd_sc_hd__conb_1
XFILLER_9_57 VPWR VGND VPWR VGND sky130_fd_sc_hd__decap_3
XFILLER_20_233 VPWR VGND VPWR VGND sky130_fd_sc_hd__decap_3
XFILLER_20_200 VPWR VGND VPWR VGND sky130_fd_sc_hd__decap_3
XFILLER_20_277 VPWR VGND VPWR VGND sky130_fd_sc_hd__decap_3
XFILLER_18_44 VPWR VGND VPWR VGND sky130_fd_sc_hd__decap_3
XFILLER_18_88 VPWR VGND VPWR VGND sky130_fd_sc_hd__decap_3
XFILLER_18_77 VPWR VGND VPWR VGND sky130_fd_sc_hd__decap_3
XFILLER_7_237 VPWR VGND VPWR VGND sky130_fd_sc_hd__decap_3
XFILLER_11_211 VPWR VGND VPWR VGND sky130_fd_sc_hd__decap_3
XFILLER_11_255 VPWR VGND VPWR VGND sky130_fd_sc_hd__decap_3
XFILLER_11_299 VPWR VGND VPWR VGND sky130_fd_sc_hd__decap_3
XFILLER_22_9 VPWR VGND VPWR VGND sky130_fd_sc_hd__decap_3
XFILLER_19_311 VPWR VGND VPWR VGND sky130_fd_sc_hd__decap_3
XFILLER_6_292 VPWR VGND VPWR VGND sky130_fd_sc_hd__decap_3
XFILLER_20_56 VPWR VGND VPWR VGND sky130_fd_sc_hd__decap_3
XFILLER_20_12 VPWR VGND VPWR VGND sky130_fd_sc_hd__decap_3
XFILLER_4_218 VPWR VGND VPWR VGND sky130_fd_sc_hd__decap_3
XFILLER_6_47 VPWR VGND VPWR VGND sky130_fd_sc_hd__decap_3
XFILLER_20_6 VPWR VGND VPWR VGND sky130_fd_sc_hd__decap_3
XFILLER_3_240 VPWR VGND VPWR VGND sky130_fd_sc_hd__decap_3
XFILLER_3_273 VPWR VGND VPWR VGND sky130_fd_sc_hd__decap_3
XFILLER_3_284 VPWR VGND VPWR VGND sky130_fd_sc_hd__decap_3
XFILLER_19_196 VPWR VGND VPWR VGND sky130_fd_sc_hd__decap_3
XFILLER_19_152 VPWR VGND VPWR VGND sky130_fd_sc_hd__decap_3
XFILLER_15_78 VPWR VGND VPWR VGND sky130_fd_sc_hd__decap_3
XFILLER_15_45 VPWR VGND VPWR VGND sky130_fd_sc_hd__decap_3
XFILLER_15_12 VPWR VGND VPWR VGND sky130_fd_sc_hd__decap_3
XFILLER_13_317 VPWR VGND VPWR VGND sky130_fd_sc_hd__decap_3
XFILLER_0_287 VPWR VGND VPWR VGND sky130_fd_sc_hd__decap_3
XFILLER_0_265 VPWR VGND VPWR VGND sky130_fd_sc_hd__decap_3
XFILLER_0_243 VPWR VGND VPWR VGND sky130_fd_sc_hd__decap_3
XFILLER_0_221 VPWR VGND VPWR VGND sky130_fd_sc_hd__decap_3
XFILLER_16_144 VPWR VGND VPWR VGND sky130_fd_sc_hd__decap_3
XFILLER_16_133 VPWR VGND VPWR VGND sky130_fd_sc_hd__decap_3
XFILLER_16_100 VPWR VGND VPWR VGND sky130_fd_sc_hd__decap_3
XFILLER_16_177 VPWR VGND VPWR VGND sky130_fd_sc_hd__decap_3
XFILLER_8_321 VPWR VGND VPWR VGND sky130_fd_sc_hd__decap_3
XFILLER_22_147 VPWR VGND VPWR VGND sky130_fd_sc_hd__decap_3
XFILLER_22_136 VPWR VGND VPWR VGND sky130_fd_sc_hd__decap_3
XFILLER_22_103 VPWR VGND VPWR VGND sky130_fd_sc_hd__decap_3
XFILLER_7_90 VPWR VGND VPWR VGND sky130_fd_sc_hd__decap_3
XFILLER_10_309 VPWR VGND VPWR VGND sky130_fd_sc_hd__decap_3
XFILLER_13_169 VPWR VGND VPWR VGND sky130_fd_sc_hd__decap_3
XFILLER_13_158 VPWR VGND VPWR VGND sky130_fd_sc_hd__decap_3
XFILLER_13_125 VPWR VGND VPWR VGND sky130_fd_sc_hd__decap_3
XFILLER_5_302 VPWR VGND VPWR VGND sky130_fd_sc_hd__decap_3
XFILLER_3_48 VPWR VGND VPWR VGND sky130_fd_sc_hd__decap_3
XFILLER_3_15 VPWR VGND VPWR VGND sky130_fd_sc_hd__decap_3
XFILLER_8_162 VPWR VGND VPWR VGND sky130_fd_sc_hd__decap_3
XFILLER_12_180 VPWR VGND VPWR VGND sky130_fd_sc_hd__decap_3
XFILLER_10_106 VPWR VGND VPWR VGND sky130_fd_sc_hd__decap_3
XFILLER_2_327 VPWR VGND VPWR VGND sky130_fd_sc_hd__decap_3
XFILLER_12_24 VPWR VGND VPWR VGND sky130_fd_sc_hd__decap_3
XFILLER_12_35 VPWR VGND VPWR VGND sky130_fd_sc_hd__decap_3
XFILLER_12_68 VPWR VGND VPWR VGND sky130_fd_sc_hd__decap_3
XFILLER_18_206 VPWR VGND VPWR VGND sky130_fd_sc_hd__decap_3
XFILLER_18_239 VPWR VGND VPWR VGND sky130_fd_sc_hd__decap_3
XFILLER_5_143 VPWR VGND VPWR VGND sky130_fd_sc_hd__decap_3
XFILLER_5_187 VPWR VGND VPWR VGND sky130_fd_sc_hd__decap_3
XFILLER_17_261 VPWR VGND VPWR VGND sky130_fd_sc_hd__decap_3
XFILLER_4_80 VPWR VGND VPWR VGND sky130_fd_sc_hd__decap_3
XFILLER_4_91 VPWR VGND VPWR VGND sky130_fd_sc_hd__decap_3
XFILLER_23_253 VPWR VGND VPWR VGND sky130_fd_sc_hd__decap_3
XFILLER_23_12 VPWR VGND VPWR VGND sky130_fd_sc_hd__decap_3
XFILLER_2_168 VPWR VGND VPWR VGND sky130_fd_sc_hd__decap_3
XFILLER_2_124 VPWR VGND VPWR VGND sky130_fd_sc_hd__decap_3
XFILLER_0_38 VPWR VGND VPWR VGND sky130_fd_sc_hd__decap_3
Xmisfit01_core_6 uio_oe[6] misfit01_core_6/HI VPWR VGND VGND VPWR sky130_fd_sc_hd__conb_1
XFILLER_14_286 VPWR VGND VPWR VGND sky130_fd_sc_hd__decap_3
XFILLER_14_253 VPWR VGND VPWR VGND sky130_fd_sc_hd__decap_3
XFILLER_14_242 VPWR VGND VPWR VGND sky130_fd_sc_hd__decap_3
XFILLER_9_36 VPWR VGND VPWR VGND sky130_fd_sc_hd__decap_3
XFILLER_9_69 VPWR VGND VPWR VGND sky130_fd_sc_hd__decap_3
XFILLER_1_190 VPWR VGND VPWR VGND sky130_fd_sc_hd__decap_3
XFILLER_20_289 VPWR VGND VPWR VGND sky130_fd_sc_hd__decap_3
XFILLER_20_256 VPWR VGND VPWR VGND sky130_fd_sc_hd__decap_3
XFILLER_20_245 VPWR VGND VPWR VGND sky130_fd_sc_hd__decap_3
XFILLER_20_212 VPWR VGND VPWR VGND sky130_fd_sc_hd__decap_3
XFILLER_9_290 VPWR VGND VPWR VGND sky130_fd_sc_hd__decap_3
XFILLER_18_56 VPWR VGND VPWR VGND sky130_fd_sc_hd__decap_3
XFILLER_18_12 VPWR VGND VPWR VGND sky130_fd_sc_hd__decap_3
XFILLER_7_205 VPWR VGND VPWR VGND sky130_fd_sc_hd__decap_3
XFILLER_7_249 VPWR VGND VPWR VGND sky130_fd_sc_hd__decap_3
XFILLER_11_234 VPWR VGND VPWR VGND sky130_fd_sc_hd__decap_3
XFILLER_11_267 VPWR VGND VPWR VGND sky130_fd_sc_hd__decap_3
XFILLER_19_323 VPWR VGND VPWR VGND sky130_fd_sc_hd__decap_3
XFILLER_15_9 VPWR VGND VPWR VGND sky130_fd_sc_hd__decap_3
XFILLER_6_271 VPWR VGND VPWR VGND sky130_fd_sc_hd__decap_3
XFILLER_1_81 VPWR VGND VPWR VGND sky130_fd_sc_hd__decap_3
XFILLER_20_24 VPWR VGND VPWR VGND sky130_fd_sc_hd__decap_3
XFILLER_20_68 VPWR VGND VPWR VGND sky130_fd_sc_hd__decap_3
XFILLER_20_35 VPWR VGND VPWR VGND sky130_fd_sc_hd__decap_3
XFILLER_16_315 VPWR VGND VPWR VGND sky130_fd_sc_hd__decap_3
XFILLER_16_304 VPWR VGND VPWR VGND sky130_fd_sc_hd__decap_3
XFILLER_3_252 VPWR VGND VPWR VGND sky130_fd_sc_hd__decap_3
XFILLER_6_15 VPWR VGND VPWR VGND sky130_fd_sc_hd__decap_3
XFILLER_6_59 VPWR VGND VPWR VGND sky130_fd_sc_hd__decap_3
XFILLER_19_131 VPWR VGND VPWR VGND sky130_fd_sc_hd__decap_3
XFILLER_13_6 VPWR VGND VPWR VGND sky130_fd_sc_hd__decap_3
XFILLER_3_296 VPWR VGND VPWR VGND sky130_fd_sc_hd__decap_3
XFILLER_22_318 VPWR VGND VPWR VGND sky130_fd_sc_hd__decap_3
XFILLER_19_175 VPWR VGND VPWR VGND sky130_fd_sc_hd__decap_3
XFILLER_19_164 VPWR VGND VPWR VGND sky130_fd_sc_hd__decap_3
XFILLER_15_57 VPWR VGND VPWR VGND sky130_fd_sc_hd__decap_3
XFILLER_15_24 VPWR VGND VPWR VGND sky130_fd_sc_hd__decap_3
XFILLER_13_329 VPWR VGND VPWR VGND sky130_fd_sc_hd__decap_3
XFILLER_0_299 VPWR VGND VPWR VGND sky130_fd_sc_hd__decap_3
XFILLER_0_277 VPWR VGND VPWR VGND sky130_fd_sc_hd__decap_3
XFILLER_0_200 VPWR VGND VPWR VGND sky130_fd_sc_hd__decap_3
XFILLER_16_189 VPWR VGND VPWR VGND sky130_fd_sc_hd__decap_3
XFILLER_16_156 VPWR VGND VPWR VGND sky130_fd_sc_hd__decap_3
XFILLER_16_112 VPWR VGND VPWR VGND sky130_fd_sc_hd__decap_3
XFILLER_11_3 VPWR VGND VPWR VGND sky130_fd_sc_hd__decap_3
XFILLER_22_159 VPWR VGND VPWR VGND sky130_fd_sc_hd__decap_3
XFILLER_22_115 VPWR VGND VPWR VGND sky130_fd_sc_hd__decap_3
XFILLER_21_181 VPWR VGND VPWR VGND sky130_fd_sc_hd__decap_3
XFILLER_13_137 VPWR VGND VPWR VGND sky130_fd_sc_hd__decap_3
XFILLER_9_108 VPWR VGND VPWR VGND sky130_fd_sc_hd__decap_3
XFILLER_9_119 VPWR VGND VPWR VGND sky130_fd_sc_hd__decap_3
XFILLER_3_27 VPWR VGND VPWR VGND sky130_fd_sc_hd__decap_3
XFILLER_5_314 VPWR VGND VPWR VGND sky130_fd_sc_hd__decap_3
XFILLER_8_130 VPWR VGND VPWR VGND sky130_fd_sc_hd__decap_3
XFILLER_8_141 VPWR VGND VPWR VGND sky130_fd_sc_hd__decap_3
XFILLER_8_174 VPWR VGND VPWR VGND sky130_fd_sc_hd__decap_3
XFILLER_12_192 VPWR VGND VPWR VGND sky130_fd_sc_hd__decap_3
XPHY_EDGE_ROW_19_Left_43 VPWR VGND VPWR VGND sky130_fd_sc_hd__decap_3
XFILLER_10_118 VPWR VGND VPWR VGND sky130_fd_sc_hd__decap_3
XFILLER_12_47 VPWR VGND VPWR VGND sky130_fd_sc_hd__decap_3
XFILLER_18_218 VPWR VGND VPWR VGND sky130_fd_sc_hd__decap_3
XFILLER_5_122 VPWR VGND VPWR VGND sky130_fd_sc_hd__decap_3
XFILLER_5_155 VPWR VGND VPWR VGND sky130_fd_sc_hd__decap_3
XFILLER_5_199 VPWR VGND VPWR VGND sky130_fd_sc_hd__decap_3
XFILLER_17_273 VPWR VGND VPWR VGND sky130_fd_sc_hd__decap_3
XFILLER_17_240 VPWR VGND VPWR VGND sky130_fd_sc_hd__decap_3
XFILLER_17_284 VPWR VGND VPWR VGND sky130_fd_sc_hd__decap_3
XFILLER_23_265 VPWR VGND VPWR VGND sky130_fd_sc_hd__decap_3
XPHY_EDGE_ROW_4_Left_28 VPWR VGND VPWR VGND sky130_fd_sc_hd__decap_3
XFILLER_23_287 VPWR VGND VPWR VGND sky130_fd_sc_hd__decap_3
XFILLER_23_57 VPWR VGND VPWR VGND sky130_fd_sc_hd__decap_3
XFILLER_23_35 VPWR VGND VPWR VGND sky130_fd_sc_hd__decap_3
XFILLER_23_24 VPWR VGND VPWR VGND sky130_fd_sc_hd__decap_3
XFILLER_2_147 VPWR VGND VPWR VGND sky130_fd_sc_hd__decap_3
XFILLER_2_136 VPWR VGND VPWR VGND sky130_fd_sc_hd__decap_3
XFILLER_2_103 VPWR VGND VPWR VGND sky130_fd_sc_hd__decap_3
Xmisfit01_core_7 uio_oe[7] misfit01_core_7/HI VPWR VGND VGND VPWR sky130_fd_sc_hd__conb_1
XFILLER_14_298 VPWR VGND VPWR VGND sky130_fd_sc_hd__decap_3
XFILLER_14_265 VPWR VGND VPWR VGND sky130_fd_sc_hd__decap_3
XFILLER_14_221 VPWR VGND VPWR VGND sky130_fd_sc_hd__decap_3
XFILLER_9_15 VPWR VGND VPWR VGND sky130_fd_sc_hd__decap_3
XFILLER_9_48 VPWR VGND VPWR VGND sky130_fd_sc_hd__decap_3
XFILLER_13_90 VPWR VGND VPWR VGND sky130_fd_sc_hd__decap_3
XFILLER_20_268 VPWR VGND VPWR VGND sky130_fd_sc_hd__decap_3
XFILLER_20_224 VPWR VGND VPWR VGND sky130_fd_sc_hd__decap_3
XFILLER_18_68 VPWR VGND VPWR VGND sky130_fd_sc_hd__decap_3
XFILLER_18_35 VPWR VGND VPWR VGND sky130_fd_sc_hd__decap_3
XFILLER_18_24 VPWR VGND VPWR VGND sky130_fd_sc_hd__decap_3
XFILLER_11_202 VPWR VGND VPWR VGND sky130_fd_sc_hd__decap_3
XFILLER_11_246 VPWR VGND VPWR VGND sky130_fd_sc_hd__decap_3
XFILLER_7_217 VPWR VGND VPWR VGND sky130_fd_sc_hd__decap_3
XFILLER_7_228 VPWR VGND VPWR VGND sky130_fd_sc_hd__decap_3
XFILLER_19_302 VPWR VGND VPWR VGND sky130_fd_sc_hd__decap_3
XFILLER_6_283 VPWR VGND VPWR VGND sky130_fd_sc_hd__decap_3
XFILLER_1_60 VPWR VGND VPWR VGND sky130_fd_sc_hd__decap_3
XFILLER_1_93 VPWR VGND VPWR VGND sky130_fd_sc_hd__decap_3
XFILLER_20_47 VPWR VGND VPWR VGND sky130_fd_sc_hd__decap_3
XFILLER_4_209 VPWR VGND VPWR VGND sky130_fd_sc_hd__decap_3
XFILLER_16_327 VPWR VGND VPWR VGND sky130_fd_sc_hd__decap_3
XPHY_EDGE_ROW_7_Left_31 VPWR VGND VPWR VGND sky130_fd_sc_hd__decap_3
XFILLER_3_220 VPWR VGND VPWR VGND sky130_fd_sc_hd__decap_3
XFILLER_3_231 VPWR VGND VPWR VGND sky130_fd_sc_hd__decap_3
XFILLER_3_264 VPWR VGND VPWR VGND sky130_fd_sc_hd__decap_3
XFILLER_6_38 VPWR VGND VPWR VGND sky130_fd_sc_hd__decap_3
XFILLER_10_80 VPWR VGND VPWR VGND sky130_fd_sc_hd__decap_3
XFILLER_10_91 VPWR VGND VPWR VGND sky130_fd_sc_hd__decap_3
XFILLER_19_143 VPWR VGND VPWR VGND sky130_fd_sc_hd__decap_3
XFILLER_19_187 VPWR VGND VPWR VGND sky130_fd_sc_hd__decap_3
XFILLER_15_69 VPWR VGND VPWR VGND sky130_fd_sc_hd__decap_3
XFILLER_15_36 VPWR VGND VPWR VGND sky130_fd_sc_hd__decap_3
XFILLER_13_308 VPWR VGND VPWR VGND sky130_fd_sc_hd__decap_3
XFILLER_0_212 VPWR VGND VPWR VGND sky130_fd_sc_hd__decap_3
XFILLER_0_256 VPWR VGND VPWR VGND sky130_fd_sc_hd__decap_3
XFILLER_0_234 VPWR VGND VPWR VGND sky130_fd_sc_hd__decap_3
XPHY_EDGE_ROW_19_Right_19 VPWR VGND VPWR VGND sky130_fd_sc_hd__decap_3
XFILLER_16_168 VPWR VGND VPWR VGND sky130_fd_sc_hd__decap_3
XFILLER_16_124 VPWR VGND VPWR VGND sky130_fd_sc_hd__decap_3
XFILLER_12_330 VPWR VGND VPWR VGND sky130_fd_sc_hd__decap_3
XFILLER_8_301 VPWR VGND VPWR VGND sky130_fd_sc_hd__decap_3
XFILLER_8_312 VPWR VGND VPWR VGND sky130_fd_sc_hd__decap_3
XFILLER_21_90 VPWR VGND VPWR VGND sky130_fd_sc_hd__decap_3
XFILLER_22_127 VPWR VGND VPWR VGND sky130_fd_sc_hd__decap_3
XFILLER_15_190 VPWR VGND VPWR VGND sky130_fd_sc_hd__decap_3
XFILLER_7_81 VPWR VGND VPWR VGND sky130_fd_sc_hd__decap_3
XFILLER_13_149 VPWR VGND VPWR VGND sky130_fd_sc_hd__decap_3
XFILLER_13_116 VPWR VGND VPWR VGND sky130_fd_sc_hd__decap_3
XFILLER_13_105 VPWR VGND VPWR VGND sky130_fd_sc_hd__decap_3
XFILLER_5_326 VPWR VGND VPWR VGND sky130_fd_sc_hd__decap_3
XFILLER_3_39 VPWR VGND VPWR VGND sky130_fd_sc_hd__decap_3
XFILLER_12_171 VPWR VGND VPWR VGND sky130_fd_sc_hd__decap_3
XFILLER_8_153 VPWR VGND VPWR VGND sky130_fd_sc_hd__decap_3
XFILLER_8_186 VPWR VGND VPWR VGND sky130_fd_sc_hd__decap_3
XFILLER_8_197 VPWR VGND VPWR VGND sky130_fd_sc_hd__decap_3
XFILLER_12_15 VPWR VGND VPWR VGND sky130_fd_sc_hd__decap_3
XFILLER_12_59 VPWR VGND VPWR VGND sky130_fd_sc_hd__decap_3
XFILLER_2_318 VPWR VGND VPWR VGND sky130_fd_sc_hd__decap_3
XFILLER_5_9 VPWR VGND VPWR VGND sky130_fd_sc_hd__decap_3
XFILLER_5_134 VPWR VGND VPWR VGND sky130_fd_sc_hd__decap_3
XFILLER_5_178 VPWR VGND VPWR VGND sky130_fd_sc_hd__decap_3
XPHY_EDGE_ROW_20_Left_44 VPWR VGND VPWR VGND sky130_fd_sc_hd__decap_3
XFILLER_17_296 VPWR VGND VPWR VGND sky130_fd_sc_hd__decap_3
XFILLER_17_252 VPWR VGND VPWR VGND sky130_fd_sc_hd__decap_3
XFILLER_4_71 VPWR VGND VPWR VGND sky130_fd_sc_hd__decap_3
XFILLER_23_277 VPWR VGND VPWR VGND sky130_fd_sc_hd__decap_3
XFILLER_23_47 VPWR VGND VPWR VGND sky130_fd_sc_hd__decap_3
XFILLER_3_6 VPWR VGND VPWR VGND sky130_fd_sc_hd__decap_3
XFILLER_2_159 VPWR VGND VPWR VGND sky130_fd_sc_hd__decap_3
XFILLER_2_115 VPWR VGND VPWR VGND sky130_fd_sc_hd__decap_3
XFILLER_14_200 VPWR VGND VPWR VGND sky130_fd_sc_hd__decap_3
XFILLER_0_18 VPWR VGND VPWR VGND sky130_fd_sc_hd__decap_3
XFILLER_0_29 VPWR VGND VPWR VGND sky130_fd_sc_hd__decap_3
Xmisfit01_core_8 uio_out[0] misfit01_core_8/HI VPWR VGND VGND VPWR sky130_fd_sc_hd__conb_1
XFILLER_14_277 VPWR VGND VPWR VGND sky130_fd_sc_hd__decap_3
XFILLER_14_233 VPWR VGND VPWR VGND sky130_fd_sc_hd__decap_3
XFILLER_9_27 VPWR VGND VPWR VGND sky130_fd_sc_hd__decap_3
XFILLER_1_181 VPWR VGND VPWR VGND sky130_fd_sc_hd__decap_3
XFILLER_20_203 VPWR VGND VPWR VGND sky130_fd_sc_hd__decap_3
XFILLER_20_236 VPWR VGND VPWR VGND sky130_fd_sc_hd__decap_3
XFILLER_9_270 VPWR VGND VPWR VGND sky130_fd_sc_hd__decap_3
XFILLER_9_281 VPWR VGND VPWR VGND sky130_fd_sc_hd__decap_3
XFILLER_18_47 VPWR VGND VPWR VGND sky130_fd_sc_hd__decap_3
XFILLER_11_214 VPWR VGND VPWR VGND sky130_fd_sc_hd__decap_3
XFILLER_11_225 VPWR VGND VPWR VGND sky130_fd_sc_hd__decap_3
XFILLER_11_258 VPWR VGND VPWR VGND sky130_fd_sc_hd__decap_3
XFILLER_1_3 VPWR VGND VPWR VGND sky130_fd_sc_hd__decap_3
XFILLER_19_314 VPWR VGND VPWR VGND sky130_fd_sc_hd__decap_3
XFILLER_6_262 VPWR VGND VPWR VGND sky130_fd_sc_hd__decap_3
XFILLER_10_280 VPWR VGND VPWR VGND sky130_fd_sc_hd__decap_3
XFILLER_6_295 VPWR VGND VPWR VGND sky130_fd_sc_hd__decap_3
XFILLER_1_72 VPWR VGND VPWR VGND sky130_fd_sc_hd__decap_3
XFILLER_20_59 VPWR VGND VPWR VGND sky130_fd_sc_hd__decap_3
XFILLER_20_15 VPWR VGND VPWR VGND sky130_fd_sc_hd__decap_3
XFILLER_3_243 VPWR VGND VPWR VGND sky130_fd_sc_hd__decap_3
XFILLER_3_276 VPWR VGND VPWR VGND sky130_fd_sc_hd__decap_3
XFILLER_3_287 VPWR VGND VPWR VGND sky130_fd_sc_hd__decap_3
XFILLER_19_199 VPWR VGND VPWR VGND sky130_fd_sc_hd__decap_3
XFILLER_19_155 VPWR VGND VPWR VGND sky130_fd_sc_hd__decap_3
XFILLER_19_122 VPWR VGND VPWR VGND sky130_fd_sc_hd__decap_3
XFILLER_19_90 VPWR VGND VPWR VGND sky130_fd_sc_hd__decap_3
XFILLER_20_9 VPWR VGND VPWR VGND sky130_fd_sc_hd__decap_3
XFILLER_22_309 VPWR VGND VPWR VGND sky130_fd_sc_hd__decap_3
XFILLER_15_48 VPWR VGND VPWR VGND sky130_fd_sc_hd__decap_3
XFILLER_15_15 VPWR VGND VPWR VGND sky130_fd_sc_hd__decap_3
XFILLER_21_320 VPWR VGND VPWR VGND sky130_fd_sc_hd__decap_3
XFILLER_0_246 VPWR VGND VPWR VGND sky130_fd_sc_hd__decap_3
XFILLER_16_103 VPWR VGND VPWR VGND sky130_fd_sc_hd__decap_3
XFILLER_0_268 VPWR VGND VPWR VGND sky130_fd_sc_hd__decap_3
XFILLER_16_147 VPWR VGND VPWR VGND sky130_fd_sc_hd__decap_3
XFILLER_16_136 VPWR VGND VPWR VGND sky130_fd_sc_hd__decap_3
XFILLER_8_324 VPWR VGND VPWR VGND sky130_fd_sc_hd__decap_3
XFILLER_22_106 VPWR VGND VPWR VGND sky130_fd_sc_hd__decap_3
XFILLER_7_60 VPWR VGND VPWR VGND sky130_fd_sc_hd__decap_3
XFILLER_7_93 VPWR VGND VPWR VGND sky130_fd_sc_hd__decap_3
XFILLER_13_128 VPWR VGND VPWR VGND sky130_fd_sc_hd__decap_3
XFILLER_21_172 VPWR VGND VPWR VGND sky130_fd_sc_hd__decap_3
XFILLER_21_161 VPWR VGND VPWR VGND sky130_fd_sc_hd__decap_3
XFILLER_5_305 VPWR VGND VPWR VGND sky130_fd_sc_hd__decap_3
XFILLER_3_18 VPWR VGND VPWR VGND sky130_fd_sc_hd__decap_3
XFILLER_16_91 VPWR VGND VPWR VGND sky130_fd_sc_hd__decap_3
XFILLER_16_80 VPWR VGND VPWR VGND sky130_fd_sc_hd__decap_3
XFILLER_8_121 VPWR VGND VPWR VGND sky130_fd_sc_hd__decap_3
XFILLER_12_150 VPWR VGND VPWR VGND sky130_fd_sc_hd__decap_3
XFILLER_12_183 VPWR VGND VPWR VGND sky130_fd_sc_hd__decap_3
XFILLER_8_165 VPWR VGND VPWR VGND sky130_fd_sc_hd__decap_3
XFILLER_10_109 VPWR VGND VPWR VGND sky130_fd_sc_hd__decap_3
XFILLER_12_38 VPWR VGND VPWR VGND sky130_fd_sc_hd__decap_3
XFILLER_18_209 VPWR VGND VPWR VGND sky130_fd_sc_hd__decap_3
XFILLER_5_102 VPWR VGND VPWR VGND sky130_fd_sc_hd__decap_3
XFILLER_5_113 VPWR VGND VPWR VGND sky130_fd_sc_hd__decap_3
XFILLER_5_146 VPWR VGND VPWR VGND sky130_fd_sc_hd__decap_3
XFILLER_17_264 VPWR VGND VPWR VGND sky130_fd_sc_hd__decap_3
XFILLER_17_231 VPWR VGND VPWR VGND sky130_fd_sc_hd__decap_3
XFILLER_17_220 VPWR VGND VPWR VGND sky130_fd_sc_hd__decap_3
XFILLER_4_50 VPWR VGND VPWR VGND sky130_fd_sc_hd__decap_3
XFILLER_4_94 VPWR VGND VPWR VGND sky130_fd_sc_hd__decap_3
XFILLER_23_256 VPWR VGND VPWR VGND sky130_fd_sc_hd__decap_3
XFILLER_23_15 VPWR VGND VPWR VGND sky130_fd_sc_hd__decap_3
XFILLER_2_127 VPWR VGND VPWR VGND sky130_fd_sc_hd__decap_3
XFILLER_14_256 VPWR VGND VPWR VGND sky130_fd_sc_hd__decap_3
XFILLER_14_245 VPWR VGND VPWR VGND sky130_fd_sc_hd__decap_3
XFILLER_14_212 VPWR VGND VPWR VGND sky130_fd_sc_hd__decap_3
Xmisfit01_core_9 uio_out[1] misfit01_core_9/HI VPWR VGND VGND VPWR sky130_fd_sc_hd__conb_1
XFILLER_14_289 VPWR VGND VPWR VGND sky130_fd_sc_hd__decap_3
XFILLER_13_81 VPWR VGND VPWR VGND sky130_fd_sc_hd__decap_3
XFILLER_9_39 VPWR VGND VPWR VGND sky130_fd_sc_hd__decap_3
XFILLER_1_193 VPWR VGND VPWR VGND sky130_fd_sc_hd__decap_3
XFILLER_20_248 VPWR VGND VPWR VGND sky130_fd_sc_hd__decap_3
XFILLER_20_215 VPWR VGND VPWR VGND sky130_fd_sc_hd__decap_3
XFILLER_20_259 VPWR VGND VPWR VGND sky130_fd_sc_hd__decap_3
XFILLER_9_293 VPWR VGND VPWR VGND sky130_fd_sc_hd__decap_3
XFILLER_18_15 VPWR VGND VPWR VGND sky130_fd_sc_hd__decap_3
XFILLER_18_59 VPWR VGND VPWR VGND sky130_fd_sc_hd__decap_3
XFILLER_7_208 VPWR VGND VPWR VGND sky130_fd_sc_hd__decap_3
XFILLER_11_237 VPWR VGND VPWR VGND sky130_fd_sc_hd__decap_3
XFILLER_19_326 VPWR VGND VPWR VGND sky130_fd_sc_hd__decap_3
XFILLER_6_230 VPWR VGND VPWR VGND sky130_fd_sc_hd__decap_3
XFILLER_6_274 VPWR VGND VPWR VGND sky130_fd_sc_hd__decap_3
XFILLER_10_292 VPWR VGND VPWR VGND sky130_fd_sc_hd__decap_3
XFILLER_1_51 VPWR VGND VPWR VGND sky130_fd_sc_hd__decap_3
XFILLER_1_84 VPWR VGND VPWR VGND sky130_fd_sc_hd__decap_3
XFILLER_20_38 VPWR VGND VPWR VGND sky130_fd_sc_hd__decap_3
XFILLER_16_318 VPWR VGND VPWR VGND sky130_fd_sc_hd__decap_3
XFILLER_3_211 VPWR VGND VPWR VGND sky130_fd_sc_hd__decap_3
XFILLER_6_18 VPWR VGND VPWR VGND sky130_fd_sc_hd__decap_3
XFILLER_6_29 VPWR VGND VPWR VGND sky130_fd_sc_hd__decap_3
XFILLER_3_255 VPWR VGND VPWR VGND sky130_fd_sc_hd__decap_3
XFILLER_3_299 VPWR VGND VPWR VGND sky130_fd_sc_hd__decap_3
XFILLER_10_71 VPWR VGND VPWR VGND sky130_fd_sc_hd__decap_3
XFILLER_19_178 VPWR VGND VPWR VGND sky130_fd_sc_hd__decap_3
XFILLER_19_134 VPWR VGND VPWR VGND sky130_fd_sc_hd__decap_3
XFILLER_13_9 VPWR VGND VPWR VGND sky130_fd_sc_hd__decap_3
XFILLER_15_27 VPWR VGND VPWR VGND sky130_fd_sc_hd__decap_3
XFILLER_21_332 VPWR VGND VPWR VGND sky130_fd_sc_hd__decap_3
XPHY_EDGE_ROW_1_Right_1 VPWR VGND VPWR VGND sky130_fd_sc_hd__decap_3
XFILLER_0_225 VPWR VGND VPWR VGND sky130_fd_sc_hd__decap_3
XFILLER_0_203 VPWR VGND VPWR VGND sky130_fd_sc_hd__decap_3
XFILLER_16_115 VPWR VGND VPWR VGND sky130_fd_sc_hd__decap_3
XFILLER_16_159 VPWR VGND VPWR VGND sky130_fd_sc_hd__decap_3
XFILLER_12_321 VPWR VGND VPWR VGND sky130_fd_sc_hd__decap_3
XFILLER_21_81 VPWR VGND VPWR VGND sky130_fd_sc_hd__decap_3
XFILLER_11_6 VPWR VGND VPWR VGND sky130_fd_sc_hd__decap_3
XFILLER_22_118 VPWR VGND VPWR VGND sky130_fd_sc_hd__decap_3
XFILLER_15_181 VPWR VGND VPWR VGND sky130_fd_sc_hd__decap_3
XFILLER_7_72 VPWR VGND VPWR VGND sky130_fd_sc_hd__decap_3
XFILLER_21_140 VPWR VGND VPWR VGND sky130_fd_sc_hd__decap_3
XFILLER_21_184 VPWR VGND VPWR VGND sky130_fd_sc_hd__decap_3
XFILLER_5_317 VPWR VGND VPWR VGND sky130_fd_sc_hd__decap_3
XFILLER_8_100 VPWR VGND VPWR VGND sky130_fd_sc_hd__decap_3
XFILLER_8_133 VPWR VGND VPWR VGND sky130_fd_sc_hd__decap_3
XFILLER_8_144 VPWR VGND VPWR VGND sky130_fd_sc_hd__decap_3
XFILLER_8_177 VPWR VGND VPWR VGND sky130_fd_sc_hd__decap_3
XFILLER_12_162 VPWR VGND VPWR VGND sky130_fd_sc_hd__decap_3
XFILLER_2_309 VPWR VGND VPWR VGND sky130_fd_sc_hd__decap_3
XFILLER_1_320 VPWR VGND VPWR VGND sky130_fd_sc_hd__decap_3
XFILLER_5_125 VPWR VGND VPWR VGND sky130_fd_sc_hd__decap_3
XFILLER_5_158 VPWR VGND VPWR VGND sky130_fd_sc_hd__decap_3
XFILLER_5_169 VPWR VGND VPWR VGND sky130_fd_sc_hd__decap_3
XFILLER_17_287 VPWR VGND VPWR VGND sky130_fd_sc_hd__decap_3
XFILLER_17_276 VPWR VGND VPWR VGND sky130_fd_sc_hd__decap_3
XFILLER_17_243 VPWR VGND VPWR VGND sky130_fd_sc_hd__decap_3
XFILLER_4_62 VPWR VGND VPWR VGND sky130_fd_sc_hd__decap_3
XFILLER_4_180 VPWR VGND VPWR VGND sky130_fd_sc_hd__decap_3
XFILLER_23_268 VPWR VGND VPWR VGND sky130_fd_sc_hd__decap_3
XFILLER_23_38 VPWR VGND VPWR VGND sky130_fd_sc_hd__decap_3
XFILLER_2_106 VPWR VGND VPWR VGND sky130_fd_sc_hd__decap_3
XFILLER_14_268 VPWR VGND VPWR VGND sky130_fd_sc_hd__decap_3
XFILLER_14_224 VPWR VGND VPWR VGND sky130_fd_sc_hd__decap_3
XFILLER_9_18 VPWR VGND VPWR VGND sky130_fd_sc_hd__decap_3
XFILLER_13_93 VPWR VGND VPWR VGND sky130_fd_sc_hd__decap_3
XFILLER_13_60 VPWR VGND VPWR VGND sky130_fd_sc_hd__decap_3
XFILLER_1_172 VPWR VGND VPWR VGND sky130_fd_sc_hd__decap_3
XFILLER_1_161 VPWR VGND VPWR VGND sky130_fd_sc_hd__decap_3
XFILLER_20_227 VPWR VGND VPWR VGND sky130_fd_sc_hd__decap_3
XFILLER_13_290 VPWR VGND VPWR VGND sky130_fd_sc_hd__decap_3
XFILLER_9_261 VPWR VGND VPWR VGND sky130_fd_sc_hd__decap_3
XFILLER_18_38 VPWR VGND VPWR VGND sky130_fd_sc_hd__decap_3
XFILLER_11_205 VPWR VGND VPWR VGND sky130_fd_sc_hd__decap_3
XFILLER_11_249 VPWR VGND VPWR VGND sky130_fd_sc_hd__decap_3
XFILLER_19_305 VPWR VGND VPWR VGND sky130_fd_sc_hd__decap_3
XFILLER_6_242 VPWR VGND VPWR VGND sky130_fd_sc_hd__decap_3
XFILLER_6_253 VPWR VGND VPWR VGND sky130_fd_sc_hd__decap_3
XFILLER_6_286 VPWR VGND VPWR VGND sky130_fd_sc_hd__decap_3
XFILLER_10_271 VPWR VGND VPWR VGND sky130_fd_sc_hd__decap_3
XFILLER_1_30 VPWR VGND VPWR VGND sky130_fd_sc_hd__decap_3
X_25_ VPWR VGND uo_out[1] _25_/A VPWR VGND sky130_fd_sc_hd__buf_2
XFILLER_1_63 VPWR VGND VPWR VGND sky130_fd_sc_hd__decap_3
XFILLER_1_96 VPWR VGND VPWR VGND sky130_fd_sc_hd__decap_3
XFILLER_3_234 VPWR VGND VPWR VGND sky130_fd_sc_hd__decap_3
XFILLER_19_113 VPWR VGND VPWR VGND sky130_fd_sc_hd__decap_3
XFILLER_19_102 VPWR VGND VPWR VGND sky130_fd_sc_hd__decap_3
XFILLER_3_267 VPWR VGND VPWR VGND sky130_fd_sc_hd__decap_3
XFILLER_10_50 VPWR VGND VPWR VGND sky130_fd_sc_hd__decap_3
XFILLER_10_94 VPWR VGND VPWR VGND sky130_fd_sc_hd__decap_3
XFILLER_19_146 VPWR VGND VPWR VGND sky130_fd_sc_hd__decap_3
XFILLER_19_81 VPWR VGND VPWR VGND sky130_fd_sc_hd__decap_3
XFILLER_21_311 VPWR VGND VPWR VGND sky130_fd_sc_hd__decap_3
XFILLER_15_39 VPWR VGND VPWR VGND sky130_fd_sc_hd__decap_3
XFILLER_0_259 VPWR VGND VPWR VGND sky130_fd_sc_hd__decap_3
XFILLER_0_237 VPWR VGND VPWR VGND sky130_fd_sc_hd__decap_3
XFILLER_0_215 VPWR VGND VPWR VGND sky130_fd_sc_hd__decap_3
XFILLER_16_127 VPWR VGND VPWR VGND sky130_fd_sc_hd__decap_3
XFILLER_8_304 VPWR VGND VPWR VGND sky130_fd_sc_hd__decap_3
XFILLER_8_315 VPWR VGND VPWR VGND sky130_fd_sc_hd__decap_3
XFILLER_21_93 VPWR VGND VPWR VGND sky130_fd_sc_hd__decap_3
XFILLER_21_60 VPWR VGND VPWR VGND sky130_fd_sc_hd__decap_3
Xclkbuf_0_clk VGND VPWR VGND VPWR clk clkbuf_0_clk/X sky130_fd_sc_hd__clkbuf_16
XFILLER_15_193 VPWR VGND VPWR VGND sky130_fd_sc_hd__decap_3
XFILLER_7_51 VPWR VGND VPWR VGND sky130_fd_sc_hd__decap_3
XFILLER_7_84 VPWR VGND VPWR VGND sky130_fd_sc_hd__decap_3
XPHY_EDGE_ROW_15_Right_15 VPWR VGND VPWR VGND sky130_fd_sc_hd__decap_3
XFILLER_21_152 VPWR VGND VPWR VGND sky130_fd_sc_hd__decap_3
XFILLER_13_119 VPWR VGND VPWR VGND sky130_fd_sc_hd__decap_3
XFILLER_13_108 VPWR VGND VPWR VGND sky130_fd_sc_hd__decap_3
XFILLER_5_329 VPWR VGND VPWR VGND sky130_fd_sc_hd__decap_3
XFILLER_16_71 VPWR VGND VPWR VGND sky130_fd_sc_hd__decap_3
XFILLER_8_112 VPWR VGND VPWR VGND sky130_fd_sc_hd__decap_3
XFILLER_8_156 VPWR VGND VPWR VGND sky130_fd_sc_hd__decap_3
XFILLER_8_189 VPWR VGND VPWR VGND sky130_fd_sc_hd__decap_3
XFILLER_12_130 VPWR VGND VPWR VGND sky130_fd_sc_hd__decap_3
XFILLER_12_141 VPWR VGND VPWR VGND sky130_fd_sc_hd__decap_3
XFILLER_12_174 VPWR VGND VPWR VGND sky130_fd_sc_hd__decap_3
XFILLER_12_18 VPWR VGND VPWR VGND sky130_fd_sc_hd__decap_3
XFILLER_12_29 VPWR VGND VPWR VGND sky130_fd_sc_hd__decap_3
XFILLER_5_137 VPWR VGND VPWR VGND sky130_fd_sc_hd__decap_3
XFILLER_1_332 VPWR VGND VPWR VGND sky130_fd_sc_hd__decap_3
XFILLER_17_255 VPWR VGND VPWR VGND sky130_fd_sc_hd__decap_3
XFILLER_17_211 VPWR VGND VPWR VGND sky130_fd_sc_hd__decap_3
XFILLER_17_299 VPWR VGND VPWR VGND sky130_fd_sc_hd__decap_3
XFILLER_4_41 VPWR VGND VPWR VGND sky130_fd_sc_hd__decap_3
XFILLER_4_74 VPWR VGND VPWR VGND sky130_fd_sc_hd__decap_3
XFILLER_4_85 VPWR VGND VPWR VGND sky130_fd_sc_hd__decap_3
XFILLER_4_192 VPWR VGND VPWR VGND sky130_fd_sc_hd__decap_3
XFILLER_23_225 VPWR VGND VPWR VGND sky130_fd_sc_hd__decap_3
XFILLER_3_9 VPWR VGND VPWR VGND sky130_fd_sc_hd__decap_3
XFILLER_2_118 VPWR VGND VPWR VGND sky130_fd_sc_hd__decap_3
XFILLER_14_236 VPWR VGND VPWR VGND sky130_fd_sc_hd__decap_3
XFILLER_14_203 VPWR VGND VPWR VGND sky130_fd_sc_hd__decap_3
XFILLER_22_280 VPWR VGND VPWR VGND sky130_fd_sc_hd__decap_3
XFILLER_13_72 VPWR VGND VPWR VGND sky130_fd_sc_hd__decap_3
XFILLER_1_184 VPWR VGND VPWR VGND sky130_fd_sc_hd__decap_3
XFILLER_1_140 VPWR VGND VPWR VGND sky130_fd_sc_hd__decap_3
XFILLER_20_239 VPWR VGND VPWR VGND sky130_fd_sc_hd__decap_3
XFILLER_20_206 VPWR VGND VPWR VGND sky130_fd_sc_hd__decap_3
XFILLER_9_240 VPWR VGND VPWR VGND sky130_fd_sc_hd__decap_3
XFILLER_9_273 VPWR VGND VPWR VGND sky130_fd_sc_hd__decap_3
XFILLER_9_284 VPWR VGND VPWR VGND sky130_fd_sc_hd__decap_3
XFILLER_11_217 VPWR VGND VPWR VGND sky130_fd_sc_hd__decap_3
XFILLER_11_228 VPWR VGND VPWR VGND sky130_fd_sc_hd__decap_3
XFILLER_1_6 VPWR VGND VPWR VGND sky130_fd_sc_hd__decap_3
XFILLER_19_317 VPWR VGND VPWR VGND sky130_fd_sc_hd__decap_3
XFILLER_6_221 VPWR VGND VPWR VGND sky130_fd_sc_hd__decap_3
XFILLER_6_265 VPWR VGND VPWR VGND sky130_fd_sc_hd__decap_3
XFILLER_6_298 VPWR VGND VPWR VGND sky130_fd_sc_hd__decap_3
XFILLER_10_283 VPWR VGND VPWR VGND sky130_fd_sc_hd__decap_3
X_24_ VPWR VGND uo_out[0] _24_/A VPWR VGND sky130_fd_sc_hd__buf_2
XFILLER_1_42 VPWR VGND VPWR VGND sky130_fd_sc_hd__decap_3
XFILLER_1_75 VPWR VGND VPWR VGND sky130_fd_sc_hd__decap_3
XFILLER_20_29 VPWR VGND VPWR VGND sky130_fd_sc_hd__decap_3
XFILLER_20_18 VPWR VGND VPWR VGND sky130_fd_sc_hd__decap_3
XFILLER_16_309 VPWR VGND VPWR VGND sky130_fd_sc_hd__decap_3
XFILLER_3_202 VPWR VGND VPWR VGND sky130_fd_sc_hd__decap_3
XFILLER_3_246 VPWR VGND VPWR VGND sky130_fd_sc_hd__decap_3
XFILLER_10_62 VPWR VGND VPWR VGND sky130_fd_sc_hd__decap_3
XFILLER_19_125 VPWR VGND VPWR VGND sky130_fd_sc_hd__decap_3
XFILLER_19_60 VPWR VGND VPWR VGND sky130_fd_sc_hd__decap_3
XFILLER_19_169 VPWR VGND VPWR VGND sky130_fd_sc_hd__decap_3
XFILLER_19_158 VPWR VGND VPWR VGND sky130_fd_sc_hd__decap_3
XFILLER_19_93 VPWR VGND VPWR VGND sky130_fd_sc_hd__decap_3
XFILLER_15_320 VPWR VGND VPWR VGND sky130_fd_sc_hd__decap_3
XPHY_EDGE_ROW_11_Left_35 VPWR VGND VPWR VGND sky130_fd_sc_hd__decap_3
XFILLER_21_323 VPWR VGND VPWR VGND sky130_fd_sc_hd__decap_3
XFILLER_18_180 VPWR VGND VPWR VGND sky130_fd_sc_hd__decap_3
XFILLER_15_18 VPWR VGND VPWR VGND sky130_fd_sc_hd__decap_3
XFILLER_0_249 VPWR VGND VPWR VGND sky130_fd_sc_hd__decap_3
Xmisfit01_core uio_oe[3] misfit01_core/HI VPWR VGND VGND VPWR sky130_fd_sc_hd__conb_1
XFILLER_16_106 VPWR VGND VPWR VGND sky130_fd_sc_hd__decap_3
XFILLER_12_312 VPWR VGND VPWR VGND sky130_fd_sc_hd__decap_3
XFILLER_12_301 VPWR VGND VPWR VGND sky130_fd_sc_hd__decap_3
XFILLER_8_327 VPWR VGND VPWR VGND sky130_fd_sc_hd__decap_3
XFILLER_21_72 VPWR VGND VPWR VGND sky130_fd_sc_hd__decap_3
XFILLER_22_109 VPWR VGND VPWR VGND sky130_fd_sc_hd__decap_3
XFILLER_15_172 VPWR VGND VPWR VGND sky130_fd_sc_hd__decap_3
XFILLER_15_161 VPWR VGND VPWR VGND sky130_fd_sc_hd__decap_3
XFILLER_7_30 VPWR VGND VPWR VGND sky130_fd_sc_hd__decap_3
XFILLER_7_63 VPWR VGND VPWR VGND sky130_fd_sc_hd__decap_3
XFILLER_7_96 VPWR VGND VPWR VGND sky130_fd_sc_hd__decap_3
XFILLER_21_175 VPWR VGND VPWR VGND sky130_fd_sc_hd__decap_3
XFILLER_21_164 VPWR VGND VPWR VGND sky130_fd_sc_hd__decap_3
XFILLER_21_131 VPWR VGND VPWR VGND sky130_fd_sc_hd__decap_3
XFILLER_5_308 VPWR VGND VPWR VGND sky130_fd_sc_hd__decap_3
XFILLER_16_94 VPWR VGND VPWR VGND sky130_fd_sc_hd__decap_3
XFILLER_16_50 VPWR VGND VPWR VGND sky130_fd_sc_hd__decap_3
XFILLER_12_153 VPWR VGND VPWR VGND sky130_fd_sc_hd__decap_3
XFILLER_4_330 VPWR VGND VPWR VGND sky130_fd_sc_hd__decap_3
XFILLER_8_124 VPWR VGND VPWR VGND sky130_fd_sc_hd__decap_3
XFILLER_8_168 VPWR VGND VPWR VGND sky130_fd_sc_hd__decap_3
XFILLER_12_186 VPWR VGND VPWR VGND sky130_fd_sc_hd__decap_3
XFILLER_12_197 VPWR VGND VPWR VGND sky130_fd_sc_hd__decap_3
XFILLER_7_190 VPWR VGND VPWR VGND sky130_fd_sc_hd__decap_3
XFILLER_5_105 VPWR VGND VPWR VGND sky130_fd_sc_hd__decap_3
XFILLER_5_116 VPWR VGND VPWR VGND sky130_fd_sc_hd__decap_3
XFILLER_5_149 VPWR VGND VPWR VGND sky130_fd_sc_hd__decap_3
XFILLER_1_311 VPWR VGND VPWR VGND sky130_fd_sc_hd__decap_3
XFILLER_17_267 VPWR VGND VPWR VGND sky130_fd_sc_hd__decap_3
XFILLER_17_234 VPWR VGND VPWR VGND sky130_fd_sc_hd__decap_3
XFILLER_4_171 VPWR VGND VPWR VGND sky130_fd_sc_hd__decap_3
XFILLER_4_53 VPWR VGND VPWR VGND sky130_fd_sc_hd__decap_3
XFILLER_4_97 VPWR VGND VPWR VGND sky130_fd_sc_hd__decap_3
XFILLER_23_259 VPWR VGND VPWR VGND sky130_fd_sc_hd__decap_3
XFILLER_23_248 VPWR VGND VPWR VGND sky130_fd_sc_hd__decap_3
XFILLER_23_18 VPWR VGND VPWR VGND sky130_fd_sc_hd__decap_3
XFILLER_23_29 VPWR VGND VPWR VGND sky130_fd_sc_hd__decap_3
XFILLER_22_292 VPWR VGND VPWR VGND sky130_fd_sc_hd__decap_3
XFILLER_14_259 VPWR VGND VPWR VGND sky130_fd_sc_hd__decap_3
XFILLER_14_248 VPWR VGND VPWR VGND sky130_fd_sc_hd__decap_3
XFILLER_14_215 VPWR VGND VPWR VGND sky130_fd_sc_hd__decap_3
XFILLER_13_51 VPWR VGND VPWR VGND sky130_fd_sc_hd__decap_3
XFILLER_13_84 VPWR VGND VPWR VGND sky130_fd_sc_hd__decap_3
XFILLER_1_196 VPWR VGND VPWR VGND sky130_fd_sc_hd__decap_3
XFILLER_1_152 VPWR VGND VPWR VGND sky130_fd_sc_hd__decap_3
XFILLER_20_218 VPWR VGND VPWR VGND sky130_fd_sc_hd__decap_3
XFILLER_13_281 VPWR VGND VPWR VGND sky130_fd_sc_hd__decap_3
XFILLER_13_270 VPWR VGND VPWR VGND sky130_fd_sc_hd__decap_3
XFILLER_9_252 VPWR VGND VPWR VGND sky130_fd_sc_hd__decap_3
XFILLER_9_296 VPWR VGND VPWR VGND sky130_fd_sc_hd__decap_3
XFILLER_18_29 VPWR VGND VPWR VGND sky130_fd_sc_hd__decap_3
XFILLER_18_18 VPWR VGND VPWR VGND sky130_fd_sc_hd__decap_3
XFILLER_19_329 VPWR VGND VPWR VGND sky130_fd_sc_hd__decap_3
XFILLER_6_200 VPWR VGND VPWR VGND sky130_fd_sc_hd__decap_3
XFILLER_6_233 VPWR VGND VPWR VGND sky130_fd_sc_hd__decap_3
XFILLER_10_262 VPWR VGND VPWR VGND sky130_fd_sc_hd__decap_3
XFILLER_10_295 VPWR VGND VPWR VGND sky130_fd_sc_hd__decap_3
XFILLER_6_277 VPWR VGND VPWR VGND sky130_fd_sc_hd__decap_3
XFILLER_1_21 VPWR VGND VPWR VGND sky130_fd_sc_hd__decap_3
XFILLER_1_87 VPWR VGND VPWR VGND sky130_fd_sc_hd__decap_3
XFILLER_3_214 VPWR VGND VPWR VGND sky130_fd_sc_hd__decap_3
XFILLER_3_225 VPWR VGND VPWR VGND sky130_fd_sc_hd__decap_3
XFILLER_3_258 VPWR VGND VPWR VGND sky130_fd_sc_hd__decap_3
XFILLER_10_41 VPWR VGND VPWR VGND sky130_fd_sc_hd__decap_3
XFILLER_10_74 VPWR VGND VPWR VGND sky130_fd_sc_hd__decap_3
XFILLER_10_85 VPWR VGND VPWR VGND sky130_fd_sc_hd__decap_3
XFILLER_19_137 VPWR VGND VPWR VGND sky130_fd_sc_hd__decap_3
XFILLER_19_72 VPWR VGND VPWR VGND sky130_fd_sc_hd__decap_3
XFILLER_15_332 VPWR VGND VPWR VGND sky130_fd_sc_hd__decap_3
XFILLER_2_280 VPWR VGND VPWR VGND sky130_fd_sc_hd__decap_3
XFILLER_18_192 VPWR VGND VPWR VGND sky130_fd_sc_hd__decap_3
XFILLER_21_302 VPWR VGND VPWR VGND sky130_fd_sc_hd__decap_3
XFILLER_0_228 VPWR VGND VPWR VGND sky130_fd_sc_hd__decap_3
XFILLER_0_206 VPWR VGND VPWR VGND sky130_fd_sc_hd__decap_3
XFILLER_16_118 VPWR VGND VPWR VGND sky130_fd_sc_hd__decap_3
XFILLER_12_324 VPWR VGND VPWR VGND sky130_fd_sc_hd__decap_3
XFILLER_21_51 VPWR VGND VPWR VGND sky130_fd_sc_hd__decap_3
XFILLER_21_84 VPWR VGND VPWR VGND sky130_fd_sc_hd__decap_3
XFILLER_11_9 VPWR VGND VPWR VGND sky130_fd_sc_hd__decap_3
XFILLER_15_184 VPWR VGND VPWR VGND sky130_fd_sc_hd__decap_3
XFILLER_15_140 VPWR VGND VPWR VGND sky130_fd_sc_hd__decap_3
XFILLER_7_42 VPWR VGND VPWR VGND sky130_fd_sc_hd__decap_3
XFILLER_7_75 VPWR VGND VPWR VGND sky130_fd_sc_hd__decap_3
XPHY_EDGE_ROW_5_Right_5 VPWR VGND VPWR VGND sky130_fd_sc_hd__decap_3
XFILLER_21_187 VPWR VGND VPWR VGND sky130_fd_sc_hd__decap_3
XFILLER_21_143 VPWR VGND VPWR VGND sky130_fd_sc_hd__decap_3
XFILLER_16_62 VPWR VGND VPWR VGND sky130_fd_sc_hd__decap_3
XFILLER_8_103 VPWR VGND VPWR VGND sky130_fd_sc_hd__decap_3
XFILLER_8_136 VPWR VGND VPWR VGND sky130_fd_sc_hd__decap_3
XFILLER_12_121 VPWR VGND VPWR VGND sky130_fd_sc_hd__decap_3
XFILLER_12_165 VPWR VGND VPWR VGND sky130_fd_sc_hd__decap_3
XFILLER_8_147 VPWR VGND VPWR VGND sky130_fd_sc_hd__decap_3
XFILLER_5_128 VPWR VGND VPWR VGND sky130_fd_sc_hd__decap_3
XFILLER_1_323 VPWR VGND VPWR VGND sky130_fd_sc_hd__decap_3
XFILLER_17_246 VPWR VGND VPWR VGND sky130_fd_sc_hd__decap_3
XFILLER_17_202 VPWR VGND VPWR VGND sky130_fd_sc_hd__decap_3
XFILLER_4_21 VPWR VGND VPWR VGND sky130_fd_sc_hd__decap_3
XFILLER_4_32 VPWR VGND VPWR VGND sky130_fd_sc_hd__decap_3
XFILLER_4_65 VPWR VGND VPWR VGND sky130_fd_sc_hd__decap_3
XFILLER_4_150 VPWR VGND VPWR VGND sky130_fd_sc_hd__decap_3
XFILLER_4_183 VPWR VGND VPWR VGND sky130_fd_sc_hd__decap_3
XFILLER_2_109 VPWR VGND VPWR VGND sky130_fd_sc_hd__decap_3
XFILLER_14_227 VPWR VGND VPWR VGND sky130_fd_sc_hd__decap_3
XFILLER_22_271 VPWR VGND VPWR VGND sky130_fd_sc_hd__decap_3
XFILLER_13_63 VPWR VGND VPWR VGND sky130_fd_sc_hd__decap_3
XFILLER_13_30 VPWR VGND VPWR VGND sky130_fd_sc_hd__decap_3
XFILLER_13_96 VPWR VGND VPWR VGND sky130_fd_sc_hd__decap_3
XFILLER_1_131 VPWR VGND VPWR VGND sky130_fd_sc_hd__decap_3
XFILLER_1_175 VPWR VGND VPWR VGND sky130_fd_sc_hd__decap_3
XFILLER_1_164 VPWR VGND VPWR VGND sky130_fd_sc_hd__decap_3
XFILLER_13_293 VPWR VGND VPWR VGND sky130_fd_sc_hd__decap_3
XFILLER_9_220 VPWR VGND VPWR VGND sky130_fd_sc_hd__decap_3
XFILLER_9_231 VPWR VGND VPWR VGND sky130_fd_sc_hd__decap_3
XFILLER_9_264 VPWR VGND VPWR VGND sky130_fd_sc_hd__decap_3
XFILLER_11_208 VPWR VGND VPWR VGND sky130_fd_sc_hd__decap_3
XFILLER_19_308 VPWR VGND VPWR VGND sky130_fd_sc_hd__decap_3
XFILLER_6_212 VPWR VGND VPWR VGND sky130_fd_sc_hd__decap_3
XFILLER_6_245 VPWR VGND VPWR VGND sky130_fd_sc_hd__decap_3
XFILLER_6_256 VPWR VGND VPWR VGND sky130_fd_sc_hd__decap_3
XFILLER_10_230 VPWR VGND VPWR VGND sky130_fd_sc_hd__decap_3
XFILLER_10_274 VPWR VGND VPWR VGND sky130_fd_sc_hd__decap_3
XFILLER_6_289 VPWR VGND VPWR VGND sky130_fd_sc_hd__decap_3
XFILLER_18_330 VPWR VGND VPWR VGND sky130_fd_sc_hd__decap_3
XFILLER_1_33 VPWR VGND VPWR VGND sky130_fd_sc_hd__decap_3
XFILLER_1_66 VPWR VGND VPWR VGND sky130_fd_sc_hd__decap_3
XFILLER_1_99 VPWR VGND VPWR VGND sky130_fd_sc_hd__decap_3
XFILLER_3_237 VPWR VGND VPWR VGND sky130_fd_sc_hd__decap_3
XFILLER_10_53 VPWR VGND VPWR VGND sky130_fd_sc_hd__decap_3
XFILLER_10_97 VPWR VGND VPWR VGND sky130_fd_sc_hd__decap_3
XFILLER_19_149 VPWR VGND VPWR VGND sky130_fd_sc_hd__decap_3
XFILLER_19_116 VPWR VGND VPWR VGND sky130_fd_sc_hd__decap_3
XFILLER_19_105 VPWR VGND VPWR VGND sky130_fd_sc_hd__decap_3
XFILLER_19_84 VPWR VGND VPWR VGND sky130_fd_sc_hd__decap_3
XFILLER_19_51 VPWR VGND VPWR VGND sky130_fd_sc_hd__decap_3
XFILLER_15_311 VPWR VGND VPWR VGND sky130_fd_sc_hd__decap_3
XFILLER_18_3 VPWR VGND VPWR VGND sky130_fd_sc_hd__decap_3
XFILLER_2_292 VPWR VGND VPWR VGND sky130_fd_sc_hd__decap_3
XFILLER_18_171 VPWR VGND VPWR VGND sky130_fd_sc_hd__decap_3
XFILLER_21_314 VPWR VGND VPWR VGND sky130_fd_sc_hd__decap_3
XFILLER_0_218 VPWR VGND VPWR VGND sky130_fd_sc_hd__decap_3
XFILLER_8_318 VPWR VGND VPWR VGND sky130_fd_sc_hd__decap_3
XFILLER_21_96 VPWR VGND VPWR VGND sky130_fd_sc_hd__decap_3
XFILLER_21_63 VPWR VGND VPWR VGND sky130_fd_sc_hd__decap_3
XFILLER_21_30 VPWR VGND VPWR VGND sky130_fd_sc_hd__decap_3
XFILLER_15_152 VPWR VGND VPWR VGND sky130_fd_sc_hd__decap_3
XFILLER_15_196 VPWR VGND VPWR VGND sky130_fd_sc_hd__decap_3
XFILLER_7_21 VPWR VGND VPWR VGND sky130_fd_sc_hd__decap_3
XFILLER_7_87 VPWR VGND VPWR VGND sky130_fd_sc_hd__decap_3
XFILLER_21_122 VPWR VGND VPWR VGND sky130_fd_sc_hd__decap_3
XFILLER_21_155 VPWR VGND VPWR VGND sky130_fd_sc_hd__decap_3
XFILLER_16_41 VPWR VGND VPWR VGND sky130_fd_sc_hd__decap_3
XFILLER_16_85 VPWR VGND VPWR VGND sky130_fd_sc_hd__decap_3
XFILLER_16_74 VPWR VGND VPWR VGND sky130_fd_sc_hd__decap_3
XFILLER_8_115 VPWR VGND VPWR VGND sky130_fd_sc_hd__decap_3
XFILLER_8_159 VPWR VGND VPWR VGND sky130_fd_sc_hd__decap_3
XPHY_EDGE_ROW_11_Right_11 VPWR VGND VPWR VGND sky130_fd_sc_hd__decap_3
XFILLER_12_100 VPWR VGND VPWR VGND sky130_fd_sc_hd__decap_3
XFILLER_12_133 VPWR VGND VPWR VGND sky130_fd_sc_hd__decap_3
XFILLER_12_144 VPWR VGND VPWR VGND sky130_fd_sc_hd__decap_3
XFILLER_12_177 VPWR VGND VPWR VGND sky130_fd_sc_hd__decap_3
XPHY_EDGE_ROW_20_Right_20 VPWR VGND VPWR VGND sky130_fd_sc_hd__decap_3
XFILLER_4_321 VPWR VGND VPWR VGND sky130_fd_sc_hd__decap_3
XFILLER_7_181 VPWR VGND VPWR VGND sky130_fd_sc_hd__decap_3
XFILLER_1_302 VPWR VGND VPWR VGND sky130_fd_sc_hd__decap_3
XFILLER_17_258 VPWR VGND VPWR VGND sky130_fd_sc_hd__decap_3
XFILLER_17_225 VPWR VGND VPWR VGND sky130_fd_sc_hd__decap_3
XFILLER_17_214 VPWR VGND VPWR VGND sky130_fd_sc_hd__decap_3
XFILLER_4_44 VPWR VGND VPWR VGND sky130_fd_sc_hd__decap_3
XFILLER_4_77 VPWR VGND VPWR VGND sky130_fd_sc_hd__decap_3
XFILLER_4_88 VPWR VGND VPWR VGND sky130_fd_sc_hd__decap_3
XFILLER_4_162 VPWR VGND VPWR VGND sky130_fd_sc_hd__decap_3
XFILLER_16_280 VPWR VGND VPWR VGND sky130_fd_sc_hd__decap_3
XFILLER_14_239 VPWR VGND VPWR VGND sky130_fd_sc_hd__decap_3
XFILLER_14_206 VPWR VGND VPWR VGND sky130_fd_sc_hd__decap_3
XFILLER_22_283 VPWR VGND VPWR VGND sky130_fd_sc_hd__decap_3
XFILLER_13_75 VPWR VGND VPWR VGND sky130_fd_sc_hd__decap_3
XFILLER_13_42 VPWR VGND VPWR VGND sky130_fd_sc_hd__decap_3
XFILLER_1_143 VPWR VGND VPWR VGND sky130_fd_sc_hd__decap_3
XFILLER_1_187 VPWR VGND VPWR VGND sky130_fd_sc_hd__decap_3
XFILLER_20_209 VPWR VGND VPWR VGND sky130_fd_sc_hd__decap_3
XFILLER_13_261 VPWR VGND VPWR VGND sky130_fd_sc_hd__decap_3
XFILLER_9_243 VPWR VGND VPWR VGND sky130_fd_sc_hd__decap_3
XFILLER_9_276 VPWR VGND VPWR VGND sky130_fd_sc_hd__decap_3
XFILLER_9_287 VPWR VGND VPWR VGND sky130_fd_sc_hd__decap_3
XFILLER_1_9 VPWR VGND VPWR VGND sky130_fd_sc_hd__decap_3
XFILLER_6_224 VPWR VGND VPWR VGND sky130_fd_sc_hd__decap_3
XFILLER_6_268 VPWR VGND VPWR VGND sky130_fd_sc_hd__decap_3
XFILLER_10_242 VPWR VGND VPWR VGND sky130_fd_sc_hd__decap_3
XFILLER_10_253 VPWR VGND VPWR VGND sky130_fd_sc_hd__decap_3
XFILLER_10_286 VPWR VGND VPWR VGND sky130_fd_sc_hd__decap_3
XFILLER_1_12 VPWR VGND VPWR VGND sky130_fd_sc_hd__decap_3
XFILLER_1_45 VPWR VGND VPWR VGND sky130_fd_sc_hd__decap_3
XFILLER_1_78 VPWR VGND VPWR VGND sky130_fd_sc_hd__decap_3
XFILLER_5_290 VPWR VGND VPWR VGND sky130_fd_sc_hd__decap_3
XFILLER_3_205 VPWR VGND VPWR VGND sky130_fd_sc_hd__decap_3
XFILLER_10_21 VPWR VGND VPWR VGND sky130_fd_sc_hd__decap_3
XFILLER_19_30 VPWR VGND VPWR VGND sky130_fd_sc_hd__decap_3
XFILLER_3_249 VPWR VGND VPWR VGND sky130_fd_sc_hd__decap_3
XFILLER_10_32 VPWR VGND VPWR VGND sky130_fd_sc_hd__decap_3
XFILLER_10_65 VPWR VGND VPWR VGND sky130_fd_sc_hd__decap_3
XFILLER_19_128 VPWR VGND VPWR VGND sky130_fd_sc_hd__decap_3
XFILLER_19_96 VPWR VGND VPWR VGND sky130_fd_sc_hd__decap_3
XFILLER_19_63 VPWR VGND VPWR VGND sky130_fd_sc_hd__decap_3
XFILLER_15_323 VPWR VGND VPWR VGND sky130_fd_sc_hd__decap_3
XFILLER_2_271 VPWR VGND VPWR VGND sky130_fd_sc_hd__decap_3
XFILLER_21_326 VPWR VGND VPWR VGND sky130_fd_sc_hd__decap_3
XFILLER_18_183 VPWR VGND VPWR VGND sky130_fd_sc_hd__decap_3
XFILLER_18_150 VPWR VGND VPWR VGND sky130_fd_sc_hd__decap_3
XFILLER_16_109 VPWR VGND VPWR VGND sky130_fd_sc_hd__decap_3
XFILLER_12_315 VPWR VGND VPWR VGND sky130_fd_sc_hd__decap_3
XFILLER_12_304 VPWR VGND VPWR VGND sky130_fd_sc_hd__decap_3
XFILLER_21_75 VPWR VGND VPWR VGND sky130_fd_sc_hd__decap_3
XFILLER_21_42 VPWR VGND VPWR VGND sky130_fd_sc_hd__decap_3
XFILLER_15_175 VPWR VGND VPWR VGND sky130_fd_sc_hd__decap_3
XFILLER_15_164 VPWR VGND VPWR VGND sky130_fd_sc_hd__decap_3
XFILLER_15_131 VPWR VGND VPWR VGND sky130_fd_sc_hd__decap_3
XPHY_EDGE_ROW_15_Left_39 VPWR VGND VPWR VGND sky130_fd_sc_hd__decap_3
XFILLER_7_33 VPWR VGND VPWR VGND sky130_fd_sc_hd__decap_3
XFILLER_7_66 VPWR VGND VPWR VGND sky130_fd_sc_hd__decap_3
XFILLER_7_99 VPWR VGND VPWR VGND sky130_fd_sc_hd__decap_3
XFILLER_21_178 VPWR VGND VPWR VGND sky130_fd_sc_hd__decap_3
XFILLER_21_134 VPWR VGND VPWR VGND sky130_fd_sc_hd__decap_3
XFILLER_16_53 VPWR VGND VPWR VGND sky130_fd_sc_hd__decap_3
XFILLER_16_97 VPWR VGND VPWR VGND sky130_fd_sc_hd__decap_3
XFILLER_8_127 VPWR VGND VPWR VGND sky130_fd_sc_hd__decap_3
XFILLER_12_112 VPWR VGND VPWR VGND sky130_fd_sc_hd__decap_3
XFILLER_12_156 VPWR VGND VPWR VGND sky130_fd_sc_hd__decap_3
XFILLER_12_189 VPWR VGND VPWR VGND sky130_fd_sc_hd__decap_3
XFILLER_7_193 VPWR VGND VPWR VGND sky130_fd_sc_hd__decap_3
XFILLER_5_108 VPWR VGND VPWR VGND sky130_fd_sc_hd__decap_3
XFILLER_5_119 VPWR VGND VPWR VGND sky130_fd_sc_hd__decap_3
XFILLER_1_314 VPWR VGND VPWR VGND sky130_fd_sc_hd__decap_3
XFILLER_17_237 VPWR VGND VPWR VGND sky130_fd_sc_hd__decap_3
XFILLER_4_130 VPWR VGND VPWR VGND sky130_fd_sc_hd__decap_3
XFILLER_4_141 VPWR VGND VPWR VGND sky130_fd_sc_hd__decap_3
XFILLER_4_12 VPWR VGND VPWR VGND sky130_fd_sc_hd__decap_3
XFILLER_4_56 VPWR VGND VPWR VGND sky130_fd_sc_hd__decap_3
XFILLER_4_174 VPWR VGND VPWR VGND sky130_fd_sc_hd__decap_3
XFILLER_16_292 VPWR VGND VPWR VGND sky130_fd_sc_hd__decap_3
XPHY_EDGE_ROW_18_Left_42 VPWR VGND VPWR VGND sky130_fd_sc_hd__decap_3
XFILLER_14_218 VPWR VGND VPWR VGND sky130_fd_sc_hd__decap_3
XFILLER_22_295 VPWR VGND VPWR VGND sky130_fd_sc_hd__decap_3
XFILLER_22_262 VPWR VGND VPWR VGND sky130_fd_sc_hd__decap_3
XFILLER_13_87 VPWR VGND VPWR VGND sky130_fd_sc_hd__decap_3
XFILLER_13_21 VPWR VGND VPWR VGND sky130_fd_sc_hd__decap_3
XFILLER_1_199 VPWR VGND VPWR VGND sky130_fd_sc_hd__decap_3
XFILLER_1_155 VPWR VGND VPWR VGND sky130_fd_sc_hd__decap_3
XFILLER_1_122 VPWR VGND VPWR VGND sky130_fd_sc_hd__decap_3
XFILLER_8_3 VPWR VGND VPWR VGND sky130_fd_sc_hd__decap_3
XFILLER_13_284 VPWR VGND VPWR VGND sky130_fd_sc_hd__decap_3
XFILLER_13_273 VPWR VGND VPWR VGND sky130_fd_sc_hd__decap_3
XFILLER_13_240 VPWR VGND VPWR VGND sky130_fd_sc_hd__decap_3
XFILLER_9_211 VPWR VGND VPWR VGND sky130_fd_sc_hd__decap_3
XFILLER_9_255 VPWR VGND VPWR VGND sky130_fd_sc_hd__decap_3
XFILLER_9_299 VPWR VGND VPWR VGND sky130_fd_sc_hd__decap_3
XPHY_EDGE_ROW_3_Left_27 VPWR VGND VPWR VGND sky130_fd_sc_hd__decap_3
XFILLER_10_221 VPWR VGND VPWR VGND sky130_fd_sc_hd__decap_3
XFILLER_6_203 VPWR VGND VPWR VGND sky130_fd_sc_hd__decap_3
XFILLER_6_236 VPWR VGND VPWR VGND sky130_fd_sc_hd__decap_3
XFILLER_10_265 VPWR VGND VPWR VGND sky130_fd_sc_hd__decap_3
XFILLER_10_298 VPWR VGND VPWR VGND sky130_fd_sc_hd__decap_3
XFILLER_1_24 VPWR VGND VPWR VGND sky130_fd_sc_hd__decap_3
XFILLER_18_321 VPWR VGND VPWR VGND sky130_fd_sc_hd__decap_3
XFILLER_1_57 VPWR VGND VPWR VGND sky130_fd_sc_hd__decap_3
Xinput1 VGND VPWR VPWR VGND inv_y _25_/A sky130_fd_sc_hd__clkdlybuf4s25_1
XFILLER_3_217 VPWR VGND VPWR VGND sky130_fd_sc_hd__decap_3
XFILLER_3_228 VPWR VGND VPWR VGND sky130_fd_sc_hd__decap_3
XFILLER_10_44 VPWR VGND VPWR VGND sky130_fd_sc_hd__decap_3
XFILLER_19_42 VPWR VGND VPWR VGND sky130_fd_sc_hd__decap_3
XFILLER_10_77 VPWR VGND VPWR VGND sky130_fd_sc_hd__decap_3
XFILLER_10_88 VPWR VGND VPWR VGND sky130_fd_sc_hd__decap_3
XFILLER_19_75 VPWR VGND VPWR VGND sky130_fd_sc_hd__decap_3
XFILLER_15_302 VPWR VGND VPWR VGND sky130_fd_sc_hd__decap_3
XFILLER_2_283 VPWR VGND VPWR VGND sky130_fd_sc_hd__decap_3
XFILLER_21_305 VPWR VGND VPWR VGND sky130_fd_sc_hd__decap_3
XFILLER_18_162 VPWR VGND VPWR VGND sky130_fd_sc_hd__decap_3
XFILLER_0_209 VPWR VGND VPWR VGND sky130_fd_sc_hd__decap_3
XFILLER_21_21 VPWR VGND VPWR VGND sky130_fd_sc_hd__decap_3
XFILLER_12_327 VPWR VGND VPWR VGND sky130_fd_sc_hd__decap_3
XFILLER_8_309 VPWR VGND VPWR VGND sky130_fd_sc_hd__decap_3
XFILLER_21_87 VPWR VGND VPWR VGND sky130_fd_sc_hd__decap_3
XPHY_EDGE_ROW_6_Left_30 VPWR VGND VPWR VGND sky130_fd_sc_hd__decap_3
XFILLER_15_187 VPWR VGND VPWR VGND sky130_fd_sc_hd__decap_3
XFILLER_15_143 VPWR VGND VPWR VGND sky130_fd_sc_hd__decap_3
XFILLER_7_12 VPWR VGND VPWR VGND sky130_fd_sc_hd__decap_3
XFILLER_7_45 VPWR VGND VPWR VGND sky130_fd_sc_hd__decap_3
XFILLER_7_78 VPWR VGND VPWR VGND sky130_fd_sc_hd__decap_3
XFILLER_7_320 VPWR VGND VPWR VGND sky130_fd_sc_hd__decap_3
XFILLER_23_3 VPWR VGND VPWR VGND sky130_fd_sc_hd__decap_3
XFILLER_21_146 VPWR VGND VPWR VGND sky130_fd_sc_hd__decap_3
XFILLER_21_113 VPWR VGND VPWR VGND sky130_fd_sc_hd__decap_3
XFILLER_21_102 VPWR VGND VPWR VGND sky130_fd_sc_hd__decap_3
XFILLER_16_65 VPWR VGND VPWR VGND sky130_fd_sc_hd__decap_3
XFILLER_16_32 VPWR VGND VPWR VGND sky130_fd_sc_hd__decap_3
XFILLER_16_21 VPWR VGND VPWR VGND sky130_fd_sc_hd__decap_3
XFILLER_12_124 VPWR VGND VPWR VGND sky130_fd_sc_hd__decap_3
XFILLER_4_301 VPWR VGND VPWR VGND sky130_fd_sc_hd__decap_3
XFILLER_4_312 VPWR VGND VPWR VGND sky130_fd_sc_hd__decap_3
XFILLER_8_106 VPWR VGND VPWR VGND sky130_fd_sc_hd__decap_3
XFILLER_12_168 VPWR VGND VPWR VGND sky130_fd_sc_hd__decap_3
XFILLER_7_161 VPWR VGND VPWR VGND sky130_fd_sc_hd__decap_3
XFILLER_7_172 VPWR VGND VPWR VGND sky130_fd_sc_hd__decap_3
XPHY_EDGE_ROW_9_Right_9 VPWR VGND VPWR VGND sky130_fd_sc_hd__decap_3
XFILLER_11_190 VPWR VGND VPWR VGND sky130_fd_sc_hd__decap_3
XFILLER_19_290 VPWR VGND VPWR VGND sky130_fd_sc_hd__decap_3
XFILLER_1_326 VPWR VGND VPWR VGND sky130_fd_sc_hd__decap_3
XFILLER_17_249 VPWR VGND VPWR VGND sky130_fd_sc_hd__decap_3
XFILLER_17_205 VPWR VGND VPWR VGND sky130_fd_sc_hd__decap_3
XFILLER_4_24 VPWR VGND VPWR VGND sky130_fd_sc_hd__decap_3
XFILLER_4_153 VPWR VGND VPWR VGND sky130_fd_sc_hd__decap_3
XFILLER_4_35 VPWR VGND VPWR VGND sky130_fd_sc_hd__decap_3
XFILLER_4_68 VPWR VGND VPWR VGND sky130_fd_sc_hd__decap_3
XFILLER_4_186 VPWR VGND VPWR VGND sky130_fd_sc_hd__decap_3
XFILLER_4_197 VPWR VGND VPWR VGND sky130_fd_sc_hd__decap_3
XFILLER_16_271 VPWR VGND VPWR VGND sky130_fd_sc_hd__decap_3
XFILLER_22_274 VPWR VGND VPWR VGND sky130_fd_sc_hd__decap_3
XFILLER_22_230 VPWR VGND VPWR VGND sky130_fd_sc_hd__decap_3
XFILLER_13_33 VPWR VGND VPWR VGND sky130_fd_sc_hd__decap_3
XFILLER_13_99 VPWR VGND VPWR VGND sky130_fd_sc_hd__decap_3
XFILLER_13_66 VPWR VGND VPWR VGND sky130_fd_sc_hd__decap_3
XFILLER_1_178 VPWR VGND VPWR VGND sky130_fd_sc_hd__decap_3
XFILLER_1_134 VPWR VGND VPWR VGND sky130_fd_sc_hd__decap_3
XFILLER_13_296 VPWR VGND VPWR VGND sky130_fd_sc_hd__decap_3
XFILLER_13_252 VPWR VGND VPWR VGND sky130_fd_sc_hd__decap_3
XFILLER_9_234 VPWR VGND VPWR VGND sky130_fd_sc_hd__decap_3
XFILLER_9_267 VPWR VGND VPWR VGND sky130_fd_sc_hd__decap_3
XFILLER_6_215 VPWR VGND VPWR VGND sky130_fd_sc_hd__decap_3
XFILLER_10_200 VPWR VGND VPWR VGND sky130_fd_sc_hd__decap_3
XFILLER_10_233 VPWR VGND VPWR VGND sky130_fd_sc_hd__decap_3
XFILLER_10_277 VPWR VGND VPWR VGND sky130_fd_sc_hd__decap_3
XFILLER_6_248 VPWR VGND VPWR VGND sky130_fd_sc_hd__decap_3
XFILLER_6_259 VPWR VGND VPWR VGND sky130_fd_sc_hd__decap_3
XFILLER_1_36 VPWR VGND VPWR VGND sky130_fd_sc_hd__decap_3
XFILLER_1_69 VPWR VGND VPWR VGND sky130_fd_sc_hd__decap_3
XFILLER_5_270 VPWR VGND VPWR VGND sky130_fd_sc_hd__decap_3
XFILLER_5_281 VPWR VGND VPWR VGND sky130_fd_sc_hd__decap_3
Xinput2 VGND VPWR VPWR VGND rst_n input2/X sky130_fd_sc_hd__clkdlybuf4s25_1
XFILLER_10_12 VPWR VGND VPWR VGND sky130_fd_sc_hd__decap_3
XFILLER_10_56 VPWR VGND VPWR VGND sky130_fd_sc_hd__decap_3
XFILLER_19_119 VPWR VGND VPWR VGND sky130_fd_sc_hd__decap_3
XFILLER_19_108 VPWR VGND VPWR VGND sky130_fd_sc_hd__decap_3
XFILLER_19_87 VPWR VGND VPWR VGND sky130_fd_sc_hd__decap_3
XFILLER_19_21 VPWR VGND VPWR VGND sky130_fd_sc_hd__decap_3
XFILLER_15_314 VPWR VGND VPWR VGND sky130_fd_sc_hd__decap_3
XFILLER_2_295 VPWR VGND VPWR VGND sky130_fd_sc_hd__decap_3
XFILLER_2_262 VPWR VGND VPWR VGND sky130_fd_sc_hd__decap_3
XFILLER_18_174 VPWR VGND VPWR VGND sky130_fd_sc_hd__decap_3
XFILLER_18_141 VPWR VGND VPWR VGND sky130_fd_sc_hd__decap_3
XFILLER_18_130 VPWR VGND VPWR VGND sky130_fd_sc_hd__decap_3
XFILLER_18_6 VPWR VGND VPWR VGND sky130_fd_sc_hd__decap_3
XFILLER_21_317 VPWR VGND VPWR VGND sky130_fd_sc_hd__decap_3
XFILLER_21_33 VPWR VGND VPWR VGND sky130_fd_sc_hd__decap_3
XFILLER_21_99 VPWR VGND VPWR VGND sky130_fd_sc_hd__decap_3
XFILLER_21_66 VPWR VGND VPWR VGND sky130_fd_sc_hd__decap_3
XFILLER_15_199 VPWR VGND VPWR VGND sky130_fd_sc_hd__decap_3
XFILLER_15_155 VPWR VGND VPWR VGND sky130_fd_sc_hd__decap_3
XFILLER_15_122 VPWR VGND VPWR VGND sky130_fd_sc_hd__decap_3
XFILLER_7_24 VPWR VGND VPWR VGND sky130_fd_sc_hd__decap_3
XFILLER_7_57 VPWR VGND VPWR VGND sky130_fd_sc_hd__decap_3
XFILLER_7_332 VPWR VGND VPWR VGND sky130_fd_sc_hd__decap_3
XFILLER_16_3 VPWR VGND VPWR VGND sky130_fd_sc_hd__decap_3
XFILLER_21_169 VPWR VGND VPWR VGND sky130_fd_sc_hd__decap_3
XFILLER_21_158 VPWR VGND VPWR VGND sky130_fd_sc_hd__decap_3
XFILLER_21_125 VPWR VGND VPWR VGND sky130_fd_sc_hd__decap_3
XFILLER_16_88 VPWR VGND VPWR VGND sky130_fd_sc_hd__decap_3
XFILLER_16_77 VPWR VGND VPWR VGND sky130_fd_sc_hd__decap_3
XFILLER_16_44 VPWR VGND VPWR VGND sky130_fd_sc_hd__decap_3
XFILLER_8_118 VPWR VGND VPWR VGND sky130_fd_sc_hd__decap_3
XFILLER_12_103 VPWR VGND VPWR VGND sky130_fd_sc_hd__decap_3
XFILLER_12_136 VPWR VGND VPWR VGND sky130_fd_sc_hd__decap_3
XFILLER_12_147 VPWR VGND VPWR VGND sky130_fd_sc_hd__decap_3
XFILLER_4_324 VPWR VGND VPWR VGND sky130_fd_sc_hd__decap_3
XFILLER_7_140 VPWR VGND VPWR VGND sky130_fd_sc_hd__decap_3
XFILLER_7_184 VPWR VGND VPWR VGND sky130_fd_sc_hd__decap_3
XFILLER_1_305 VPWR VGND VPWR VGND sky130_fd_sc_hd__decap_3
XFILLER_17_228 VPWR VGND VPWR VGND sky130_fd_sc_hd__decap_3
XFILLER_17_217 VPWR VGND VPWR VGND sky130_fd_sc_hd__decap_3
XFILLER_4_47 VPWR VGND VPWR VGND sky130_fd_sc_hd__decap_3
XFILLER_4_121 VPWR VGND VPWR VGND sky130_fd_sc_hd__decap_3
XFILLER_4_165 VPWR VGND VPWR VGND sky130_fd_sc_hd__decap_3
XFILLER_16_283 VPWR VGND VPWR VGND sky130_fd_sc_hd__decap_3
XFILLER_14_209 VPWR VGND VPWR VGND sky130_fd_sc_hd__decap_3
XFILLER_22_286 VPWR VGND VPWR VGND sky130_fd_sc_hd__decap_3
XFILLER_22_253 VPWR VGND VPWR VGND sky130_fd_sc_hd__decap_3
XFILLER_22_242 VPWR VGND VPWR VGND sky130_fd_sc_hd__decap_3
XFILLER_13_45 VPWR VGND VPWR VGND sky130_fd_sc_hd__decap_3
XFILLER_13_12 VPWR VGND VPWR VGND sky130_fd_sc_hd__decap_3
XFILLER_13_78 VPWR VGND VPWR VGND sky130_fd_sc_hd__decap_3
XFILLER_1_102 VPWR VGND VPWR VGND sky130_fd_sc_hd__decap_3
XFILLER_1_113 VPWR VGND VPWR VGND sky130_fd_sc_hd__decap_3
XFILLER_1_146 VPWR VGND VPWR VGND sky130_fd_sc_hd__decap_3
XFILLER_13_231 VPWR VGND VPWR VGND sky130_fd_sc_hd__decap_3
XFILLER_13_220 VPWR VGND VPWR VGND sky130_fd_sc_hd__decap_3
XFILLER_13_264 VPWR VGND VPWR VGND sky130_fd_sc_hd__decap_3
XFILLER_9_202 VPWR VGND VPWR VGND sky130_fd_sc_hd__decap_3
XFILLER_9_246 VPWR VGND VPWR VGND sky130_fd_sc_hd__decap_3
XFILLER_0_190 VPWR VGND VPWR VGND sky130_fd_sc_hd__decap_3
XFILLER_5_90 VPWR VGND VPWR VGND sky130_fd_sc_hd__decap_3
XFILLER_6_227 VPWR VGND VPWR VGND sky130_fd_sc_hd__decap_3
XFILLER_10_212 VPWR VGND VPWR VGND sky130_fd_sc_hd__decap_3
XFILLER_10_245 VPWR VGND VPWR VGND sky130_fd_sc_hd__decap_3
XFILLER_10_256 VPWR VGND VPWR VGND sky130_fd_sc_hd__decap_3
XFILLER_10_289 VPWR VGND VPWR VGND sky130_fd_sc_hd__decap_3
XFILLER_18_312 VPWR VGND VPWR VGND sky130_fd_sc_hd__decap_3
XFILLER_18_301 VPWR VGND VPWR VGND sky130_fd_sc_hd__decap_3
XFILLER_1_15 VPWR VGND VPWR VGND sky130_fd_sc_hd__decap_3
XFILLER_1_48 VPWR VGND VPWR VGND sky130_fd_sc_hd__decap_3
XPHY_EDGE_ROW_18_Right_18 VPWR VGND VPWR VGND sky130_fd_sc_hd__decap_3
XFILLER_5_293 VPWR VGND VPWR VGND sky130_fd_sc_hd__decap_3
Xinput3 VGND VPWR VPWR VGND ui_in[0] _00_/D sky130_fd_sc_hd__clkdlybuf4s25_1
XFILLER_3_208 VPWR VGND VPWR VGND sky130_fd_sc_hd__decap_3
XFILLER_10_24 VPWR VGND VPWR VGND sky130_fd_sc_hd__decap_3
XFILLER_10_35 VPWR VGND VPWR VGND sky130_fd_sc_hd__decap_3
XFILLER_10_68 VPWR VGND VPWR VGND sky130_fd_sc_hd__decap_3
XFILLER_19_99 VPWR VGND VPWR VGND sky130_fd_sc_hd__decap_3
XFILLER_19_66 VPWR VGND VPWR VGND sky130_fd_sc_hd__decap_3
XFILLER_19_33 VPWR VGND VPWR VGND sky130_fd_sc_hd__decap_3
XFILLER_15_326 VPWR VGND VPWR VGND sky130_fd_sc_hd__decap_3
X_01_ VGND VPWR VPWR VGND _01_/CLK _25_/A input2/X _24_/A sky130_fd_sc_hd__dfrtp_2
XFILLER_2_274 VPWR VGND VPWR VGND sky130_fd_sc_hd__decap_3
XFILLER_2_230 VPWR VGND VPWR VGND sky130_fd_sc_hd__decap_3
XFILLER_18_197 VPWR VGND VPWR VGND sky130_fd_sc_hd__decap_3
XFILLER_18_186 VPWR VGND VPWR VGND sky130_fd_sc_hd__decap_3
XFILLER_18_153 VPWR VGND VPWR VGND sky130_fd_sc_hd__decap_3
XFILLER_21_329 VPWR VGND VPWR VGND sky130_fd_sc_hd__decap_3
XFILLER_2_91 VPWR VGND VPWR VGND sky130_fd_sc_hd__decap_3
XFILLER_2_80 VPWR VGND VPWR VGND sky130_fd_sc_hd__decap_3
XFILLER_12_318 VPWR VGND VPWR VGND sky130_fd_sc_hd__decap_3
XFILLER_21_78 VPWR VGND VPWR VGND sky130_fd_sc_hd__decap_3
XFILLER_21_45 VPWR VGND VPWR VGND sky130_fd_sc_hd__decap_3
XFILLER_21_12 VPWR VGND VPWR VGND sky130_fd_sc_hd__decap_3
XFILLER_15_134 VPWR VGND VPWR VGND sky130_fd_sc_hd__decap_3
XFILLER_15_178 VPWR VGND VPWR VGND sky130_fd_sc_hd__decap_3
XFILLER_7_36 VPWR VGND VPWR VGND sky130_fd_sc_hd__decap_3
XFILLER_7_311 VPWR VGND VPWR VGND sky130_fd_sc_hd__decap_3
XFILLER_7_69 VPWR VGND VPWR VGND sky130_fd_sc_hd__decap_3
XFILLER_21_137 VPWR VGND VPWR VGND sky130_fd_sc_hd__decap_3
XFILLER_16_12 VPWR VGND VPWR VGND sky130_fd_sc_hd__decap_3
XFILLER_16_56 VPWR VGND VPWR VGND sky130_fd_sc_hd__decap_3
XPHY_EDGE_ROW_0_Right_0 VPWR VGND VPWR VGND sky130_fd_sc_hd__decap_3
XFILLER_12_115 VPWR VGND VPWR VGND sky130_fd_sc_hd__decap_3
XFILLER_12_159 VPWR VGND VPWR VGND sky130_fd_sc_hd__decap_3
XFILLER_7_152 VPWR VGND VPWR VGND sky130_fd_sc_hd__decap_3
XFILLER_11_181 VPWR VGND VPWR VGND sky130_fd_sc_hd__decap_3
XFILLER_7_196 VPWR VGND VPWR VGND sky130_fd_sc_hd__decap_3
XFILLER_19_281 VPWR VGND VPWR VGND sky130_fd_sc_hd__decap_3
XFILLER_19_270 VPWR VGND VPWR VGND sky130_fd_sc_hd__decap_3
XFILLER_1_317 VPWR VGND VPWR VGND sky130_fd_sc_hd__decap_3
XFILLER_4_15 VPWR VGND VPWR VGND sky130_fd_sc_hd__decap_3
XFILLER_4_59 VPWR VGND VPWR VGND sky130_fd_sc_hd__decap_3
XFILLER_4_100 VPWR VGND VPWR VGND sky130_fd_sc_hd__decap_3
XFILLER_4_133 VPWR VGND VPWR VGND sky130_fd_sc_hd__decap_3
XFILLER_4_144 VPWR VGND VPWR VGND sky130_fd_sc_hd__decap_3
XFILLER_4_177 VPWR VGND VPWR VGND sky130_fd_sc_hd__decap_3
XFILLER_16_295 VPWR VGND VPWR VGND sky130_fd_sc_hd__decap_3
XFILLER_16_262 VPWR VGND VPWR VGND sky130_fd_sc_hd__decap_3
XFILLER_22_265 VPWR VGND VPWR VGND sky130_fd_sc_hd__decap_3
XFILLER_22_221 VPWR VGND VPWR VGND sky130_fd_sc_hd__decap_3
XFILLER_13_57 VPWR VGND VPWR VGND sky130_fd_sc_hd__decap_3
XFILLER_13_24 VPWR VGND VPWR VGND sky130_fd_sc_hd__decap_3
XFILLER_1_158 VPWR VGND VPWR VGND sky130_fd_sc_hd__decap_3
XFILLER_1_125 VPWR VGND VPWR VGND sky130_fd_sc_hd__decap_3
XFILLER_8_6 VPWR VGND VPWR VGND sky130_fd_sc_hd__decap_3
XFILLER_1_169 VPWR VGND VPWR VGND sky130_fd_sc_hd__decap_3
XFILLER_13_276 VPWR VGND VPWR VGND sky130_fd_sc_hd__decap_3
XFILLER_13_243 VPWR VGND VPWR VGND sky130_fd_sc_hd__decap_3
XFILLER_9_214 VPWR VGND VPWR VGND sky130_fd_sc_hd__decap_3
XFILLER_9_225 VPWR VGND VPWR VGND sky130_fd_sc_hd__decap_3
XFILLER_13_287 VPWR VGND VPWR VGND sky130_fd_sc_hd__decap_3
XFILLER_9_258 VPWR VGND VPWR VGND sky130_fd_sc_hd__decap_3
XFILLER_8_280 VPWR VGND VPWR VGND sky130_fd_sc_hd__decap_3
XFILLER_6_206 VPWR VGND VPWR VGND sky130_fd_sc_hd__decap_3
XFILLER_6_239 VPWR VGND VPWR VGND sky130_fd_sc_hd__decap_3
XFILLER_10_224 VPWR VGND VPWR VGND sky130_fd_sc_hd__decap_3
XFILLER_10_268 VPWR VGND VPWR VGND sky130_fd_sc_hd__decap_3
XFILLER_6_3 VPWR VGND VPWR VGND sky130_fd_sc_hd__decap_3
XFILLER_18_324 VPWR VGND VPWR VGND sky130_fd_sc_hd__decap_3
XFILLER_1_27 VPWR VGND VPWR VGND sky130_fd_sc_hd__decap_3
XFILLER_5_261 VPWR VGND VPWR VGND sky130_fd_sc_hd__decap_3
XFILLER_19_12 VPWR VGND VPWR VGND sky130_fd_sc_hd__decap_3
XFILLER_10_47 VPWR VGND VPWR VGND sky130_fd_sc_hd__decap_3
XFILLER_19_78 VPWR VGND VPWR VGND sky130_fd_sc_hd__decap_3
XFILLER_19_45 VPWR VGND VPWR VGND sky130_fd_sc_hd__decap_3
XFILLER_15_305 VPWR VGND VPWR VGND sky130_fd_sc_hd__decap_3
X_00_ VGND VPWR VPWR VGND _00_/CLK _00_/D input2/X inv_a sky130_fd_sc_hd__dfrtp_2
XFILLER_2_286 VPWR VGND VPWR VGND sky130_fd_sc_hd__decap_3
XFILLER_2_253 VPWR VGND VPWR VGND sky130_fd_sc_hd__decap_3
XFILLER_2_242 VPWR VGND VPWR VGND sky130_fd_sc_hd__decap_3
XFILLER_21_308 VPWR VGND VPWR VGND sky130_fd_sc_hd__decap_3
XFILLER_18_165 VPWR VGND VPWR VGND sky130_fd_sc_hd__decap_3
XFILLER_18_121 VPWR VGND VPWR VGND sky130_fd_sc_hd__decap_3
XFILLER_20_330 VPWR VGND VPWR VGND sky130_fd_sc_hd__decap_3
XFILLER_21_57 VPWR VGND VPWR VGND sky130_fd_sc_hd__decap_3
XFILLER_21_24 VPWR VGND VPWR VGND sky130_fd_sc_hd__decap_3
XFILLER_15_146 VPWR VGND VPWR VGND sky130_fd_sc_hd__decap_3
XFILLER_15_113 VPWR VGND VPWR VGND sky130_fd_sc_hd__decap_3
XFILLER_15_102 VPWR VGND VPWR VGND sky130_fd_sc_hd__decap_3
XFILLER_23_190 VPWR VGND VPWR VGND sky130_fd_sc_hd__decap_3
XFILLER_7_15 VPWR VGND VPWR VGND sky130_fd_sc_hd__decap_3
XFILLER_7_48 VPWR VGND VPWR VGND sky130_fd_sc_hd__decap_3
XFILLER_7_323 VPWR VGND VPWR VGND sky130_fd_sc_hd__decap_3
XFILLER_11_90 VPWR VGND VPWR VGND sky130_fd_sc_hd__decap_3
XFILLER_23_6 VPWR VGND VPWR VGND sky130_fd_sc_hd__decap_3
XFILLER_21_149 VPWR VGND VPWR VGND sky130_fd_sc_hd__decap_3
XFILLER_21_116 VPWR VGND VPWR VGND sky130_fd_sc_hd__decap_3
XFILLER_21_105 VPWR VGND VPWR VGND sky130_fd_sc_hd__decap_3
XFILLER_16_68 VPWR VGND VPWR VGND sky130_fd_sc_hd__decap_3
XFILLER_16_35 VPWR VGND VPWR VGND sky130_fd_sc_hd__decap_3
XFILLER_16_24 VPWR VGND VPWR VGND sky130_fd_sc_hd__decap_3
XFILLER_20_171 VPWR VGND VPWR VGND sky130_fd_sc_hd__decap_3
XFILLER_8_109 VPWR VGND VPWR VGND sky130_fd_sc_hd__decap_3
XFILLER_12_127 VPWR VGND VPWR VGND sky130_fd_sc_hd__decap_3
XFILLER_4_304 VPWR VGND VPWR VGND sky130_fd_sc_hd__decap_3
XFILLER_4_315 VPWR VGND VPWR VGND sky130_fd_sc_hd__decap_3
XFILLER_7_131 VPWR VGND VPWR VGND sky130_fd_sc_hd__decap_3
XFILLER_7_164 VPWR VGND VPWR VGND sky130_fd_sc_hd__decap_3
XFILLER_7_175 VPWR VGND VPWR VGND sky130_fd_sc_hd__decap_3
XFILLER_11_193 VPWR VGND VPWR VGND sky130_fd_sc_hd__decap_3
XFILLER_21_3 VPWR VGND VPWR VGND sky130_fd_sc_hd__decap_3
XFILLER_19_293 VPWR VGND VPWR VGND sky130_fd_sc_hd__decap_3
XFILLER_1_329 VPWR VGND VPWR VGND sky130_fd_sc_hd__decap_3
XFILLER_8_80 VPWR VGND VPWR VGND sky130_fd_sc_hd__decap_3
XFILLER_8_91 VPWR VGND VPWR VGND sky130_fd_sc_hd__decap_3
XFILLER_17_208 VPWR VGND VPWR VGND sky130_fd_sc_hd__decap_3
XFILLER_4_112 VPWR VGND VPWR VGND sky130_fd_sc_hd__decap_3
XFILLER_4_38 VPWR VGND VPWR VGND sky130_fd_sc_hd__decap_3
XFILLER_4_156 VPWR VGND VPWR VGND sky130_fd_sc_hd__decap_3
XFILLER_4_189 VPWR VGND VPWR VGND sky130_fd_sc_hd__decap_3
XFILLER_16_230 VPWR VGND VPWR VGND sky130_fd_sc_hd__decap_3
XFILLER_16_274 VPWR VGND VPWR VGND sky130_fd_sc_hd__decap_3
XFILLER_22_233 VPWR VGND VPWR VGND sky130_fd_sc_hd__decap_3
XFILLER_22_277 VPWR VGND VPWR VGND sky130_fd_sc_hd__decap_3
XFILLER_13_69 VPWR VGND VPWR VGND sky130_fd_sc_hd__decap_3
XFILLER_13_36 VPWR VGND VPWR VGND sky130_fd_sc_hd__decap_3
XFILLER_1_137 VPWR VGND VPWR VGND sky130_fd_sc_hd__decap_3
XFILLER_13_299 VPWR VGND VPWR VGND sky130_fd_sc_hd__decap_3
XFILLER_13_255 VPWR VGND VPWR VGND sky130_fd_sc_hd__decap_3
XFILLER_13_211 VPWR VGND VPWR VGND sky130_fd_sc_hd__decap_3
XFILLER_9_237 VPWR VGND VPWR VGND sky130_fd_sc_hd__decap_3
XFILLER_0_181 VPWR VGND VPWR VGND sky130_fd_sc_hd__decap_3
XFILLER_5_81 VPWR VGND VPWR VGND sky130_fd_sc_hd__decap_3
XFILLER_8_292 VPWR VGND VPWR VGND sky130_fd_sc_hd__decap_3
XFILLER_10_203 VPWR VGND VPWR VGND sky130_fd_sc_hd__decap_3
XFILLER_6_218 VPWR VGND VPWR VGND sky130_fd_sc_hd__decap_3
XFILLER_10_236 VPWR VGND VPWR VGND sky130_fd_sc_hd__decap_3
XPHY_EDGE_ROW_23_Left_47 VPWR VGND VPWR VGND sky130_fd_sc_hd__decap_3
XFILLER_1_39 VPWR VGND VPWR VGND sky130_fd_sc_hd__decap_3
XFILLER_5_240 VPWR VGND VPWR VGND sky130_fd_sc_hd__decap_3
XFILLER_5_273 VPWR VGND VPWR VGND sky130_fd_sc_hd__decap_3
XFILLER_5_284 VPWR VGND VPWR VGND sky130_fd_sc_hd__decap_3
XFILLER_10_15 VPWR VGND VPWR VGND sky130_fd_sc_hd__decap_3
XFILLER_19_24 VPWR VGND VPWR VGND sky130_fd_sc_hd__decap_3
XFILLER_10_59 VPWR VGND VPWR VGND sky130_fd_sc_hd__decap_3
XFILLER_19_57 VPWR VGND VPWR VGND sky130_fd_sc_hd__decap_3
XFILLER_15_317 VPWR VGND VPWR VGND sky130_fd_sc_hd__decap_3
XFILLER_2_265 VPWR VGND VPWR VGND sky130_fd_sc_hd__decap_3
XFILLER_2_221 VPWR VGND VPWR VGND sky130_fd_sc_hd__decap_3
XFILLER_18_133 VPWR VGND VPWR VGND sky130_fd_sc_hd__decap_3
XFILLER_18_100 VPWR VGND VPWR VGND sky130_fd_sc_hd__decap_3
XFILLER_18_9 VPWR VGND VPWR VGND sky130_fd_sc_hd__decap_3
XFILLER_2_298 VPWR VGND VPWR VGND sky130_fd_sc_hd__decap_3
XFILLER_18_177 VPWR VGND VPWR VGND sky130_fd_sc_hd__decap_3
XFILLER_18_144 VPWR VGND VPWR VGND sky130_fd_sc_hd__decap_3
XFILLER_2_71 VPWR VGND VPWR VGND sky130_fd_sc_hd__decap_3
XFILLER_12_309 VPWR VGND VPWR VGND sky130_fd_sc_hd__decap_3
XFILLER_21_69 VPWR VGND VPWR VGND sky130_fd_sc_hd__decap_3
XFILLER_21_36 VPWR VGND VPWR VGND sky130_fd_sc_hd__decap_3
XFILLER_15_169 VPWR VGND VPWR VGND sky130_fd_sc_hd__decap_3
XFILLER_15_158 VPWR VGND VPWR VGND sky130_fd_sc_hd__decap_3
XFILLER_15_125 VPWR VGND VPWR VGND sky130_fd_sc_hd__decap_3
XFILLER_7_27 VPWR VGND VPWR VGND sky130_fd_sc_hd__decap_3
XFILLER_7_302 VPWR VGND VPWR VGND sky130_fd_sc_hd__decap_3
XFILLER_11_320 VPWR VGND VPWR VGND sky130_fd_sc_hd__decap_3
XFILLER_16_6 VPWR VGND VPWR VGND sky130_fd_sc_hd__decap_3
XFILLER_21_128 VPWR VGND VPWR VGND sky130_fd_sc_hd__decap_3
XFILLER_14_180 VPWR VGND VPWR VGND sky130_fd_sc_hd__decap_3
XPHY_EDGE_ROW_10_Left_34 VPWR VGND VPWR VGND sky130_fd_sc_hd__decap_3
XFILLER_16_47 VPWR VGND VPWR VGND sky130_fd_sc_hd__decap_3
XFILLER_12_106 VPWR VGND VPWR VGND sky130_fd_sc_hd__decap_3
XFILLER_20_150 VPWR VGND VPWR VGND sky130_fd_sc_hd__decap_3
XFILLER_4_327 VPWR VGND VPWR VGND sky130_fd_sc_hd__decap_3
XFILLER_7_143 VPWR VGND VPWR VGND sky130_fd_sc_hd__decap_3
XFILLER_7_187 VPWR VGND VPWR VGND sky130_fd_sc_hd__decap_3
XFILLER_11_161 VPWR VGND VPWR VGND sky130_fd_sc_hd__decap_3
XFILLER_11_172 VPWR VGND VPWR VGND sky130_fd_sc_hd__decap_3
XFILLER_14_3 VPWR VGND VPWR VGND sky130_fd_sc_hd__decap_3
XFILLER_19_261 VPWR VGND VPWR VGND sky130_fd_sc_hd__decap_3
XFILLER_1_308 VPWR VGND VPWR VGND sky130_fd_sc_hd__decap_3
XFILLER_4_124 VPWR VGND VPWR VGND sky130_fd_sc_hd__decap_3
XFILLER_0_330 VPWR VGND VPWR VGND sky130_fd_sc_hd__decap_3
XFILLER_4_168 VPWR VGND VPWR VGND sky130_fd_sc_hd__decap_3
XFILLER_17_90 VPWR VGND VPWR VGND sky130_fd_sc_hd__decap_3
XFILLER_16_253 VPWR VGND VPWR VGND sky130_fd_sc_hd__decap_3
XFILLER_16_242 VPWR VGND VPWR VGND sky130_fd_sc_hd__decap_3
XFILLER_16_286 VPWR VGND VPWR VGND sky130_fd_sc_hd__decap_3
XFILLER_3_190 VPWR VGND VPWR VGND sky130_fd_sc_hd__decap_3
XFILLER_22_256 VPWR VGND VPWR VGND sky130_fd_sc_hd__decap_3
XFILLER_22_245 VPWR VGND VPWR VGND sky130_fd_sc_hd__decap_3
XFILLER_13_15 VPWR VGND VPWR VGND sky130_fd_sc_hd__decap_3
XFILLER_22_289 VPWR VGND VPWR VGND sky130_fd_sc_hd__decap_3
XFILLER_13_48 VPWR VGND VPWR VGND sky130_fd_sc_hd__decap_3
XFILLER_1_149 VPWR VGND VPWR VGND sky130_fd_sc_hd__decap_3
XFILLER_1_105 VPWR VGND VPWR VGND sky130_fd_sc_hd__decap_3
XFILLER_1_116 VPWR VGND VPWR VGND sky130_fd_sc_hd__decap_3
XFILLER_13_267 VPWR VGND VPWR VGND sky130_fd_sc_hd__decap_3
XFILLER_13_234 VPWR VGND VPWR VGND sky130_fd_sc_hd__decap_3
XFILLER_9_205 VPWR VGND VPWR VGND sky130_fd_sc_hd__decap_3
XFILLER_9_249 VPWR VGND VPWR VGND sky130_fd_sc_hd__decap_3
Xmisfit01_core_20 uo_out[6] misfit01_core_20/HI VPWR VGND VGND VPWR sky130_fd_sc_hd__conb_1
XFILLER_0_193 VPWR VGND VPWR VGND sky130_fd_sc_hd__decap_3
XFILLER_8_271 VPWR VGND VPWR VGND sky130_fd_sc_hd__decap_3
XFILLER_5_60 VPWR VGND VPWR VGND sky130_fd_sc_hd__decap_3
XFILLER_5_93 VPWR VGND VPWR VGND sky130_fd_sc_hd__decap_3
XFILLER_10_215 VPWR VGND VPWR VGND sky130_fd_sc_hd__decap_3
XFILLER_10_248 VPWR VGND VPWR VGND sky130_fd_sc_hd__decap_3
XFILLER_10_259 VPWR VGND VPWR VGND sky130_fd_sc_hd__decap_3
XFILLER_18_315 VPWR VGND VPWR VGND sky130_fd_sc_hd__decap_3
XFILLER_18_304 VPWR VGND VPWR VGND sky130_fd_sc_hd__decap_3
XFILLER_1_18 VPWR VGND VPWR VGND sky130_fd_sc_hd__decap_3
XFILLER_14_91 VPWR VGND VPWR VGND sky130_fd_sc_hd__decap_3
XFILLER_14_80 VPWR VGND VPWR VGND sky130_fd_sc_hd__decap_3
XFILLER_5_252 VPWR VGND VPWR VGND sky130_fd_sc_hd__decap_3
XFILLER_5_296 VPWR VGND VPWR VGND sky130_fd_sc_hd__decap_3
XFILLER_10_38 VPWR VGND VPWR VGND sky130_fd_sc_hd__decap_3
XFILLER_19_69 VPWR VGND VPWR VGND sky130_fd_sc_hd__decap_3
XFILLER_19_36 VPWR VGND VPWR VGND sky130_fd_sc_hd__decap_3
XFILLER_15_329 VPWR VGND VPWR VGND sky130_fd_sc_hd__decap_3
XPHY_EDGE_ROW_14_Right_14 VPWR VGND VPWR VGND sky130_fd_sc_hd__decap_3
XPHY_EDGE_ROW_23_Right_23 VPWR VGND VPWR VGND sky130_fd_sc_hd__decap_3
XFILLER_2_277 VPWR VGND VPWR VGND sky130_fd_sc_hd__decap_3
XFILLER_2_233 VPWR VGND VPWR VGND sky130_fd_sc_hd__decap_3
XFILLER_2_200 VPWR VGND VPWR VGND sky130_fd_sc_hd__decap_3
XFILLER_18_156 VPWR VGND VPWR VGND sky130_fd_sc_hd__decap_3
XFILLER_18_112 VPWR VGND VPWR VGND sky130_fd_sc_hd__decap_3
XFILLER_18_189 VPWR VGND VPWR VGND sky130_fd_sc_hd__decap_3
XFILLER_2_50 VPWR VGND VPWR VGND sky130_fd_sc_hd__decap_3
XFILLER_2_94 VPWR VGND VPWR VGND sky130_fd_sc_hd__decap_3
XFILLER_21_15 VPWR VGND VPWR VGND sky130_fd_sc_hd__decap_3
XFILLER_20_321 VPWR VGND VPWR VGND sky130_fd_sc_hd__decap_3
XFILLER_21_48 VPWR VGND VPWR VGND sky130_fd_sc_hd__decap_3
XFILLER_15_137 VPWR VGND VPWR VGND sky130_fd_sc_hd__decap_3
XFILLER_11_332 VPWR VGND VPWR VGND sky130_fd_sc_hd__decap_3
XFILLER_7_39 VPWR VGND VPWR VGND sky130_fd_sc_hd__decap_3
XFILLER_7_314 VPWR VGND VPWR VGND sky130_fd_sc_hd__decap_3
XFILLER_11_81 VPWR VGND VPWR VGND sky130_fd_sc_hd__decap_3
XFILLER_14_192 VPWR VGND VPWR VGND sky130_fd_sc_hd__decap_3
XFILLER_16_59 VPWR VGND VPWR VGND sky130_fd_sc_hd__decap_3
XFILLER_16_15 VPWR VGND VPWR VGND sky130_fd_sc_hd__decap_3
XFILLER_12_118 VPWR VGND VPWR VGND sky130_fd_sc_hd__decap_3
XFILLER_20_162 VPWR VGND VPWR VGND sky130_fd_sc_hd__decap_3
XFILLER_7_122 VPWR VGND VPWR VGND sky130_fd_sc_hd__decap_3
XFILLER_11_140 VPWR VGND VPWR VGND sky130_fd_sc_hd__decap_3
XFILLER_22_91 VPWR VGND VPWR VGND sky130_fd_sc_hd__decap_3
XFILLER_22_80 VPWR VGND VPWR VGND sky130_fd_sc_hd__decap_3
XFILLER_7_155 VPWR VGND VPWR VGND sky130_fd_sc_hd__decap_3
XFILLER_7_199 VPWR VGND VPWR VGND sky130_fd_sc_hd__decap_3
XFILLER_11_184 VPWR VGND VPWR VGND sky130_fd_sc_hd__decap_3
XFILLER_19_240 VPWR VGND VPWR VGND sky130_fd_sc_hd__decap_3
XFILLER_19_284 VPWR VGND VPWR VGND sky130_fd_sc_hd__decap_3
XFILLER_19_273 VPWR VGND VPWR VGND sky130_fd_sc_hd__decap_3
XFILLER_8_71 VPWR VGND VPWR VGND sky130_fd_sc_hd__decap_3
XPHY_EDGE_ROW_4_Right_4 VPWR VGND VPWR VGND sky130_fd_sc_hd__decap_3
XFILLER_4_18 VPWR VGND VPWR VGND sky130_fd_sc_hd__decap_3
XFILLER_4_29 VPWR VGND VPWR VGND sky130_fd_sc_hd__decap_3
XFILLER_4_103 VPWR VGND VPWR VGND sky130_fd_sc_hd__decap_3
XFILLER_4_136 VPWR VGND VPWR VGND sky130_fd_sc_hd__decap_3
XFILLER_4_147 VPWR VGND VPWR VGND sky130_fd_sc_hd__decap_3
XFILLER_16_298 VPWR VGND VPWR VGND sky130_fd_sc_hd__decap_3
XFILLER_16_265 VPWR VGND VPWR VGND sky130_fd_sc_hd__decap_3
XFILLER_16_221 VPWR VGND VPWR VGND sky130_fd_sc_hd__decap_3
XFILLER_22_268 VPWR VGND VPWR VGND sky130_fd_sc_hd__decap_3
XFILLER_22_224 VPWR VGND VPWR VGND sky130_fd_sc_hd__decap_3
XFILLER_13_27 VPWR VGND VPWR VGND sky130_fd_sc_hd__decap_3
XFILLER_1_128 VPWR VGND VPWR VGND sky130_fd_sc_hd__decap_3
XFILLER_8_9 VPWR VGND VPWR VGND sky130_fd_sc_hd__decap_3
XFILLER_13_202 VPWR VGND VPWR VGND sky130_fd_sc_hd__decap_3
Xmisfit01_core_21 uo_out[7] misfit01_core_21/HI VPWR VGND VGND VPWR sky130_fd_sc_hd__conb_1
Xmisfit01_core_10 uio_out[2] misfit01_core_10/HI VPWR VGND VGND VPWR sky130_fd_sc_hd__conb_1
XFILLER_21_290 VPWR VGND VPWR VGND sky130_fd_sc_hd__decap_3
XFILLER_13_246 VPWR VGND VPWR VGND sky130_fd_sc_hd__decap_3
XFILLER_9_217 VPWR VGND VPWR VGND sky130_fd_sc_hd__decap_3
XFILLER_9_228 VPWR VGND VPWR VGND sky130_fd_sc_hd__decap_3
XFILLER_0_172 VPWR VGND VPWR VGND sky130_fd_sc_hd__decap_3
XFILLER_0_150 VPWR VGND VPWR VGND sky130_fd_sc_hd__decap_3
XFILLER_8_283 VPWR VGND VPWR VGND sky130_fd_sc_hd__decap_3
XFILLER_5_72 VPWR VGND VPWR VGND sky130_fd_sc_hd__decap_3
XFILLER_6_209 VPWR VGND VPWR VGND sky130_fd_sc_hd__decap_3
XFILLER_10_227 VPWR VGND VPWR VGND sky130_fd_sc_hd__decap_3
XFILLER_6_6 VPWR VGND VPWR VGND sky130_fd_sc_hd__decap_3
XFILLER_18_327 VPWR VGND VPWR VGND sky130_fd_sc_hd__decap_3
XFILLER_5_220 VPWR VGND VPWR VGND sky130_fd_sc_hd__decap_3
XFILLER_5_231 VPWR VGND VPWR VGND sky130_fd_sc_hd__decap_3
XFILLER_5_264 VPWR VGND VPWR VGND sky130_fd_sc_hd__decap_3
XFILLER_19_48 VPWR VGND VPWR VGND sky130_fd_sc_hd__decap_3
XFILLER_19_15 VPWR VGND VPWR VGND sky130_fd_sc_hd__decap_3
XFILLER_23_330 VPWR VGND VPWR VGND sky130_fd_sc_hd__decap_3
XFILLER_15_308 VPWR VGND VPWR VGND sky130_fd_sc_hd__decap_3
XFILLER_2_289 VPWR VGND VPWR VGND sky130_fd_sc_hd__decap_3
XFILLER_2_256 VPWR VGND VPWR VGND sky130_fd_sc_hd__decap_3
XFILLER_2_245 VPWR VGND VPWR VGND sky130_fd_sc_hd__decap_3
XFILLER_2_212 VPWR VGND VPWR VGND sky130_fd_sc_hd__decap_3
XFILLER_4_3 VPWR VGND VPWR VGND sky130_fd_sc_hd__decap_3
XFILLER_18_168 VPWR VGND VPWR VGND sky130_fd_sc_hd__decap_3
XFILLER_18_124 VPWR VGND VPWR VGND sky130_fd_sc_hd__decap_3
XFILLER_14_330 VPWR VGND VPWR VGND sky130_fd_sc_hd__decap_3
XFILLER_2_62 VPWR VGND VPWR VGND sky130_fd_sc_hd__decap_3
XFILLER_17_190 VPWR VGND VPWR VGND sky130_fd_sc_hd__decap_3
XFILLER_21_27 VPWR VGND VPWR VGND sky130_fd_sc_hd__decap_3
XFILLER_15_116 VPWR VGND VPWR VGND sky130_fd_sc_hd__decap_3
XFILLER_15_105 VPWR VGND VPWR VGND sky130_fd_sc_hd__decap_3
XFILLER_23_193 VPWR VGND VPWR VGND sky130_fd_sc_hd__decap_3
XFILLER_23_160 VPWR VGND VPWR VGND sky130_fd_sc_hd__decap_3
XFILLER_15_149 VPWR VGND VPWR VGND sky130_fd_sc_hd__decap_3
XFILLER_7_18 VPWR VGND VPWR VGND sky130_fd_sc_hd__decap_3
XFILLER_11_311 VPWR VGND VPWR VGND sky130_fd_sc_hd__decap_3
XFILLER_7_326 VPWR VGND VPWR VGND sky130_fd_sc_hd__decap_3
XFILLER_11_60 VPWR VGND VPWR VGND sky130_fd_sc_hd__decap_3
XFILLER_11_93 VPWR VGND VPWR VGND sky130_fd_sc_hd__decap_3
XFILLER_23_9 VPWR VGND VPWR VGND sky130_fd_sc_hd__decap_3
XFILLER_21_108 VPWR VGND VPWR VGND sky130_fd_sc_hd__decap_3
XFILLER_21_119 VPWR VGND VPWR VGND sky130_fd_sc_hd__decap_3
XFILLER_14_171 VPWR VGND VPWR VGND sky130_fd_sc_hd__decap_3
XFILLER_20_141 VPWR VGND VPWR VGND sky130_fd_sc_hd__decap_3
XFILLER_20_130 VPWR VGND VPWR VGND sky130_fd_sc_hd__decap_3
XFILLER_16_38 VPWR VGND VPWR VGND sky130_fd_sc_hd__decap_3
XFILLER_4_318 VPWR VGND VPWR VGND sky130_fd_sc_hd__decap_3
XFILLER_7_134 VPWR VGND VPWR VGND sky130_fd_sc_hd__decap_3
XFILLER_11_152 VPWR VGND VPWR VGND sky130_fd_sc_hd__decap_3
XFILLER_11_196 VPWR VGND VPWR VGND sky130_fd_sc_hd__decap_3
XFILLER_7_178 VPWR VGND VPWR VGND sky130_fd_sc_hd__decap_3
XFILLER_21_6 VPWR VGND VPWR VGND sky130_fd_sc_hd__decap_3
XFILLER_19_252 VPWR VGND VPWR VGND sky130_fd_sc_hd__decap_3
XFILLER_19_296 VPWR VGND VPWR VGND sky130_fd_sc_hd__decap_3
XFILLER_8_50 VPWR VGND VPWR VGND sky130_fd_sc_hd__decap_3
XFILLER_8_94 VPWR VGND VPWR VGND sky130_fd_sc_hd__decap_3
XFILLER_0_321 VPWR VGND VPWR VGND sky130_fd_sc_hd__decap_3
XFILLER_4_115 VPWR VGND VPWR VGND sky130_fd_sc_hd__decap_3
XFILLER_4_159 VPWR VGND VPWR VGND sky130_fd_sc_hd__decap_3
XFILLER_17_81 VPWR VGND VPWR VGND sky130_fd_sc_hd__decap_3
XFILLER_16_277 VPWR VGND VPWR VGND sky130_fd_sc_hd__decap_3
XFILLER_16_233 VPWR VGND VPWR VGND sky130_fd_sc_hd__decap_3
XFILLER_16_200 VPWR VGND VPWR VGND sky130_fd_sc_hd__decap_3
XFILLER_3_181 VPWR VGND VPWR VGND sky130_fd_sc_hd__decap_3
XFILLER_22_236 VPWR VGND VPWR VGND sky130_fd_sc_hd__decap_3
XFILLER_13_39 VPWR VGND VPWR VGND sky130_fd_sc_hd__decap_3
XFILLER_13_258 VPWR VGND VPWR VGND sky130_fd_sc_hd__decap_3
XFILLER_13_225 VPWR VGND VPWR VGND sky130_fd_sc_hd__decap_3
XFILLER_13_214 VPWR VGND VPWR VGND sky130_fd_sc_hd__decap_3
Xmisfit01_core_11 uio_out[3] misfit01_core_11/HI VPWR VGND VGND VPWR sky130_fd_sc_hd__conb_1
Xmisfit01_core_22 uio_oe[0] misfit01_core_22/HI VPWR VGND VGND VPWR sky130_fd_sc_hd__conb_1
XFILLER_0_162 VPWR VGND VPWR VGND sky130_fd_sc_hd__decap_3
XFILLER_0_184 VPWR VGND VPWR VGND sky130_fd_sc_hd__decap_3
XFILLER_12_280 VPWR VGND VPWR VGND sky130_fd_sc_hd__decap_3
XFILLER_5_51 VPWR VGND VPWR VGND sky130_fd_sc_hd__decap_3
XFILLER_8_262 VPWR VGND VPWR VGND sky130_fd_sc_hd__decap_3
XFILLER_8_295 VPWR VGND VPWR VGND sky130_fd_sc_hd__decap_3
XFILLER_5_84 VPWR VGND VPWR VGND sky130_fd_sc_hd__decap_3
XFILLER_10_206 VPWR VGND VPWR VGND sky130_fd_sc_hd__decap_3
XFILLER_10_239 VPWR VGND VPWR VGND sky130_fd_sc_hd__decap_3
XFILLER_14_71 VPWR VGND VPWR VGND sky130_fd_sc_hd__decap_3
XFILLER_5_243 VPWR VGND VPWR VGND sky130_fd_sc_hd__decap_3
XFILLER_5_276 VPWR VGND VPWR VGND sky130_fd_sc_hd__decap_3
XFILLER_5_287 VPWR VGND VPWR VGND sky130_fd_sc_hd__decap_3
XFILLER_10_18 VPWR VGND VPWR VGND sky130_fd_sc_hd__decap_3
XFILLER_10_29 VPWR VGND VPWR VGND sky130_fd_sc_hd__decap_3
XFILLER_19_27 VPWR VGND VPWR VGND sky130_fd_sc_hd__decap_3
XFILLER_2_268 VPWR VGND VPWR VGND sky130_fd_sc_hd__decap_3
XFILLER_2_224 VPWR VGND VPWR VGND sky130_fd_sc_hd__decap_3
XFILLER_18_147 VPWR VGND VPWR VGND sky130_fd_sc_hd__decap_3
XFILLER_18_136 VPWR VGND VPWR VGND sky130_fd_sc_hd__decap_3
XFILLER_18_103 VPWR VGND VPWR VGND sky130_fd_sc_hd__decap_3
XFILLER_2_85 VPWR VGND VPWR VGND sky130_fd_sc_hd__decap_3
XFILLER_2_74 VPWR VGND VPWR VGND sky130_fd_sc_hd__decap_3
XFILLER_2_41 VPWR VGND VPWR VGND sky130_fd_sc_hd__decap_3
XFILLER_1_290 VPWR VGND VPWR VGND sky130_fd_sc_hd__decap_3
XFILLER_20_312 VPWR VGND VPWR VGND sky130_fd_sc_hd__decap_3
XFILLER_20_301 VPWR VGND VPWR VGND sky130_fd_sc_hd__decap_3
XFILLER_21_39 VPWR VGND VPWR VGND sky130_fd_sc_hd__decap_3
XFILLER_15_128 VPWR VGND VPWR VGND sky130_fd_sc_hd__decap_3
XFILLER_23_172 VPWR VGND VPWR VGND sky130_fd_sc_hd__decap_3
XFILLER_7_305 VPWR VGND VPWR VGND sky130_fd_sc_hd__decap_3
XFILLER_11_323 VPWR VGND VPWR VGND sky130_fd_sc_hd__decap_3
XFILLER_11_72 VPWR VGND VPWR VGND sky130_fd_sc_hd__decap_3
XFILLER_16_9 VPWR VGND VPWR VGND sky130_fd_sc_hd__decap_3
XFILLER_14_150 VPWR VGND VPWR VGND sky130_fd_sc_hd__decap_3
XFILLER_14_183 VPWR VGND VPWR VGND sky130_fd_sc_hd__decap_3
Xclkbuf_1_0__f_clk VGND VPWR VGND VPWR clkbuf_0_clk/X _01_/CLK sky130_fd_sc_hd__clkbuf_16
XFILLER_20_153 VPWR VGND VPWR VGND sky130_fd_sc_hd__decap_3
XFILLER_12_109 VPWR VGND VPWR VGND sky130_fd_sc_hd__decap_3
XFILLER_20_197 VPWR VGND VPWR VGND sky130_fd_sc_hd__decap_3
XFILLER_22_71 VPWR VGND VPWR VGND sky130_fd_sc_hd__decap_3
XFILLER_7_102 VPWR VGND VPWR VGND sky130_fd_sc_hd__decap_3
XFILLER_7_113 VPWR VGND VPWR VGND sky130_fd_sc_hd__decap_3
XFILLER_7_146 VPWR VGND VPWR VGND sky130_fd_sc_hd__decap_3
XFILLER_11_131 VPWR VGND VPWR VGND sky130_fd_sc_hd__decap_3
XFILLER_11_164 VPWR VGND VPWR VGND sky130_fd_sc_hd__decap_3
XFILLER_11_175 VPWR VGND VPWR VGND sky130_fd_sc_hd__decap_3
XFILLER_19_264 VPWR VGND VPWR VGND sky130_fd_sc_hd__decap_3
XFILLER_19_231 VPWR VGND VPWR VGND sky130_fd_sc_hd__decap_3
XFILLER_19_220 VPWR VGND VPWR VGND sky130_fd_sc_hd__decap_3
XFILLER_14_6 VPWR VGND VPWR VGND sky130_fd_sc_hd__decap_3
XPHY_EDGE_ROW_14_Left_38 VPWR VGND VPWR VGND sky130_fd_sc_hd__decap_3
XFILLER_8_62 VPWR VGND VPWR VGND sky130_fd_sc_hd__decap_3
XFILLER_4_127 VPWR VGND VPWR VGND sky130_fd_sc_hd__decap_3
XFILLER_16_212 VPWR VGND VPWR VGND sky130_fd_sc_hd__decap_3
XFILLER_17_93 VPWR VGND VPWR VGND sky130_fd_sc_hd__decap_3
XFILLER_17_60 VPWR VGND VPWR VGND sky130_fd_sc_hd__decap_3
XFILLER_16_289 VPWR VGND VPWR VGND sky130_fd_sc_hd__decap_3
XFILLER_16_256 VPWR VGND VPWR VGND sky130_fd_sc_hd__decap_3
XFILLER_16_245 VPWR VGND VPWR VGND sky130_fd_sc_hd__decap_3
XFILLER_3_193 VPWR VGND VPWR VGND sky130_fd_sc_hd__decap_3
XFILLER_12_3 VPWR VGND VPWR VGND sky130_fd_sc_hd__decap_3
XFILLER_22_259 VPWR VGND VPWR VGND sky130_fd_sc_hd__decap_3
XFILLER_22_248 VPWR VGND VPWR VGND sky130_fd_sc_hd__decap_3
XFILLER_13_18 VPWR VGND VPWR VGND sky130_fd_sc_hd__decap_3
XFILLER_1_108 VPWR VGND VPWR VGND sky130_fd_sc_hd__decap_3
XFILLER_1_119 VPWR VGND VPWR VGND sky130_fd_sc_hd__decap_3
XFILLER_13_237 VPWR VGND VPWR VGND sky130_fd_sc_hd__decap_3
XFILLER_9_208 VPWR VGND VPWR VGND sky130_fd_sc_hd__decap_3
Xmisfit01_core_12 uio_out[4] misfit01_core_12/HI VPWR VGND VGND VPWR sky130_fd_sc_hd__conb_1
Xmisfit01_core_23 uio_oe[1] misfit01_core_23/HI VPWR VGND VGND VPWR sky130_fd_sc_hd__conb_1
XFILLER_21_281 VPWR VGND VPWR VGND sky130_fd_sc_hd__decap_3
XFILLER_21_270 VPWR VGND VPWR VGND sky130_fd_sc_hd__decap_3
XFILLER_0_141 VPWR VGND VPWR VGND sky130_fd_sc_hd__decap_3
XFILLER_12_292 VPWR VGND VPWR VGND sky130_fd_sc_hd__decap_3
XFILLER_8_230 VPWR VGND VPWR VGND sky130_fd_sc_hd__decap_3
XFILLER_5_30 VPWR VGND VPWR VGND sky130_fd_sc_hd__decap_3
XFILLER_5_63 VPWR VGND VPWR VGND sky130_fd_sc_hd__decap_3
XFILLER_5_96 VPWR VGND VPWR VGND sky130_fd_sc_hd__decap_3
XFILLER_8_274 VPWR VGND VPWR VGND sky130_fd_sc_hd__decap_3
XPHY_EDGE_ROW_17_Left_41 VPWR VGND VPWR VGND sky130_fd_sc_hd__decap_3
XFILLER_10_218 VPWR VGND VPWR VGND sky130_fd_sc_hd__decap_3
XFILLER_18_318 VPWR VGND VPWR VGND sky130_fd_sc_hd__decap_3
XFILLER_14_94 VPWR VGND VPWR VGND sky130_fd_sc_hd__decap_3
XFILLER_14_50 VPWR VGND VPWR VGND sky130_fd_sc_hd__decap_3
XFILLER_5_211 VPWR VGND VPWR VGND sky130_fd_sc_hd__decap_3
XFILLER_5_255 VPWR VGND VPWR VGND sky130_fd_sc_hd__decap_3
XFILLER_5_299 VPWR VGND VPWR VGND sky130_fd_sc_hd__decap_3
XFILLER_19_39 VPWR VGND VPWR VGND sky130_fd_sc_hd__decap_3
XFILLER_23_321 VPWR VGND VPWR VGND sky130_fd_sc_hd__decap_3
XPHY_EDGE_ROW_2_Left_26 VPWR VGND VPWR VGND sky130_fd_sc_hd__decap_3
XFILLER_2_236 VPWR VGND VPWR VGND sky130_fd_sc_hd__decap_3
XFILLER_2_203 VPWR VGND VPWR VGND sky130_fd_sc_hd__decap_3
XFILLER_18_115 VPWR VGND VPWR VGND sky130_fd_sc_hd__decap_3
XFILLER_18_159 VPWR VGND VPWR VGND sky130_fd_sc_hd__decap_3
XFILLER_14_321 VPWR VGND VPWR VGND sky130_fd_sc_hd__decap_3
XFILLER_2_97 VPWR VGND VPWR VGND sky130_fd_sc_hd__decap_3
XFILLER_2_53 VPWR VGND VPWR VGND sky130_fd_sc_hd__decap_3
XPHY_EDGE_ROW_10_Right_10 VPWR VGND VPWR VGND sky130_fd_sc_hd__decap_3
XFILLER_20_324 VPWR VGND VPWR VGND sky130_fd_sc_hd__decap_3
XFILLER_17_181 VPWR VGND VPWR VGND sky130_fd_sc_hd__decap_3
XFILLER_21_18 VPWR VGND VPWR VGND sky130_fd_sc_hd__decap_3
XFILLER_23_184 VPWR VGND VPWR VGND sky130_fd_sc_hd__decap_3
XFILLER_7_317 VPWR VGND VPWR VGND sky130_fd_sc_hd__decap_3
XFILLER_11_302 VPWR VGND VPWR VGND sky130_fd_sc_hd__decap_3
XFILLER_11_51 VPWR VGND VPWR VGND sky130_fd_sc_hd__decap_3
XFILLER_11_84 VPWR VGND VPWR VGND sky130_fd_sc_hd__decap_3
XFILLER_14_162 VPWR VGND VPWR VGND sky130_fd_sc_hd__decap_3
XFILLER_16_29 VPWR VGND VPWR VGND sky130_fd_sc_hd__decap_3
XFILLER_16_18 VPWR VGND VPWR VGND sky130_fd_sc_hd__decap_3
XFILLER_20_165 VPWR VGND VPWR VGND sky130_fd_sc_hd__decap_3
XFILLER_20_121 VPWR VGND VPWR VGND sky130_fd_sc_hd__decap_3
XFILLER_4_309 VPWR VGND VPWR VGND sky130_fd_sc_hd__decap_3
XFILLER_22_94 VPWR VGND VPWR VGND sky130_fd_sc_hd__decap_3
XFILLER_22_50 VPWR VGND VPWR VGND sky130_fd_sc_hd__decap_3
XFILLER_3_320 VPWR VGND VPWR VGND sky130_fd_sc_hd__decap_3
XFILLER_7_125 VPWR VGND VPWR VGND sky130_fd_sc_hd__decap_3
XFILLER_7_158 VPWR VGND VPWR VGND sky130_fd_sc_hd__decap_3
XFILLER_7_169 VPWR VGND VPWR VGND sky130_fd_sc_hd__decap_3
XFILLER_11_143 VPWR VGND VPWR VGND sky130_fd_sc_hd__decap_3
XFILLER_11_187 VPWR VGND VPWR VGND sky130_fd_sc_hd__decap_3
XFILLER_19_287 VPWR VGND VPWR VGND sky130_fd_sc_hd__decap_3
XFILLER_19_276 VPWR VGND VPWR VGND sky130_fd_sc_hd__decap_3
XFILLER_19_243 VPWR VGND VPWR VGND sky130_fd_sc_hd__decap_3
XFILLER_8_41 VPWR VGND VPWR VGND sky130_fd_sc_hd__decap_3
XFILLER_8_74 VPWR VGND VPWR VGND sky130_fd_sc_hd__decap_3
XFILLER_8_85 VPWR VGND VPWR VGND sky130_fd_sc_hd__decap_3
XFILLER_6_180 VPWR VGND VPWR VGND sky130_fd_sc_hd__decap_3
XFILLER_4_106 VPWR VGND VPWR VGND sky130_fd_sc_hd__decap_3
XFILLER_0_312 VPWR VGND VPWR VGND sky130_fd_sc_hd__decap_3
XFILLER_17_72 VPWR VGND VPWR VGND sky130_fd_sc_hd__decap_3
XFILLER_16_224 VPWR VGND VPWR VGND sky130_fd_sc_hd__decap_3
XFILLER_16_268 VPWR VGND VPWR VGND sky130_fd_sc_hd__decap_3
XFILLER_3_161 VPWR VGND VPWR VGND sky130_fd_sc_hd__decap_3
XFILLER_3_172 VPWR VGND VPWR VGND sky130_fd_sc_hd__decap_3
XFILLER_22_227 VPWR VGND VPWR VGND sky130_fd_sc_hd__decap_3
XPHY_EDGE_ROW_8_Right_8 VPWR VGND VPWR VGND sky130_fd_sc_hd__decap_3
XFILLER_15_290 VPWR VGND VPWR VGND sky130_fd_sc_hd__decap_3
XFILLER_13_249 VPWR VGND VPWR VGND sky130_fd_sc_hd__decap_3
XFILLER_13_205 VPWR VGND VPWR VGND sky130_fd_sc_hd__decap_3
Xmisfit01_core_13 uio_out[5] misfit01_core_13/HI VPWR VGND VGND VPWR sky130_fd_sc_hd__conb_1
Xmisfit01_core_24 uio_oe[2] misfit01_core_24/HI VPWR VGND VGND VPWR sky130_fd_sc_hd__conb_1
XFILLER_21_293 VPWR VGND VPWR VGND sky130_fd_sc_hd__decap_3
XFILLER_0_197 VPWR VGND VPWR VGND sky130_fd_sc_hd__decap_3
XFILLER_0_175 VPWR VGND VPWR VGND sky130_fd_sc_hd__decap_3
XFILLER_0_153 VPWR VGND VPWR VGND sky130_fd_sc_hd__decap_3
XFILLER_0_131 VPWR VGND VPWR VGND sky130_fd_sc_hd__decap_3
XFILLER_12_271 VPWR VGND VPWR VGND sky130_fd_sc_hd__decap_3
XFILLER_8_242 VPWR VGND VPWR VGND sky130_fd_sc_hd__decap_3
XFILLER_8_253 VPWR VGND VPWR VGND sky130_fd_sc_hd__decap_3
XFILLER_8_286 VPWR VGND VPWR VGND sky130_fd_sc_hd__decap_3
XFILLER_5_42 VPWR VGND VPWR VGND sky130_fd_sc_hd__decap_3
XFILLER_5_75 VPWR VGND VPWR VGND sky130_fd_sc_hd__decap_3
XFILLER_6_9 VPWR VGND VPWR VGND sky130_fd_sc_hd__decap_3
XFILLER_14_62 VPWR VGND VPWR VGND sky130_fd_sc_hd__decap_3
XFILLER_5_234 VPWR VGND VPWR VGND sky130_fd_sc_hd__decap_3
XFILLER_5_267 VPWR VGND VPWR VGND sky130_fd_sc_hd__decap_3
XFILLER_19_18 VPWR VGND VPWR VGND sky130_fd_sc_hd__decap_3
XFILLER_2_259 VPWR VGND VPWR VGND sky130_fd_sc_hd__decap_3
XFILLER_2_248 VPWR VGND VPWR VGND sky130_fd_sc_hd__decap_3
XFILLER_2_215 VPWR VGND VPWR VGND sky130_fd_sc_hd__decap_3
XFILLER_4_6 VPWR VGND VPWR VGND sky130_fd_sc_hd__decap_3
XFILLER_18_127 VPWR VGND VPWR VGND sky130_fd_sc_hd__decap_3
XFILLER_2_32 VPWR VGND VPWR VGND sky130_fd_sc_hd__decap_3
XFILLER_2_21 VPWR VGND VPWR VGND sky130_fd_sc_hd__decap_3
XFILLER_1_281 VPWR VGND VPWR VGND sky130_fd_sc_hd__decap_3
XFILLER_1_270 VPWR VGND VPWR VGND sky130_fd_sc_hd__decap_3
XFILLER_2_65 VPWR VGND VPWR VGND sky130_fd_sc_hd__decap_3
XFILLER_17_193 VPWR VGND VPWR VGND sky130_fd_sc_hd__decap_3
XFILLER_23_141 VPWR VGND VPWR VGND sky130_fd_sc_hd__decap_3
XFILLER_23_130 VPWR VGND VPWR VGND sky130_fd_sc_hd__decap_3
XFILLER_15_119 VPWR VGND VPWR VGND sky130_fd_sc_hd__decap_3
XFILLER_15_108 VPWR VGND VPWR VGND sky130_fd_sc_hd__decap_3
XFILLER_11_314 VPWR VGND VPWR VGND sky130_fd_sc_hd__decap_3
XFILLER_7_329 VPWR VGND VPWR VGND sky130_fd_sc_hd__decap_3
XFILLER_11_30 VPWR VGND VPWR VGND sky130_fd_sc_hd__decap_3
XFILLER_2_3 VPWR VGND VPWR VGND sky130_fd_sc_hd__decap_3
XFILLER_11_63 VPWR VGND VPWR VGND sky130_fd_sc_hd__decap_3
XFILLER_11_96 VPWR VGND VPWR VGND sky130_fd_sc_hd__decap_3
XFILLER_14_174 VPWR VGND VPWR VGND sky130_fd_sc_hd__decap_3
XFILLER_14_141 VPWR VGND VPWR VGND sky130_fd_sc_hd__decap_3
XFILLER_14_130 VPWR VGND VPWR VGND sky130_fd_sc_hd__decap_3
XFILLER_20_144 VPWR VGND VPWR VGND sky130_fd_sc_hd__decap_3
XFILLER_20_133 VPWR VGND VPWR VGND sky130_fd_sc_hd__decap_3
XFILLER_20_100 VPWR VGND VPWR VGND sky130_fd_sc_hd__decap_3
XFILLER_11_122 VPWR VGND VPWR VGND sky130_fd_sc_hd__decap_3
XFILLER_11_155 VPWR VGND VPWR VGND sky130_fd_sc_hd__decap_3
XFILLER_22_62 VPWR VGND VPWR VGND sky130_fd_sc_hd__decap_3
XFILLER_3_332 VPWR VGND VPWR VGND sky130_fd_sc_hd__decap_3
XFILLER_7_137 VPWR VGND VPWR VGND sky130_fd_sc_hd__decap_3
XFILLER_11_199 VPWR VGND VPWR VGND sky130_fd_sc_hd__decap_3
XFILLER_21_9 VPWR VGND VPWR VGND sky130_fd_sc_hd__decap_3
XFILLER_19_211 VPWR VGND VPWR VGND sky130_fd_sc_hd__decap_3
XFILLER_19_299 VPWR VGND VPWR VGND sky130_fd_sc_hd__decap_3
XFILLER_19_255 VPWR VGND VPWR VGND sky130_fd_sc_hd__decap_3
XFILLER_8_53 VPWR VGND VPWR VGND sky130_fd_sc_hd__decap_3
XFILLER_8_97 VPWR VGND VPWR VGND sky130_fd_sc_hd__decap_3
XFILLER_6_192 VPWR VGND VPWR VGND sky130_fd_sc_hd__decap_3
XFILLER_4_118 VPWR VGND VPWR VGND sky130_fd_sc_hd__decap_3
XFILLER_0_324 VPWR VGND VPWR VGND sky130_fd_sc_hd__decap_3
XFILLER_0_302 VPWR VGND VPWR VGND sky130_fd_sc_hd__decap_3
XFILLER_17_84 VPWR VGND VPWR VGND sky130_fd_sc_hd__decap_3
XFILLER_17_51 VPWR VGND VPWR VGND sky130_fd_sc_hd__decap_3
XFILLER_16_236 VPWR VGND VPWR VGND sky130_fd_sc_hd__decap_3
XFILLER_16_203 VPWR VGND VPWR VGND sky130_fd_sc_hd__decap_3
XFILLER_3_140 VPWR VGND VPWR VGND sky130_fd_sc_hd__decap_3
XFILLER_3_184 VPWR VGND VPWR VGND sky130_fd_sc_hd__decap_3
XFILLER_22_239 VPWR VGND VPWR VGND sky130_fd_sc_hd__decap_3
Xmisfit01_core_14 uio_out[6] misfit01_core_14/HI VPWR VGND VGND VPWR sky130_fd_sc_hd__conb_1
XFILLER_21_261 VPWR VGND VPWR VGND sky130_fd_sc_hd__decap_3
XFILLER_13_228 VPWR VGND VPWR VGND sky130_fd_sc_hd__decap_3
XFILLER_13_217 VPWR VGND VPWR VGND sky130_fd_sc_hd__decap_3
XFILLER_0_187 VPWR VGND VPWR VGND sky130_fd_sc_hd__decap_3
XFILLER_0_165 VPWR VGND VPWR VGND sky130_fd_sc_hd__decap_3
XFILLER_12_283 VPWR VGND VPWR VGND sky130_fd_sc_hd__decap_3
XFILLER_5_21 VPWR VGND VPWR VGND sky130_fd_sc_hd__decap_3
XFILLER_8_221 VPWR VGND VPWR VGND sky130_fd_sc_hd__decap_3
XFILLER_8_265 VPWR VGND VPWR VGND sky130_fd_sc_hd__decap_3
XFILLER_8_298 VPWR VGND VPWR VGND sky130_fd_sc_hd__decap_3
XFILLER_5_87 VPWR VGND VPWR VGND sky130_fd_sc_hd__decap_3
XFILLER_10_209 VPWR VGND VPWR VGND sky130_fd_sc_hd__decap_3
XFILLER_18_309 VPWR VGND VPWR VGND sky130_fd_sc_hd__decap_3
XFILLER_14_85 VPWR VGND VPWR VGND sky130_fd_sc_hd__decap_3
XFILLER_14_74 VPWR VGND VPWR VGND sky130_fd_sc_hd__decap_3
XFILLER_14_41 VPWR VGND VPWR VGND sky130_fd_sc_hd__decap_3
XFILLER_5_202 VPWR VGND VPWR VGND sky130_fd_sc_hd__decap_3
XFILLER_5_246 VPWR VGND VPWR VGND sky130_fd_sc_hd__decap_3
XFILLER_17_320 VPWR VGND VPWR VGND sky130_fd_sc_hd__decap_3
XFILLER_23_312 VPWR VGND VPWR VGND sky130_fd_sc_hd__decap_3
XFILLER_2_227 VPWR VGND VPWR VGND sky130_fd_sc_hd__decap_3
XFILLER_18_106 VPWR VGND VPWR VGND sky130_fd_sc_hd__decap_3
XFILLER_14_312 VPWR VGND VPWR VGND sky130_fd_sc_hd__decap_3
XFILLER_14_301 VPWR VGND VPWR VGND sky130_fd_sc_hd__decap_3
XFILLER_2_77 VPWR VGND VPWR VGND sky130_fd_sc_hd__decap_3
XFILLER_2_44 VPWR VGND VPWR VGND sky130_fd_sc_hd__decap_3
XFILLER_1_293 VPWR VGND VPWR VGND sky130_fd_sc_hd__decap_3
XFILLER_17_172 VPWR VGND VPWR VGND sky130_fd_sc_hd__decap_3
XFILLER_17_161 VPWR VGND VPWR VGND sky130_fd_sc_hd__decap_3
XFILLER_2_88 VPWR VGND VPWR VGND sky130_fd_sc_hd__decap_3
XFILLER_20_315 VPWR VGND VPWR VGND sky130_fd_sc_hd__decap_3
XFILLER_20_304 VPWR VGND VPWR VGND sky130_fd_sc_hd__decap_3
XFILLER_23_197 VPWR VGND VPWR VGND sky130_fd_sc_hd__decap_3
XFILLER_11_326 VPWR VGND VPWR VGND sky130_fd_sc_hd__decap_3
XFILLER_7_308 VPWR VGND VPWR VGND sky130_fd_sc_hd__decap_3
XFILLER_11_42 VPWR VGND VPWR VGND sky130_fd_sc_hd__decap_3
XFILLER_11_75 VPWR VGND VPWR VGND sky130_fd_sc_hd__decap_3
XFILLER_14_197 VPWR VGND VPWR VGND sky130_fd_sc_hd__decap_3
XFILLER_14_186 VPWR VGND VPWR VGND sky130_fd_sc_hd__decap_3
XFILLER_14_153 VPWR VGND VPWR VGND sky130_fd_sc_hd__decap_3
XFILLER_6_330 VPWR VGND VPWR VGND sky130_fd_sc_hd__decap_3
XFILLER_20_112 VPWR VGND VPWR VGND sky130_fd_sc_hd__decap_3
XFILLER_20_156 VPWR VGND VPWR VGND sky130_fd_sc_hd__decap_3
XFILLER_9_190 VPWR VGND VPWR VGND sky130_fd_sc_hd__decap_3
XFILLER_22_41 VPWR VGND VPWR VGND sky130_fd_sc_hd__decap_3
XFILLER_7_105 VPWR VGND VPWR VGND sky130_fd_sc_hd__decap_3
XFILLER_7_116 VPWR VGND VPWR VGND sky130_fd_sc_hd__decap_3
XFILLER_11_134 VPWR VGND VPWR VGND sky130_fd_sc_hd__decap_3
XFILLER_11_178 VPWR VGND VPWR VGND sky130_fd_sc_hd__decap_3
XFILLER_22_85 VPWR VGND VPWR VGND sky130_fd_sc_hd__decap_3
XFILLER_22_74 VPWR VGND VPWR VGND sky130_fd_sc_hd__decap_3
XFILLER_3_311 VPWR VGND VPWR VGND sky130_fd_sc_hd__decap_3
XFILLER_7_149 VPWR VGND VPWR VGND sky130_fd_sc_hd__decap_3
XFILLER_19_234 VPWR VGND VPWR VGND sky130_fd_sc_hd__decap_3
XFILLER_14_9 VPWR VGND VPWR VGND sky130_fd_sc_hd__decap_3
XFILLER_19_267 VPWR VGND VPWR VGND sky130_fd_sc_hd__decap_3
XFILLER_6_171 VPWR VGND VPWR VGND sky130_fd_sc_hd__decap_3
XFILLER_8_21 VPWR VGND VPWR VGND sky130_fd_sc_hd__decap_3
XFILLER_8_32 VPWR VGND VPWR VGND sky130_fd_sc_hd__decap_3
XFILLER_8_65 VPWR VGND VPWR VGND sky130_fd_sc_hd__decap_3
XFILLER_17_96 VPWR VGND VPWR VGND sky130_fd_sc_hd__decap_3
XFILLER_17_63 VPWR VGND VPWR VGND sky130_fd_sc_hd__decap_3
XFILLER_17_30 VPWR VGND VPWR VGND sky130_fd_sc_hd__decap_3
XFILLER_16_259 VPWR VGND VPWR VGND sky130_fd_sc_hd__decap_3
XFILLER_16_248 VPWR VGND VPWR VGND sky130_fd_sc_hd__decap_3
XFILLER_16_215 VPWR VGND VPWR VGND sky130_fd_sc_hd__decap_3
XFILLER_3_152 VPWR VGND VPWR VGND sky130_fd_sc_hd__decap_3
XFILLER_3_196 VPWR VGND VPWR VGND sky130_fd_sc_hd__decap_3
XFILLER_12_6 VPWR VGND VPWR VGND sky130_fd_sc_hd__decap_3
XFILLER_22_218 VPWR VGND VPWR VGND sky130_fd_sc_hd__decap_3
XFILLER_15_281 VPWR VGND VPWR VGND sky130_fd_sc_hd__decap_3
XFILLER_15_270 VPWR VGND VPWR VGND sky130_fd_sc_hd__decap_3
Xmisfit01_core_15 uio_out[7] misfit01_core_15/HI VPWR VGND VGND VPWR sky130_fd_sc_hd__conb_1
XFILLER_21_284 VPWR VGND VPWR VGND sky130_fd_sc_hd__decap_3
XFILLER_21_273 VPWR VGND VPWR VGND sky130_fd_sc_hd__decap_3
XFILLER_21_240 VPWR VGND VPWR VGND sky130_fd_sc_hd__decap_3
XFILLER_0_144 VPWR VGND VPWR VGND sky130_fd_sc_hd__decap_3
XFILLER_0_100 VPWR VGND VPWR VGND sky130_fd_sc_hd__decap_3
XFILLER_0_122 VPWR VGND VPWR VGND sky130_fd_sc_hd__decap_3
XFILLER_8_200 VPWR VGND VPWR VGND sky130_fd_sc_hd__decap_3
XFILLER_12_262 VPWR VGND VPWR VGND sky130_fd_sc_hd__decap_3
XFILLER_12_295 VPWR VGND VPWR VGND sky130_fd_sc_hd__decap_3
XFILLER_5_33 VPWR VGND VPWR VGND sky130_fd_sc_hd__decap_3
XFILLER_8_233 VPWR VGND VPWR VGND sky130_fd_sc_hd__decap_3
XFILLER_8_277 VPWR VGND VPWR VGND sky130_fd_sc_hd__decap_3
XFILLER_5_66 VPWR VGND VPWR VGND sky130_fd_sc_hd__decap_3
XFILLER_5_99 VPWR VGND VPWR VGND sky130_fd_sc_hd__decap_3
XFILLER_10_3 VPWR VGND VPWR VGND sky130_fd_sc_hd__decap_3
XFILLER_14_53 VPWR VGND VPWR VGND sky130_fd_sc_hd__decap_3
XFILLER_14_97 VPWR VGND VPWR VGND sky130_fd_sc_hd__decap_3
XFILLER_5_214 VPWR VGND VPWR VGND sky130_fd_sc_hd__decap_3
XFILLER_5_225 VPWR VGND VPWR VGND sky130_fd_sc_hd__decap_3
XFILLER_5_258 VPWR VGND VPWR VGND sky130_fd_sc_hd__decap_3
XFILLER_17_332 VPWR VGND VPWR VGND sky130_fd_sc_hd__decap_3
XFILLER_4_280 VPWR VGND VPWR VGND sky130_fd_sc_hd__decap_3
XFILLER_23_324 VPWR VGND VPWR VGND sky130_fd_sc_hd__decap_3
XFILLER_2_239 VPWR VGND VPWR VGND sky130_fd_sc_hd__decap_3
XFILLER_2_206 VPWR VGND VPWR VGND sky130_fd_sc_hd__decap_3
XFILLER_18_118 VPWR VGND VPWR VGND sky130_fd_sc_hd__decap_3
XFILLER_14_324 VPWR VGND VPWR VGND sky130_fd_sc_hd__decap_3
XFILLER_2_56 VPWR VGND VPWR VGND sky130_fd_sc_hd__decap_3
XFILLER_2_12 VPWR VGND VPWR VGND sky130_fd_sc_hd__decap_3
XFILLER_1_261 VPWR VGND VPWR VGND sky130_fd_sc_hd__decap_3
XFILLER_17_184 VPWR VGND VPWR VGND sky130_fd_sc_hd__decap_3
XFILLER_17_140 VPWR VGND VPWR VGND sky130_fd_sc_hd__decap_3
XFILLER_20_327 VPWR VGND VPWR VGND sky130_fd_sc_hd__decap_3
XFILLER_23_154 VPWR VGND VPWR VGND sky130_fd_sc_hd__decap_3
XFILLER_11_305 VPWR VGND VPWR VGND sky130_fd_sc_hd__decap_3
XFILLER_11_21 VPWR VGND VPWR VGND sky130_fd_sc_hd__decap_3
XFILLER_11_87 VPWR VGND VPWR VGND sky130_fd_sc_hd__decap_3
XFILLER_14_121 VPWR VGND VPWR VGND sky130_fd_sc_hd__decap_3
XFILLER_14_165 VPWR VGND VPWR VGND sky130_fd_sc_hd__decap_3
XFILLER_20_124 VPWR VGND VPWR VGND sky130_fd_sc_hd__decap_3
XFILLER_20_168 VPWR VGND VPWR VGND sky130_fd_sc_hd__decap_3
XFILLER_22_53 VPWR VGND VPWR VGND sky130_fd_sc_hd__decap_3
XFILLER_7_128 VPWR VGND VPWR VGND sky130_fd_sc_hd__decap_3
XFILLER_11_102 VPWR VGND VPWR VGND sky130_fd_sc_hd__decap_3
XFILLER_11_113 VPWR VGND VPWR VGND sky130_fd_sc_hd__decap_3
XFILLER_11_146 VPWR VGND VPWR VGND sky130_fd_sc_hd__decap_3
XFILLER_22_97 VPWR VGND VPWR VGND sky130_fd_sc_hd__decap_3
XFILLER_3_323 VPWR VGND VPWR VGND sky130_fd_sc_hd__decap_3
XFILLER_19_246 VPWR VGND VPWR VGND sky130_fd_sc_hd__decap_3
XFILLER_19_202 VPWR VGND VPWR VGND sky130_fd_sc_hd__decap_3
XFILLER_6_150 VPWR VGND VPWR VGND sky130_fd_sc_hd__decap_3
XFILLER_6_183 VPWR VGND VPWR VGND sky130_fd_sc_hd__decap_3
XFILLER_8_44 VPWR VGND VPWR VGND sky130_fd_sc_hd__decap_3
XFILLER_8_77 VPWR VGND VPWR VGND sky130_fd_sc_hd__decap_3
XFILLER_8_88 VPWR VGND VPWR VGND sky130_fd_sc_hd__decap_3
XFILLER_0_315 VPWR VGND VPWR VGND sky130_fd_sc_hd__decap_3
XFILLER_4_109 VPWR VGND VPWR VGND sky130_fd_sc_hd__decap_3
XPHY_EDGE_ROW_9_Left_33 VPWR VGND VPWR VGND sky130_fd_sc_hd__decap_3
XFILLER_17_75 VPWR VGND VPWR VGND sky130_fd_sc_hd__decap_3
XFILLER_17_42 VPWR VGND VPWR VGND sky130_fd_sc_hd__decap_3
XFILLER_16_227 VPWR VGND VPWR VGND sky130_fd_sc_hd__decap_3
XFILLER_3_131 VPWR VGND VPWR VGND sky130_fd_sc_hd__decap_3
XFILLER_3_164 VPWR VGND VPWR VGND sky130_fd_sc_hd__decap_3
XFILLER_3_175 VPWR VGND VPWR VGND sky130_fd_sc_hd__decap_3
XFILLER_15_293 VPWR VGND VPWR VGND sky130_fd_sc_hd__decap_3
XFILLER_13_208 VPWR VGND VPWR VGND sky130_fd_sc_hd__decap_3
Xmisfit01_core_16 uo_out[2] misfit01_core_16/HI VPWR VGND VGND VPWR sky130_fd_sc_hd__conb_1
XFILLER_21_296 VPWR VGND VPWR VGND sky130_fd_sc_hd__decap_3
XFILLER_21_252 VPWR VGND VPWR VGND sky130_fd_sc_hd__decap_3
XPHY_EDGE_ROW_17_Right_17 VPWR VGND VPWR VGND sky130_fd_sc_hd__decap_3
XFILLER_0_178 VPWR VGND VPWR VGND sky130_fd_sc_hd__decap_3
XFILLER_0_156 VPWR VGND VPWR VGND sky130_fd_sc_hd__decap_3
XFILLER_0_134 VPWR VGND VPWR VGND sky130_fd_sc_hd__decap_3
XFILLER_12_274 VPWR VGND VPWR VGND sky130_fd_sc_hd__decap_3
XFILLER_8_212 VPWR VGND VPWR VGND sky130_fd_sc_hd__decap_3
XFILLER_8_245 VPWR VGND VPWR VGND sky130_fd_sc_hd__decap_3
XFILLER_12_230 VPWR VGND VPWR VGND sky130_fd_sc_hd__decap_3
XFILLER_5_12 VPWR VGND VPWR VGND sky130_fd_sc_hd__decap_3
XFILLER_5_45 VPWR VGND VPWR VGND sky130_fd_sc_hd__decap_3
XFILLER_5_78 VPWR VGND VPWR VGND sky130_fd_sc_hd__decap_3
XFILLER_8_256 VPWR VGND VPWR VGND sky130_fd_sc_hd__decap_3
XFILLER_8_289 VPWR VGND VPWR VGND sky130_fd_sc_hd__decap_3
XFILLER_14_65 VPWR VGND VPWR VGND sky130_fd_sc_hd__decap_3
XFILLER_14_32 VPWR VGND VPWR VGND sky130_fd_sc_hd__decap_3
XFILLER_14_21 VPWR VGND VPWR VGND sky130_fd_sc_hd__decap_3
XFILLER_5_237 VPWR VGND VPWR VGND sky130_fd_sc_hd__decap_3
XFILLER_17_311 VPWR VGND VPWR VGND sky130_fd_sc_hd__decap_3
XFILLER_4_292 VPWR VGND VPWR VGND sky130_fd_sc_hd__decap_3
XFILLER_23_303 VPWR VGND VPWR VGND sky130_fd_sc_hd__decap_3
XFILLER_2_218 VPWR VGND VPWR VGND sky130_fd_sc_hd__decap_3
XFILLER_4_9 VPWR VGND VPWR VGND sky130_fd_sc_hd__decap_3
XPHY_EDGE_ROW_22_Left_46 VPWR VGND VPWR VGND sky130_fd_sc_hd__decap_3
XFILLER_1_240 VPWR VGND VPWR VGND sky130_fd_sc_hd__decap_3
XFILLER_2_68 VPWR VGND VPWR VGND sky130_fd_sc_hd__decap_3
XFILLER_2_35 VPWR VGND VPWR VGND sky130_fd_sc_hd__decap_3
XFILLER_2_24 VPWR VGND VPWR VGND sky130_fd_sc_hd__decap_3
XFILLER_1_284 VPWR VGND VPWR VGND sky130_fd_sc_hd__decap_3
XFILLER_1_273 VPWR VGND VPWR VGND sky130_fd_sc_hd__decap_3
XFILLER_17_196 VPWR VGND VPWR VGND sky130_fd_sc_hd__decap_3
XFILLER_17_152 VPWR VGND VPWR VGND sky130_fd_sc_hd__decap_3
XFILLER_23_100 VPWR VGND VPWR VGND sky130_fd_sc_hd__decap_3
XFILLER_11_317 VPWR VGND VPWR VGND sky130_fd_sc_hd__decap_3
XFILLER_2_6 VPWR VGND VPWR VGND sky130_fd_sc_hd__decap_3
XFILLER_11_33 VPWR VGND VPWR VGND sky130_fd_sc_hd__decap_3
XFILLER_11_66 VPWR VGND VPWR VGND sky130_fd_sc_hd__decap_3
XFILLER_11_99 VPWR VGND VPWR VGND sky130_fd_sc_hd__decap_3
XFILLER_14_177 VPWR VGND VPWR VGND sky130_fd_sc_hd__decap_3
XFILLER_14_144 VPWR VGND VPWR VGND sky130_fd_sc_hd__decap_3
XFILLER_14_133 VPWR VGND VPWR VGND sky130_fd_sc_hd__decap_3
XFILLER_14_100 VPWR VGND VPWR VGND sky130_fd_sc_hd__decap_3
XFILLER_6_321 VPWR VGND VPWR VGND sky130_fd_sc_hd__decap_3
XFILLER_20_147 VPWR VGND VPWR VGND sky130_fd_sc_hd__decap_3
XFILLER_20_136 VPWR VGND VPWR VGND sky130_fd_sc_hd__decap_3
XFILLER_20_103 VPWR VGND VPWR VGND sky130_fd_sc_hd__decap_3
XFILLER_9_181 VPWR VGND VPWR VGND sky130_fd_sc_hd__decap_3
XFILLER_22_65 VPWR VGND VPWR VGND sky130_fd_sc_hd__decap_3
XFILLER_22_32 VPWR VGND VPWR VGND sky130_fd_sc_hd__decap_3
XFILLER_22_21 VPWR VGND VPWR VGND sky130_fd_sc_hd__decap_3
XFILLER_3_302 VPWR VGND VPWR VGND sky130_fd_sc_hd__decap_3
XFILLER_11_125 VPWR VGND VPWR VGND sky130_fd_sc_hd__decap_3
XFILLER_11_158 VPWR VGND VPWR VGND sky130_fd_sc_hd__decap_3
XFILLER_11_169 VPWR VGND VPWR VGND sky130_fd_sc_hd__decap_3
XFILLER_0_3 VPWR VGND VPWR VGND sky130_fd_sc_hd__decap_3
XFILLER_19_258 VPWR VGND VPWR VGND sky130_fd_sc_hd__decap_3
XFILLER_19_225 VPWR VGND VPWR VGND sky130_fd_sc_hd__decap_3
XFILLER_19_214 VPWR VGND VPWR VGND sky130_fd_sc_hd__decap_3
XFILLER_8_12 VPWR VGND VPWR VGND sky130_fd_sc_hd__decap_3
XFILLER_8_56 VPWR VGND VPWR VGND sky130_fd_sc_hd__decap_3
XFILLER_6_162 VPWR VGND VPWR VGND sky130_fd_sc_hd__decap_3
XFILLER_10_180 VPWR VGND VPWR VGND sky130_fd_sc_hd__decap_3
XFILLER_18_280 VPWR VGND VPWR VGND sky130_fd_sc_hd__decap_3
XFILLER_0_327 VPWR VGND VPWR VGND sky130_fd_sc_hd__decap_3
XFILLER_0_305 VPWR VGND VPWR VGND sky130_fd_sc_hd__decap_3
XFILLER_17_21 VPWR VGND VPWR VGND sky130_fd_sc_hd__decap_3
XFILLER_16_239 VPWR VGND VPWR VGND sky130_fd_sc_hd__decap_3
XFILLER_16_206 VPWR VGND VPWR VGND sky130_fd_sc_hd__decap_3
XFILLER_17_87 VPWR VGND VPWR VGND sky130_fd_sc_hd__decap_3
XFILLER_3_143 VPWR VGND VPWR VGND sky130_fd_sc_hd__decap_3
XFILLER_3_187 VPWR VGND VPWR VGND sky130_fd_sc_hd__decap_3
XFILLER_15_261 VPWR VGND VPWR VGND sky130_fd_sc_hd__decap_3
XFILLER_21_264 VPWR VGND VPWR VGND sky130_fd_sc_hd__decap_3
XFILLER_21_231 VPWR VGND VPWR VGND sky130_fd_sc_hd__decap_3
XFILLER_21_220 VPWR VGND VPWR VGND sky130_fd_sc_hd__decap_3
Xmisfit01_core_17 uo_out[3] misfit01_core_17/HI VPWR VGND VGND VPWR sky130_fd_sc_hd__conb_1
XFILLER_0_113 VPWR VGND VPWR VGND sky130_fd_sc_hd__decap_3
XFILLER_12_286 VPWR VGND VPWR VGND sky130_fd_sc_hd__decap_3
XFILLER_8_224 VPWR VGND VPWR VGND sky130_fd_sc_hd__decap_3
XFILLER_8_268 VPWR VGND VPWR VGND sky130_fd_sc_hd__decap_3
XFILLER_12_242 VPWR VGND VPWR VGND sky130_fd_sc_hd__decap_3
XFILLER_12_253 VPWR VGND VPWR VGND sky130_fd_sc_hd__decap_3
XFILLER_5_24 VPWR VGND VPWR VGND sky130_fd_sc_hd__decap_3
XFILLER_5_57 VPWR VGND VPWR VGND sky130_fd_sc_hd__decap_3
XFILLER_7_290 VPWR VGND VPWR VGND sky130_fd_sc_hd__decap_3
XFILLER_14_88 VPWR VGND VPWR VGND sky130_fd_sc_hd__decap_3
XFILLER_14_77 VPWR VGND VPWR VGND sky130_fd_sc_hd__decap_3
XFILLER_14_44 VPWR VGND VPWR VGND sky130_fd_sc_hd__decap_3
XFILLER_5_205 VPWR VGND VPWR VGND sky130_fd_sc_hd__decap_3
XFILLER_5_249 VPWR VGND VPWR VGND sky130_fd_sc_hd__decap_3
XFILLER_17_323 VPWR VGND VPWR VGND sky130_fd_sc_hd__decap_3
XFILLER_4_271 VPWR VGND VPWR VGND sky130_fd_sc_hd__decap_3
XFILLER_23_315 VPWR VGND VPWR VGND sky130_fd_sc_hd__decap_3
XFILLER_18_109 VPWR VGND VPWR VGND sky130_fd_sc_hd__decap_3
XFILLER_14_315 VPWR VGND VPWR VGND sky130_fd_sc_hd__decap_3
XFILLER_14_304 VPWR VGND VPWR VGND sky130_fd_sc_hd__decap_3
XFILLER_1_252 VPWR VGND VPWR VGND sky130_fd_sc_hd__decap_3
XFILLER_17_164 VPWR VGND VPWR VGND sky130_fd_sc_hd__decap_3
XFILLER_17_131 VPWR VGND VPWR VGND sky130_fd_sc_hd__decap_3
XFILLER_2_47 VPWR VGND VPWR VGND sky130_fd_sc_hd__decap_3
XFILLER_1_296 VPWR VGND VPWR VGND sky130_fd_sc_hd__decap_3
XFILLER_20_318 VPWR VGND VPWR VGND sky130_fd_sc_hd__decap_3
XFILLER_17_175 VPWR VGND VPWR VGND sky130_fd_sc_hd__decap_3
XFILLER_23_178 VPWR VGND VPWR VGND sky130_fd_sc_hd__decap_3
XFILLER_11_12 VPWR VGND VPWR VGND sky130_fd_sc_hd__decap_3
XFILLER_11_329 VPWR VGND VPWR VGND sky130_fd_sc_hd__decap_3
XFILLER_11_45 VPWR VGND VPWR VGND sky130_fd_sc_hd__decap_3
XFILLER_11_78 VPWR VGND VPWR VGND sky130_fd_sc_hd__decap_3
XFILLER_14_189 VPWR VGND VPWR VGND sky130_fd_sc_hd__decap_3
XFILLER_14_156 VPWR VGND VPWR VGND sky130_fd_sc_hd__decap_3
XFILLER_14_112 VPWR VGND VPWR VGND sky130_fd_sc_hd__decap_3
XFILLER_20_159 VPWR VGND VPWR VGND sky130_fd_sc_hd__decap_3
XFILLER_20_115 VPWR VGND VPWR VGND sky130_fd_sc_hd__decap_3
XFILLER_9_193 VPWR VGND VPWR VGND sky130_fd_sc_hd__decap_3
XFILLER_3_90 VPWR VGND VPWR VGND sky130_fd_sc_hd__decap_3
XFILLER_11_137 VPWR VGND VPWR VGND sky130_fd_sc_hd__decap_3
XFILLER_22_88 VPWR VGND VPWR VGND sky130_fd_sc_hd__decap_3
XFILLER_22_77 VPWR VGND VPWR VGND sky130_fd_sc_hd__decap_3
XFILLER_22_44 VPWR VGND VPWR VGND sky130_fd_sc_hd__decap_3
XFILLER_3_314 VPWR VGND VPWR VGND sky130_fd_sc_hd__decap_3
XFILLER_7_108 VPWR VGND VPWR VGND sky130_fd_sc_hd__decap_3
XFILLER_7_119 VPWR VGND VPWR VGND sky130_fd_sc_hd__decap_3
XFILLER_19_237 VPWR VGND VPWR VGND sky130_fd_sc_hd__decap_3
XFILLER_8_24 VPWR VGND VPWR VGND sky130_fd_sc_hd__decap_3
XFILLER_8_35 VPWR VGND VPWR VGND sky130_fd_sc_hd__decap_3
XFILLER_8_68 VPWR VGND VPWR VGND sky130_fd_sc_hd__decap_3
XFILLER_6_130 VPWR VGND VPWR VGND sky130_fd_sc_hd__decap_3
XFILLER_6_141 VPWR VGND VPWR VGND sky130_fd_sc_hd__decap_3
XFILLER_6_174 VPWR VGND VPWR VGND sky130_fd_sc_hd__decap_3
XFILLER_10_192 VPWR VGND VPWR VGND sky130_fd_sc_hd__decap_3
XFILLER_18_292 VPWR VGND VPWR VGND sky130_fd_sc_hd__decap_3
XFILLER_17_99 VPWR VGND VPWR VGND sky130_fd_sc_hd__decap_3
XFILLER_17_66 VPWR VGND VPWR VGND sky130_fd_sc_hd__decap_3
XFILLER_17_33 VPWR VGND VPWR VGND sky130_fd_sc_hd__decap_3
XFILLER_16_218 VPWR VGND VPWR VGND sky130_fd_sc_hd__decap_3
XFILLER_3_122 VPWR VGND VPWR VGND sky130_fd_sc_hd__decap_3
XFILLER_3_155 VPWR VGND VPWR VGND sky130_fd_sc_hd__decap_3
XFILLER_3_199 VPWR VGND VPWR VGND sky130_fd_sc_hd__decap_3
XFILLER_12_9 VPWR VGND VPWR VGND sky130_fd_sc_hd__decap_3
XFILLER_15_284 VPWR VGND VPWR VGND sky130_fd_sc_hd__decap_3
XFILLER_15_273 VPWR VGND VPWR VGND sky130_fd_sc_hd__decap_3
XFILLER_15_240 VPWR VGND VPWR VGND sky130_fd_sc_hd__decap_3
XFILLER_0_80 VPWR VGND VPWR VGND sky130_fd_sc_hd__decap_3
XFILLER_21_287 VPWR VGND VPWR VGND sky130_fd_sc_hd__decap_3
XFILLER_21_276 VPWR VGND VPWR VGND sky130_fd_sc_hd__decap_3
XFILLER_21_243 VPWR VGND VPWR VGND sky130_fd_sc_hd__decap_3
XFILLER_0_91 VPWR VGND VPWR VGND sky130_fd_sc_hd__decap_3
XPHY_EDGE_ROW_3_Right_3 VPWR VGND VPWR VGND sky130_fd_sc_hd__decap_3
Xmisfit01_core_18 uo_out[4] misfit01_core_18/HI VPWR VGND VGND VPWR sky130_fd_sc_hd__conb_1
XFILLER_0_103 VPWR VGND VPWR VGND sky130_fd_sc_hd__decap_3
Xclkbuf_1_1__f_clk VGND VPWR VGND VPWR clkbuf_0_clk/X _00_/CLK sky130_fd_sc_hd__clkbuf_16
XFILLER_0_169 VPWR VGND VPWR VGND sky130_fd_sc_hd__decap_3
XFILLER_0_147 VPWR VGND VPWR VGND sky130_fd_sc_hd__decap_3
XFILLER_0_125 VPWR VGND VPWR VGND sky130_fd_sc_hd__decap_3
XFILLER_12_221 VPWR VGND VPWR VGND sky130_fd_sc_hd__decap_3
XFILLER_12_298 VPWR VGND VPWR VGND sky130_fd_sc_hd__decap_3
XFILLER_8_203 VPWR VGND VPWR VGND sky130_fd_sc_hd__decap_3
XFILLER_8_236 VPWR VGND VPWR VGND sky130_fd_sc_hd__decap_3
XFILLER_12_265 VPWR VGND VPWR VGND sky130_fd_sc_hd__decap_3
XFILLER_5_36 VPWR VGND VPWR VGND sky130_fd_sc_hd__decap_3
XFILLER_5_69 VPWR VGND VPWR VGND sky130_fd_sc_hd__decap_3
XFILLER_10_6 VPWR VGND VPWR VGND sky130_fd_sc_hd__decap_3
XFILLER_14_56 VPWR VGND VPWR VGND sky130_fd_sc_hd__decap_3
XFILLER_14_12 VPWR VGND VPWR VGND sky130_fd_sc_hd__decap_3
XFILLER_5_217 VPWR VGND VPWR VGND sky130_fd_sc_hd__decap_3
XFILLER_5_228 VPWR VGND VPWR VGND sky130_fd_sc_hd__decap_3
XFILLER_17_302 VPWR VGND VPWR VGND sky130_fd_sc_hd__decap_3
XFILLER_4_283 VPWR VGND VPWR VGND sky130_fd_sc_hd__decap_3
XFILLER_23_327 VPWR VGND VPWR VGND sky130_fd_sc_hd__decap_3
XFILLER_2_209 VPWR VGND VPWR VGND sky130_fd_sc_hd__decap_3
XFILLER_14_327 VPWR VGND VPWR VGND sky130_fd_sc_hd__decap_3
XFILLER_2_59 VPWR VGND VPWR VGND sky130_fd_sc_hd__decap_3
XFILLER_2_15 VPWR VGND VPWR VGND sky130_fd_sc_hd__decap_3
XFILLER_1_264 VPWR VGND VPWR VGND sky130_fd_sc_hd__decap_3
XFILLER_1_231 VPWR VGND VPWR VGND sky130_fd_sc_hd__decap_3
XFILLER_1_220 VPWR VGND VPWR VGND sky130_fd_sc_hd__decap_3
XFILLER_17_187 VPWR VGND VPWR VGND sky130_fd_sc_hd__decap_3
XFILLER_17_143 VPWR VGND VPWR VGND sky130_fd_sc_hd__decap_3
XFILLER_9_320 VPWR VGND VPWR VGND sky130_fd_sc_hd__decap_3
XFILLER_23_124 VPWR VGND VPWR VGND sky130_fd_sc_hd__decap_3
XFILLER_11_308 VPWR VGND VPWR VGND sky130_fd_sc_hd__decap_3
XFILLER_11_24 VPWR VGND VPWR VGND sky130_fd_sc_hd__decap_3
XFILLER_11_57 VPWR VGND VPWR VGND sky130_fd_sc_hd__decap_3
XFILLER_14_168 VPWR VGND VPWR VGND sky130_fd_sc_hd__decap_3
XFILLER_14_124 VPWR VGND VPWR VGND sky130_fd_sc_hd__decap_3
XFILLER_6_301 VPWR VGND VPWR VGND sky130_fd_sc_hd__decap_3
XFILLER_10_330 VPWR VGND VPWR VGND sky130_fd_sc_hd__decap_3
XFILLER_6_312 VPWR VGND VPWR VGND sky130_fd_sc_hd__decap_3
XFILLER_20_127 VPWR VGND VPWR VGND sky130_fd_sc_hd__decap_3
XFILLER_13_190 VPWR VGND VPWR VGND sky130_fd_sc_hd__decap_3
XFILLER_9_161 VPWR VGND VPWR VGND sky130_fd_sc_hd__decap_3
XFILLER_9_172 VPWR VGND VPWR VGND sky130_fd_sc_hd__decap_3
XFILLER_22_12 VPWR VGND VPWR VGND sky130_fd_sc_hd__decap_3
XFILLER_11_105 VPWR VGND VPWR VGND sky130_fd_sc_hd__decap_3
XFILLER_11_116 VPWR VGND VPWR VGND sky130_fd_sc_hd__decap_3
XFILLER_11_149 VPWR VGND VPWR VGND sky130_fd_sc_hd__decap_3
XFILLER_22_56 VPWR VGND VPWR VGND sky130_fd_sc_hd__decap_3
XFILLER_3_326 VPWR VGND VPWR VGND sky130_fd_sc_hd__decap_3
XFILLER_19_205 VPWR VGND VPWR VGND sky130_fd_sc_hd__decap_3
XFILLER_19_249 VPWR VGND VPWR VGND sky130_fd_sc_hd__decap_3
XFILLER_6_153 VPWR VGND VPWR VGND sky130_fd_sc_hd__decap_3
XFILLER_8_47 VPWR VGND VPWR VGND sky130_fd_sc_hd__decap_3
XFILLER_10_171 VPWR VGND VPWR VGND sky130_fd_sc_hd__decap_3
XFILLER_6_186 VPWR VGND VPWR VGND sky130_fd_sc_hd__decap_3
XFILLER_6_197 VPWR VGND VPWR VGND sky130_fd_sc_hd__decap_3
XFILLER_19_3 VPWR VGND VPWR VGND sky130_fd_sc_hd__decap_3
XFILLER_18_271 VPWR VGND VPWR VGND sky130_fd_sc_hd__decap_3
XFILLER_0_318 VPWR VGND VPWR VGND sky130_fd_sc_hd__decap_3
XFILLER_17_78 VPWR VGND VPWR VGND sky130_fd_sc_hd__decap_3
XFILLER_17_45 VPWR VGND VPWR VGND sky130_fd_sc_hd__decap_3
XFILLER_17_12 VPWR VGND VPWR VGND sky130_fd_sc_hd__decap_3
XFILLER_3_134 VPWR VGND VPWR VGND sky130_fd_sc_hd__decap_3
XFILLER_3_178 VPWR VGND VPWR VGND sky130_fd_sc_hd__decap_3
XFILLER_15_296 VPWR VGND VPWR VGND sky130_fd_sc_hd__decap_3
XFILLER_15_252 VPWR VGND VPWR VGND sky130_fd_sc_hd__decap_3
Xmisfit01_core_19 uo_out[5] misfit01_core_19/HI VPWR VGND VGND VPWR sky130_fd_sc_hd__conb_1
XFILLER_21_299 VPWR VGND VPWR VGND sky130_fd_sc_hd__decap_3
XFILLER_21_255 VPWR VGND VPWR VGND sky130_fd_sc_hd__decap_3
XFILLER_21_211 VPWR VGND VPWR VGND sky130_fd_sc_hd__decap_3
XFILLER_9_90 VPWR VGND VPWR VGND sky130_fd_sc_hd__decap_3
XFILLER_0_159 VPWR VGND VPWR VGND sky130_fd_sc_hd__decap_3
XFILLER_0_137 VPWR VGND VPWR VGND sky130_fd_sc_hd__decap_3
XFILLER_12_200 VPWR VGND VPWR VGND sky130_fd_sc_hd__decap_3
XFILLER_12_233 VPWR VGND VPWR VGND sky130_fd_sc_hd__decap_3
XFILLER_12_277 VPWR VGND VPWR VGND sky130_fd_sc_hd__decap_3
XFILLER_5_15 VPWR VGND VPWR VGND sky130_fd_sc_hd__decap_3
XFILLER_8_215 VPWR VGND VPWR VGND sky130_fd_sc_hd__decap_3
XFILLER_8_248 VPWR VGND VPWR VGND sky130_fd_sc_hd__decap_3
XFILLER_8_259 VPWR VGND VPWR VGND sky130_fd_sc_hd__decap_3
XFILLER_5_48 VPWR VGND VPWR VGND sky130_fd_sc_hd__decap_3
XPHY_EDGE_ROW_13_Right_13 VPWR VGND VPWR VGND sky130_fd_sc_hd__decap_3
XPHY_EDGE_ROW_22_Right_22 VPWR VGND VPWR VGND sky130_fd_sc_hd__decap_3
XFILLER_7_270 VPWR VGND VPWR VGND sky130_fd_sc_hd__decap_3
XFILLER_7_281 VPWR VGND VPWR VGND sky130_fd_sc_hd__decap_3
XFILLER_14_35 VPWR VGND VPWR VGND sky130_fd_sc_hd__decap_3
XFILLER_14_24 VPWR VGND VPWR VGND sky130_fd_sc_hd__decap_3
XFILLER_14_68 VPWR VGND VPWR VGND sky130_fd_sc_hd__decap_3
XFILLER_17_314 VPWR VGND VPWR VGND sky130_fd_sc_hd__decap_3
XFILLER_4_262 VPWR VGND VPWR VGND sky130_fd_sc_hd__decap_3
XFILLER_4_295 VPWR VGND VPWR VGND sky130_fd_sc_hd__decap_3
XFILLER_6_80 VPWR VGND VPWR VGND sky130_fd_sc_hd__decap_3
XFILLER_6_91 VPWR VGND VPWR VGND sky130_fd_sc_hd__decap_3
XFILLER_2_38 VPWR VGND VPWR VGND sky130_fd_sc_hd__decap_3
XFILLER_1_287 VPWR VGND VPWR VGND sky130_fd_sc_hd__decap_3
XFILLER_1_276 VPWR VGND VPWR VGND sky130_fd_sc_hd__decap_3
XFILLER_1_243 VPWR VGND VPWR VGND sky130_fd_sc_hd__decap_3
XFILLER_17_199 VPWR VGND VPWR VGND sky130_fd_sc_hd__decap_3
XFILLER_17_155 VPWR VGND VPWR VGND sky130_fd_sc_hd__decap_3
XFILLER_17_122 VPWR VGND VPWR VGND sky130_fd_sc_hd__decap_3
XFILLER_20_309 VPWR VGND VPWR VGND sky130_fd_sc_hd__decap_3
XFILLER_9_332 VPWR VGND VPWR VGND sky130_fd_sc_hd__decap_3
XFILLER_11_36 VPWR VGND VPWR VGND sky130_fd_sc_hd__decap_3
XFILLER_11_69 VPWR VGND VPWR VGND sky130_fd_sc_hd__decap_3
XFILLER_2_9 VPWR VGND VPWR VGND sky130_fd_sc_hd__decap_3
XFILLER_14_136 VPWR VGND VPWR VGND sky130_fd_sc_hd__decap_3
XFILLER_14_103 VPWR VGND VPWR VGND sky130_fd_sc_hd__decap_3
XFILLER_22_180 VPWR VGND VPWR VGND sky130_fd_sc_hd__decap_3
XFILLER_14_147 VPWR VGND VPWR VGND sky130_fd_sc_hd__decap_3
XFILLER_6_324 VPWR VGND VPWR VGND sky130_fd_sc_hd__decap_3
XFILLER_20_106 VPWR VGND VPWR VGND sky130_fd_sc_hd__decap_3
XFILLER_9_140 VPWR VGND VPWR VGND sky130_fd_sc_hd__decap_3
XFILLER_9_184 VPWR VGND VPWR VGND sky130_fd_sc_hd__decap_3
XFILLER_3_81 VPWR VGND VPWR VGND sky130_fd_sc_hd__decap_3
XFILLER_22_35 VPWR VGND VPWR VGND sky130_fd_sc_hd__decap_3
XFILLER_22_24 VPWR VGND VPWR VGND sky130_fd_sc_hd__decap_3
XFILLER_11_128 VPWR VGND VPWR VGND sky130_fd_sc_hd__decap_3
XFILLER_22_68 VPWR VGND VPWR VGND sky130_fd_sc_hd__decap_3
XFILLER_0_6 VPWR VGND VPWR VGND sky130_fd_sc_hd__decap_3
XFILLER_3_305 VPWR VGND VPWR VGND sky130_fd_sc_hd__decap_3
XFILLER_19_228 VPWR VGND VPWR VGND sky130_fd_sc_hd__decap_3
XFILLER_19_217 VPWR VGND VPWR VGND sky130_fd_sc_hd__decap_3
XFILLER_8_15 VPWR VGND VPWR VGND sky130_fd_sc_hd__decap_3
XFILLER_6_121 VPWR VGND VPWR VGND sky130_fd_sc_hd__decap_3
XFILLER_6_165 VPWR VGND VPWR VGND sky130_fd_sc_hd__decap_3
XFILLER_8_59 VPWR VGND VPWR VGND sky130_fd_sc_hd__decap_3
XFILLER_10_150 VPWR VGND VPWR VGND sky130_fd_sc_hd__decap_3
XFILLER_10_183 VPWR VGND VPWR VGND sky130_fd_sc_hd__decap_3
XFILLER_18_283 VPWR VGND VPWR VGND sky130_fd_sc_hd__decap_3
XFILLER_17_57 VPWR VGND VPWR VGND sky130_fd_sc_hd__decap_3
XFILLER_17_24 VPWR VGND VPWR VGND sky130_fd_sc_hd__decap_3
XFILLER_16_209 VPWR VGND VPWR VGND sky130_fd_sc_hd__decap_3
XFILLER_3_102 VPWR VGND VPWR VGND sky130_fd_sc_hd__decap_3
XFILLER_3_113 VPWR VGND VPWR VGND sky130_fd_sc_hd__decap_3
XFILLER_3_146 VPWR VGND VPWR VGND sky130_fd_sc_hd__decap_3
XFILLER_15_220 VPWR VGND VPWR VGND sky130_fd_sc_hd__decap_3
XFILLER_15_264 VPWR VGND VPWR VGND sky130_fd_sc_hd__decap_3
XFILLER_15_231 VPWR VGND VPWR VGND sky130_fd_sc_hd__decap_3
XPHY_EDGE_ROW_13_Left_37 VPWR VGND VPWR VGND sky130_fd_sc_hd__decap_3
XFILLER_0_71 VPWR VGND VPWR VGND sky130_fd_sc_hd__decap_3
XFILLER_21_267 VPWR VGND VPWR VGND sky130_fd_sc_hd__decap_3
XFILLER_21_234 VPWR VGND VPWR VGND sky130_fd_sc_hd__decap_3
XFILLER_0_116 VPWR VGND VPWR VGND sky130_fd_sc_hd__decap_3
XFILLER_8_227 VPWR VGND VPWR VGND sky130_fd_sc_hd__decap_3
XFILLER_12_212 VPWR VGND VPWR VGND sky130_fd_sc_hd__decap_3
XFILLER_12_245 VPWR VGND VPWR VGND sky130_fd_sc_hd__decap_3
XFILLER_12_256 VPWR VGND VPWR VGND sky130_fd_sc_hd__decap_3
XFILLER_12_289 VPWR VGND VPWR VGND sky130_fd_sc_hd__decap_3
XFILLER_5_27 VPWR VGND VPWR VGND sky130_fd_sc_hd__decap_3
XFILLER_7_293 VPWR VGND VPWR VGND sky130_fd_sc_hd__decap_3
XFILLER_14_47 VPWR VGND VPWR VGND sky130_fd_sc_hd__decap_3
XFILLER_5_208 VPWR VGND VPWR VGND sky130_fd_sc_hd__decap_3
XFILLER_17_326 VPWR VGND VPWR VGND sky130_fd_sc_hd__decap_3
XFILLER_4_230 VPWR VGND VPWR VGND sky130_fd_sc_hd__decap_3
XFILLER_4_274 VPWR VGND VPWR VGND sky130_fd_sc_hd__decap_3
XFILLER_23_318 VPWR VGND VPWR VGND sky130_fd_sc_hd__decap_3
XPHY_EDGE_ROW_16_Left_40 VPWR VGND VPWR VGND sky130_fd_sc_hd__decap_3
XFILLER_14_318 VPWR VGND VPWR VGND sky130_fd_sc_hd__decap_3
XFILLER_1_211 VPWR VGND VPWR VGND sky130_fd_sc_hd__decap_3
XFILLER_9_3 VPWR VGND VPWR VGND sky130_fd_sc_hd__decap_3
XFILLER_1_299 VPWR VGND VPWR VGND sky130_fd_sc_hd__decap_3
XFILLER_1_255 VPWR VGND VPWR VGND sky130_fd_sc_hd__decap_3
XFILLER_17_178 VPWR VGND VPWR VGND sky130_fd_sc_hd__decap_3
XFILLER_17_134 VPWR VGND VPWR VGND sky130_fd_sc_hd__decap_3
XFILLER_15_90 VPWR VGND VPWR VGND sky130_fd_sc_hd__decap_3
XFILLER_9_311 VPWR VGND VPWR VGND sky130_fd_sc_hd__decap_3
XFILLER_23_148 VPWR VGND VPWR VGND sky130_fd_sc_hd__decap_3
XFILLER_11_15 VPWR VGND VPWR VGND sky130_fd_sc_hd__decap_3
XFILLER_11_48 VPWR VGND VPWR VGND sky130_fd_sc_hd__decap_3
XFILLER_14_159 VPWR VGND VPWR VGND sky130_fd_sc_hd__decap_3
XFILLER_14_115 VPWR VGND VPWR VGND sky130_fd_sc_hd__decap_3
XPHY_EDGE_ROW_1_Left_25 VPWR VGND VPWR VGND sky130_fd_sc_hd__decap_3
XFILLER_10_321 VPWR VGND VPWR VGND sky130_fd_sc_hd__decap_3
XFILLER_20_118 VPWR VGND VPWR VGND sky130_fd_sc_hd__decap_3
XFILLER_13_181 VPWR VGND VPWR VGND sky130_fd_sc_hd__decap_3
XFILLER_9_152 VPWR VGND VPWR VGND sky130_fd_sc_hd__decap_3
XFILLER_9_196 VPWR VGND VPWR VGND sky130_fd_sc_hd__decap_3
XFILLER_3_60 VPWR VGND VPWR VGND sky130_fd_sc_hd__decap_3
XFILLER_3_93 VPWR VGND VPWR VGND sky130_fd_sc_hd__decap_3
XFILLER_22_47 VPWR VGND VPWR VGND sky130_fd_sc_hd__decap_3
XFILLER_3_317 VPWR VGND VPWR VGND sky130_fd_sc_hd__decap_3
XFILLER_8_38 VPWR VGND VPWR VGND sky130_fd_sc_hd__decap_3
XFILLER_6_100 VPWR VGND VPWR VGND sky130_fd_sc_hd__decap_3
XFILLER_6_133 VPWR VGND VPWR VGND sky130_fd_sc_hd__decap_3
XFILLER_6_144 VPWR VGND VPWR VGND sky130_fd_sc_hd__decap_3
XFILLER_6_177 VPWR VGND VPWR VGND sky130_fd_sc_hd__decap_3
XFILLER_10_162 VPWR VGND VPWR VGND sky130_fd_sc_hd__decap_3
XFILLER_12_80 VPWR VGND VPWR VGND sky130_fd_sc_hd__decap_3
XFILLER_12_91 VPWR VGND VPWR VGND sky130_fd_sc_hd__decap_3
XFILLER_18_295 VPWR VGND VPWR VGND sky130_fd_sc_hd__decap_3
XFILLER_18_262 VPWR VGND VPWR VGND sky130_fd_sc_hd__decap_3
XFILLER_0_309 VPWR VGND VPWR VGND sky130_fd_sc_hd__decap_3
XFILLER_17_36 VPWR VGND VPWR VGND sky130_fd_sc_hd__decap_3
XFILLER_17_69 VPWR VGND VPWR VGND sky130_fd_sc_hd__decap_3
XFILLER_3_125 VPWR VGND VPWR VGND sky130_fd_sc_hd__decap_3
XFILLER_3_158 VPWR VGND VPWR VGND sky130_fd_sc_hd__decap_3
XFILLER_3_169 VPWR VGND VPWR VGND sky130_fd_sc_hd__decap_3
XFILLER_15_243 VPWR VGND VPWR VGND sky130_fd_sc_hd__decap_3
XFILLER_15_287 VPWR VGND VPWR VGND sky130_fd_sc_hd__decap_3
XFILLER_15_276 VPWR VGND VPWR VGND sky130_fd_sc_hd__decap_3
XFILLER_2_180 VPWR VGND VPWR VGND sky130_fd_sc_hd__decap_3
XFILLER_21_246 VPWR VGND VPWR VGND sky130_fd_sc_hd__decap_3
XFILLER_0_50 VPWR VGND VPWR VGND sky130_fd_sc_hd__decap_3
XFILLER_0_94 VPWR VGND VPWR VGND sky130_fd_sc_hd__decap_3
XFILLER_9_81 VPWR VGND VPWR VGND sky130_fd_sc_hd__decap_3
XFILLER_0_106 VPWR VGND VPWR VGND sky130_fd_sc_hd__decap_3
XFILLER_0_128 VPWR VGND VPWR VGND sky130_fd_sc_hd__decap_3
XFILLER_8_206 VPWR VGND VPWR VGND sky130_fd_sc_hd__decap_3
XFILLER_8_239 VPWR VGND VPWR VGND sky130_fd_sc_hd__decap_3
XFILLER_12_224 VPWR VGND VPWR VGND sky130_fd_sc_hd__decap_3
XFILLER_12_268 VPWR VGND VPWR VGND sky130_fd_sc_hd__decap_3
XFILLER_5_39 VPWR VGND VPWR VGND sky130_fd_sc_hd__decap_3
XFILLER_10_9 VPWR VGND VPWR VGND sky130_fd_sc_hd__decap_3
XFILLER_7_261 VPWR VGND VPWR VGND sky130_fd_sc_hd__decap_3
XFILLER_11_290 VPWR VGND VPWR VGND sky130_fd_sc_hd__decap_3
XPHY_EDGE_ROW_7_Right_7 VPWR VGND VPWR VGND sky130_fd_sc_hd__decap_3
XFILLER_14_59 VPWR VGND VPWR VGND sky130_fd_sc_hd__decap_3
XFILLER_14_15 VPWR VGND VPWR VGND sky130_fd_sc_hd__decap_3
XFILLER_17_305 VPWR VGND VPWR VGND sky130_fd_sc_hd__decap_3
XFILLER_20_91 VPWR VGND VPWR VGND sky130_fd_sc_hd__decap_3
XFILLER_20_80 VPWR VGND VPWR VGND sky130_fd_sc_hd__decap_3
XFILLER_4_242 VPWR VGND VPWR VGND sky130_fd_sc_hd__decap_3
XFILLER_4_253 VPWR VGND VPWR VGND sky130_fd_sc_hd__decap_3
XFILLER_4_286 VPWR VGND VPWR VGND sky130_fd_sc_hd__decap_3
XFILLER_6_71 VPWR VGND VPWR VGND sky130_fd_sc_hd__decap_3
XFILLER_22_330 VPWR VGND VPWR VGND sky130_fd_sc_hd__decap_3
XFILLER_1_267 VPWR VGND VPWR VGND sky130_fd_sc_hd__decap_3
XFILLER_1_234 VPWR VGND VPWR VGND sky130_fd_sc_hd__decap_3
XFILLER_17_146 VPWR VGND VPWR VGND sky130_fd_sc_hd__decap_3
XFILLER_17_113 VPWR VGND VPWR VGND sky130_fd_sc_hd__decap_3
XFILLER_17_102 VPWR VGND VPWR VGND sky130_fd_sc_hd__decap_3
XFILLER_2_29 VPWR VGND VPWR VGND sky130_fd_sc_hd__decap_3
XFILLER_2_18 VPWR VGND VPWR VGND sky130_fd_sc_hd__decap_3
XFILLER_9_323 VPWR VGND VPWR VGND sky130_fd_sc_hd__decap_3
XFILLER_11_27 VPWR VGND VPWR VGND sky130_fd_sc_hd__decap_3
XFILLER_14_127 VPWR VGND VPWR VGND sky130_fd_sc_hd__decap_3
XFILLER_22_171 VPWR VGND VPWR VGND sky130_fd_sc_hd__decap_3
XFILLER_6_304 VPWR VGND VPWR VGND sky130_fd_sc_hd__decap_3
XFILLER_6_315 VPWR VGND VPWR VGND sky130_fd_sc_hd__decap_3
XFILLER_13_193 VPWR VGND VPWR VGND sky130_fd_sc_hd__decap_3
XFILLER_9_131 VPWR VGND VPWR VGND sky130_fd_sc_hd__decap_3
XFILLER_9_164 VPWR VGND VPWR VGND sky130_fd_sc_hd__decap_3
XFILLER_9_175 VPWR VGND VPWR VGND sky130_fd_sc_hd__decap_3
XFILLER_3_72 VPWR VGND VPWR VGND sky130_fd_sc_hd__decap_3
XFILLER_11_108 VPWR VGND VPWR VGND sky130_fd_sc_hd__decap_3
XFILLER_11_119 VPWR VGND VPWR VGND sky130_fd_sc_hd__decap_3
XFILLER_22_59 VPWR VGND VPWR VGND sky130_fd_sc_hd__decap_3
XFILLER_22_15 VPWR VGND VPWR VGND sky130_fd_sc_hd__decap_3
XFILLER_3_329 VPWR VGND VPWR VGND sky130_fd_sc_hd__decap_3
XFILLER_19_208 VPWR VGND VPWR VGND sky130_fd_sc_hd__decap_3
XFILLER_10_130 VPWR VGND VPWR VGND sky130_fd_sc_hd__decap_3
XFILLER_10_141 VPWR VGND VPWR VGND sky130_fd_sc_hd__decap_3
XFILLER_6_112 VPWR VGND VPWR VGND sky130_fd_sc_hd__decap_3
XFILLER_6_156 VPWR VGND VPWR VGND sky130_fd_sc_hd__decap_3
XFILLER_6_189 VPWR VGND VPWR VGND sky130_fd_sc_hd__decap_3
XFILLER_10_174 VPWR VGND VPWR VGND sky130_fd_sc_hd__decap_3
XFILLER_19_6 VPWR VGND VPWR VGND sky130_fd_sc_hd__decap_3
XFILLER_18_274 VPWR VGND VPWR VGND sky130_fd_sc_hd__decap_3
XFILLER_18_230 VPWR VGND VPWR VGND sky130_fd_sc_hd__decap_3
XFILLER_17_48 VPWR VGND VPWR VGND sky130_fd_sc_hd__decap_3
XFILLER_17_15 VPWR VGND VPWR VGND sky130_fd_sc_hd__decap_3
XFILLER_3_137 VPWR VGND VPWR VGND sky130_fd_sc_hd__decap_3
XFILLER_15_255 VPWR VGND VPWR VGND sky130_fd_sc_hd__decap_3
XFILLER_15_211 VPWR VGND VPWR VGND sky130_fd_sc_hd__decap_3
XFILLER_15_299 VPWR VGND VPWR VGND sky130_fd_sc_hd__decap_3
XFILLER_2_192 VPWR VGND VPWR VGND sky130_fd_sc_hd__decap_3
XFILLER_17_3 VPWR VGND VPWR VGND sky130_fd_sc_hd__decap_3
XFILLER_21_258 VPWR VGND VPWR VGND sky130_fd_sc_hd__decap_3
XFILLER_21_225 VPWR VGND VPWR VGND sky130_fd_sc_hd__decap_3
XFILLER_21_214 VPWR VGND VPWR VGND sky130_fd_sc_hd__decap_3
XFILLER_9_60 VPWR VGND VPWR VGND sky130_fd_sc_hd__decap_3
XFILLER_9_93 VPWR VGND VPWR VGND sky130_fd_sc_hd__decap_3
XFILLER_12_203 VPWR VGND VPWR VGND sky130_fd_sc_hd__decap_3
XFILLER_20_280 VPWR VGND VPWR VGND sky130_fd_sc_hd__decap_3
XFILLER_8_218 VPWR VGND VPWR VGND sky130_fd_sc_hd__decap_3
XFILLER_12_236 VPWR VGND VPWR VGND sky130_fd_sc_hd__decap_3
XFILLER_5_18 VPWR VGND VPWR VGND sky130_fd_sc_hd__decap_3
XFILLER_18_80 VPWR VGND VPWR VGND sky130_fd_sc_hd__decap_3
XFILLER_18_91 VPWR VGND VPWR VGND sky130_fd_sc_hd__decap_3
XFILLER_7_240 VPWR VGND VPWR VGND sky130_fd_sc_hd__decap_3
XFILLER_7_273 VPWR VGND VPWR VGND sky130_fd_sc_hd__decap_3
XFILLER_7_284 VPWR VGND VPWR VGND sky130_fd_sc_hd__decap_3
XFILLER_14_38 VPWR VGND VPWR VGND sky130_fd_sc_hd__decap_3
XFILLER_17_317 VPWR VGND VPWR VGND sky130_fd_sc_hd__decap_3
XFILLER_4_221 VPWR VGND VPWR VGND sky130_fd_sc_hd__decap_3
XFILLER_4_265 VPWR VGND VPWR VGND sky130_fd_sc_hd__decap_3
XFILLER_4_298 VPWR VGND VPWR VGND sky130_fd_sc_hd__decap_3
XFILLER_23_309 VPWR VGND VPWR VGND sky130_fd_sc_hd__decap_3
XFILLER_6_50 VPWR VGND VPWR VGND sky130_fd_sc_hd__decap_3
XFILLER_6_94 VPWR VGND VPWR VGND sky130_fd_sc_hd__decap_3
XFILLER_14_309 VPWR VGND VPWR VGND sky130_fd_sc_hd__decap_3
XFILLER_1_246 VPWR VGND VPWR VGND sky130_fd_sc_hd__decap_3
XFILLER_1_202 VPWR VGND VPWR VGND sky130_fd_sc_hd__decap_3
XFILLER_17_169 VPWR VGND VPWR VGND sky130_fd_sc_hd__decap_3
XFILLER_17_158 VPWR VGND VPWR VGND sky130_fd_sc_hd__decap_3
XFILLER_17_125 VPWR VGND VPWR VGND sky130_fd_sc_hd__decap_3
XFILLER_15_81 VPWR VGND VPWR VGND sky130_fd_sc_hd__decap_3
XFILLER_13_320 VPWR VGND VPWR VGND sky130_fd_sc_hd__decap_3
XFILLER_9_302 VPWR VGND VPWR VGND sky130_fd_sc_hd__decap_3
XFILLER_0_290 VPWR VGND VPWR VGND sky130_fd_sc_hd__decap_3
XFILLER_23_106 VPWR VGND VPWR VGND sky130_fd_sc_hd__decap_3
XFILLER_16_180 VPWR VGND VPWR VGND sky130_fd_sc_hd__decap_3
XFILLER_11_39 VPWR VGND VPWR VGND sky130_fd_sc_hd__decap_3
XFILLER_22_183 VPWR VGND VPWR VGND sky130_fd_sc_hd__decap_3
XFILLER_22_150 VPWR VGND VPWR VGND sky130_fd_sc_hd__decap_3
XFILLER_14_106 VPWR VGND VPWR VGND sky130_fd_sc_hd__decap_3
XFILLER_10_301 VPWR VGND VPWR VGND sky130_fd_sc_hd__decap_3
XFILLER_10_312 VPWR VGND VPWR VGND sky130_fd_sc_hd__decap_3
XFILLER_6_327 VPWR VGND VPWR VGND sky130_fd_sc_hd__decap_3
XFILLER_20_109 VPWR VGND VPWR VGND sky130_fd_sc_hd__decap_3
XFILLER_13_172 VPWR VGND VPWR VGND sky130_fd_sc_hd__decap_3
XFILLER_13_161 VPWR VGND VPWR VGND sky130_fd_sc_hd__decap_3
XFILLER_9_143 VPWR VGND VPWR VGND sky130_fd_sc_hd__decap_3
XFILLER_9_187 VPWR VGND VPWR VGND sky130_fd_sc_hd__decap_3
XFILLER_3_51 VPWR VGND VPWR VGND sky130_fd_sc_hd__decap_3
XFILLER_3_84 VPWR VGND VPWR VGND sky130_fd_sc_hd__decap_3
XFILLER_22_38 VPWR VGND VPWR VGND sky130_fd_sc_hd__decap_3
XFILLER_3_308 VPWR VGND VPWR VGND sky130_fd_sc_hd__decap_3
XFILLER_0_9 VPWR VGND VPWR VGND sky130_fd_sc_hd__decap_3
XFILLER_6_124 VPWR VGND VPWR VGND sky130_fd_sc_hd__decap_3
XFILLER_8_18 VPWR VGND VPWR VGND sky130_fd_sc_hd__decap_3
XFILLER_8_29 VPWR VGND VPWR VGND sky130_fd_sc_hd__decap_3
XFILLER_10_153 VPWR VGND VPWR VGND sky130_fd_sc_hd__decap_3
XFILLER_10_186 VPWR VGND VPWR VGND sky130_fd_sc_hd__decap_3
XFILLER_2_330 VPWR VGND VPWR VGND sky130_fd_sc_hd__decap_3
XFILLER_6_168 VPWR VGND VPWR VGND sky130_fd_sc_hd__decap_3
XFILLER_10_197 VPWR VGND VPWR VGND sky130_fd_sc_hd__decap_3
XFILLER_12_71 VPWR VGND VPWR VGND sky130_fd_sc_hd__decap_3
XFILLER_18_242 VPWR VGND VPWR VGND sky130_fd_sc_hd__decap_3
XFILLER_18_286 VPWR VGND VPWR VGND sky130_fd_sc_hd__decap_3
XFILLER_18_253 VPWR VGND VPWR VGND sky130_fd_sc_hd__decap_3
XFILLER_5_190 VPWR VGND VPWR VGND sky130_fd_sc_hd__decap_3
XFILLER_17_27 VPWR VGND VPWR VGND sky130_fd_sc_hd__decap_3
XFILLER_3_105 VPWR VGND VPWR VGND sky130_fd_sc_hd__decap_3
XFILLER_3_116 VPWR VGND VPWR VGND sky130_fd_sc_hd__decap_3
XFILLER_3_149 VPWR VGND VPWR VGND sky130_fd_sc_hd__decap_3
XFILLER_15_267 VPWR VGND VPWR VGND sky130_fd_sc_hd__decap_3
XFILLER_15_234 VPWR VGND VPWR VGND sky130_fd_sc_hd__decap_3
XFILLER_23_70 VPWR VGND VPWR VGND sky130_fd_sc_hd__decap_3
XFILLER_2_171 VPWR VGND VPWR VGND sky130_fd_sc_hd__decap_3
XFILLER_0_41 VPWR VGND VPWR VGND sky130_fd_sc_hd__decap_3
XFILLER_0_74 VPWR VGND VPWR VGND sky130_fd_sc_hd__decap_3
XFILLER_0_85 VPWR VGND VPWR VGND sky130_fd_sc_hd__decap_3
XFILLER_21_237 VPWR VGND VPWR VGND sky130_fd_sc_hd__decap_3
XFILLER_9_72 VPWR VGND VPWR VGND sky130_fd_sc_hd__decap_3
XFILLER_0_119 VPWR VGND VPWR VGND sky130_fd_sc_hd__decap_3
XFILLER_12_215 VPWR VGND VPWR VGND sky130_fd_sc_hd__decap_3
XFILLER_20_292 VPWR VGND VPWR VGND sky130_fd_sc_hd__decap_3
XFILLER_12_248 VPWR VGND VPWR VGND sky130_fd_sc_hd__decap_3
XFILLER_12_259 VPWR VGND VPWR VGND sky130_fd_sc_hd__decap_3
XFILLER_7_252 VPWR VGND VPWR VGND sky130_fd_sc_hd__decap_3
XFILLER_7_296 VPWR VGND VPWR VGND sky130_fd_sc_hd__decap_3
XFILLER_11_270 VPWR VGND VPWR VGND sky130_fd_sc_hd__decap_3
XFILLER_11_281 VPWR VGND VPWR VGND sky130_fd_sc_hd__decap_3
XFILLER_17_329 VPWR VGND VPWR VGND sky130_fd_sc_hd__decap_3
XFILLER_4_200 VPWR VGND VPWR VGND sky130_fd_sc_hd__decap_3
XFILLER_4_233 VPWR VGND VPWR VGND sky130_fd_sc_hd__decap_3
XFILLER_20_71 VPWR VGND VPWR VGND sky130_fd_sc_hd__decap_3
XFILLER_4_277 VPWR VGND VPWR VGND sky130_fd_sc_hd__decap_3
XFILLER_6_62 VPWR VGND VPWR VGND sky130_fd_sc_hd__decap_3
XFILLER_22_321 VPWR VGND VPWR VGND sky130_fd_sc_hd__decap_3
XFILLER_1_258 VPWR VGND VPWR VGND sky130_fd_sc_hd__decap_3
XFILLER_1_225 VPWR VGND VPWR VGND sky130_fd_sc_hd__decap_3
XFILLER_1_214 VPWR VGND VPWR VGND sky130_fd_sc_hd__decap_3
XFILLER_9_6 VPWR VGND VPWR VGND sky130_fd_sc_hd__decap_3
XFILLER_17_137 VPWR VGND VPWR VGND sky130_fd_sc_hd__decap_3
XFILLER_15_93 VPWR VGND VPWR VGND sky130_fd_sc_hd__decap_3
XFILLER_15_60 VPWR VGND VPWR VGND sky130_fd_sc_hd__decap_3
XFILLER_13_332 VPWR VGND VPWR VGND sky130_fd_sc_hd__decap_3
XFILLER_9_314 VPWR VGND VPWR VGND sky130_fd_sc_hd__decap_3
XFILLER_23_118 VPWR VGND VPWR VGND sky130_fd_sc_hd__decap_3
XFILLER_16_192 VPWR VGND VPWR VGND sky130_fd_sc_hd__decap_3
XFILLER_11_18 VPWR VGND VPWR VGND sky130_fd_sc_hd__decap_3
XFILLER_14_118 VPWR VGND VPWR VGND sky130_fd_sc_hd__decap_3
XFILLER_22_162 VPWR VGND VPWR VGND sky130_fd_sc_hd__decap_3
XFILLER_10_324 VPWR VGND VPWR VGND sky130_fd_sc_hd__decap_3
XFILLER_7_3 VPWR VGND VPWR VGND sky130_fd_sc_hd__decap_3
XFILLER_13_140 VPWR VGND VPWR VGND sky130_fd_sc_hd__decap_3
XFILLER_13_184 VPWR VGND VPWR VGND sky130_fd_sc_hd__decap_3
XFILLER_9_122 VPWR VGND VPWR VGND sky130_fd_sc_hd__decap_3
XFILLER_9_155 VPWR VGND VPWR VGND sky130_fd_sc_hd__decap_3
XFILLER_9_199 VPWR VGND VPWR VGND sky130_fd_sc_hd__decap_3
XFILLER_3_63 VPWR VGND VPWR VGND sky130_fd_sc_hd__decap_3
XFILLER_3_30 VPWR VGND VPWR VGND sky130_fd_sc_hd__decap_3
XFILLER_3_96 VPWR VGND VPWR VGND sky130_fd_sc_hd__decap_3
XPHY_EDGE_ROW_5_Left_29 VPWR VGND VPWR VGND sky130_fd_sc_hd__decap_3
XFILLER_6_103 VPWR VGND VPWR VGND sky130_fd_sc_hd__decap_3
XFILLER_6_136 VPWR VGND VPWR VGND sky130_fd_sc_hd__decap_3
XFILLER_6_147 VPWR VGND VPWR VGND sky130_fd_sc_hd__decap_3
XFILLER_10_121 VPWR VGND VPWR VGND sky130_fd_sc_hd__decap_3
XFILLER_10_165 VPWR VGND VPWR VGND sky130_fd_sc_hd__decap_3
XFILLER_12_50 VPWR VGND VPWR VGND sky130_fd_sc_hd__decap_3
XFILLER_12_94 VPWR VGND VPWR VGND sky130_fd_sc_hd__decap_3
XFILLER_18_265 VPWR VGND VPWR VGND sky130_fd_sc_hd__decap_3
XFILLER_18_221 VPWR VGND VPWR VGND sky130_fd_sc_hd__decap_3
XFILLER_18_298 VPWR VGND VPWR VGND sky130_fd_sc_hd__decap_3
XFILLER_17_39 VPWR VGND VPWR VGND sky130_fd_sc_hd__decap_3
XFILLER_3_128 VPWR VGND VPWR VGND sky130_fd_sc_hd__decap_3
XFILLER_15_202 VPWR VGND VPWR VGND sky130_fd_sc_hd__decap_3
XFILLER_23_290 VPWR VGND VPWR VGND sky130_fd_sc_hd__decap_3
XFILLER_15_246 VPWR VGND VPWR VGND sky130_fd_sc_hd__decap_3
XFILLER_2_183 VPWR VGND VPWR VGND sky130_fd_sc_hd__decap_3
XFILLER_2_150 VPWR VGND VPWR VGND sky130_fd_sc_hd__decap_3
XFILLER_0_53 VPWR VGND VPWR VGND sky130_fd_sc_hd__decap_3
XFILLER_0_97 VPWR VGND VPWR VGND sky130_fd_sc_hd__decap_3
XFILLER_21_249 VPWR VGND VPWR VGND sky130_fd_sc_hd__decap_3
XFILLER_9_51 VPWR VGND VPWR VGND sky130_fd_sc_hd__decap_3
XFILLER_9_84 VPWR VGND VPWR VGND sky130_fd_sc_hd__decap_3
XFILLER_0_109 VPWR VGND VPWR VGND sky130_fd_sc_hd__decap_3
XFILLER_8_209 VPWR VGND VPWR VGND sky130_fd_sc_hd__decap_3
XFILLER_12_227 VPWR VGND VPWR VGND sky130_fd_sc_hd__decap_3
XFILLER_20_271 VPWR VGND VPWR VGND sky130_fd_sc_hd__decap_3
XPHY_EDGE_ROW_8_Left_32 VPWR VGND VPWR VGND sky130_fd_sc_hd__decap_3
XFILLER_18_71 VPWR VGND VPWR VGND sky130_fd_sc_hd__decap_3
XFILLER_7_220 VPWR VGND VPWR VGND sky130_fd_sc_hd__decap_3
XFILLER_7_231 VPWR VGND VPWR VGND sky130_fd_sc_hd__decap_3
XFILLER_11_293 VPWR VGND VPWR VGND sky130_fd_sc_hd__decap_3
XFILLER_7_264 VPWR VGND VPWR VGND sky130_fd_sc_hd__decap_3
XFILLER_22_3 VPWR VGND VPWR VGND sky130_fd_sc_hd__decap_3
XFILLER_14_29 VPWR VGND VPWR VGND sky130_fd_sc_hd__decap_3
XFILLER_14_18 VPWR VGND VPWR VGND sky130_fd_sc_hd__decap_3
XFILLER_17_308 VPWR VGND VPWR VGND sky130_fd_sc_hd__decap_3
XFILLER_20_94 VPWR VGND VPWR VGND sky130_fd_sc_hd__decap_3
XFILLER_20_50 VPWR VGND VPWR VGND sky130_fd_sc_hd__decap_3
XFILLER_4_212 VPWR VGND VPWR VGND sky130_fd_sc_hd__decap_3
XFILLER_4_245 VPWR VGND VPWR VGND sky130_fd_sc_hd__decap_3
XFILLER_4_256 VPWR VGND VPWR VGND sky130_fd_sc_hd__decap_3
XFILLER_4_289 VPWR VGND VPWR VGND sky130_fd_sc_hd__decap_3
XFILLER_16_330 VPWR VGND VPWR VGND sky130_fd_sc_hd__decap_3
XFILLER_6_41 VPWR VGND VPWR VGND sky130_fd_sc_hd__decap_3
XFILLER_6_74 VPWR VGND VPWR VGND sky130_fd_sc_hd__decap_3
XFILLER_6_85 VPWR VGND VPWR VGND sky130_fd_sc_hd__decap_3
XFILLER_19_190 VPWR VGND VPWR VGND sky130_fd_sc_hd__decap_3
XFILLER_1_237 VPWR VGND VPWR VGND sky130_fd_sc_hd__decap_3
XFILLER_17_149 VPWR VGND VPWR VGND sky130_fd_sc_hd__decap_3
XFILLER_17_116 VPWR VGND VPWR VGND sky130_fd_sc_hd__decap_3
XFILLER_17_105 VPWR VGND VPWR VGND sky130_fd_sc_hd__decap_3
XFILLER_13_311 VPWR VGND VPWR VGND sky130_fd_sc_hd__decap_3
XFILLER_15_72 VPWR VGND VPWR VGND sky130_fd_sc_hd__decap_3
XFILLER_9_326 VPWR VGND VPWR VGND sky130_fd_sc_hd__decap_3
XFILLER_0_281 VPWR VGND VPWR VGND sky130_fd_sc_hd__decap_3
XFILLER_16_171 VPWR VGND VPWR VGND sky130_fd_sc_hd__decap_3
XFILLER_22_174 VPWR VGND VPWR VGND sky130_fd_sc_hd__decap_3
XFILLER_22_141 VPWR VGND VPWR VGND sky130_fd_sc_hd__decap_3
XFILLER_22_130 VPWR VGND VPWR VGND sky130_fd_sc_hd__decap_3
XFILLER_6_318 VPWR VGND VPWR VGND sky130_fd_sc_hd__decap_3
XFILLER_13_152 VPWR VGND VPWR VGND sky130_fd_sc_hd__decap_3
XFILLER_9_134 VPWR VGND VPWR VGND sky130_fd_sc_hd__decap_3
XPHY_EDGE_ROW_21_Left_45 VPWR VGND VPWR VGND sky130_fd_sc_hd__decap_3
XFILLER_13_196 VPWR VGND VPWR VGND sky130_fd_sc_hd__decap_3
XFILLER_9_178 VPWR VGND VPWR VGND sky130_fd_sc_hd__decap_3
XFILLER_3_42 VPWR VGND VPWR VGND sky130_fd_sc_hd__decap_3
XFILLER_3_75 VPWR VGND VPWR VGND sky130_fd_sc_hd__decap_3
XFILLER_22_29 VPWR VGND VPWR VGND sky130_fd_sc_hd__decap_3
XFILLER_22_18 VPWR VGND VPWR VGND sky130_fd_sc_hd__decap_3
XFILLER_10_100 VPWR VGND VPWR VGND sky130_fd_sc_hd__decap_3
XFILLER_6_115 VPWR VGND VPWR VGND sky130_fd_sc_hd__decap_3
XFILLER_6_159 VPWR VGND VPWR VGND sky130_fd_sc_hd__decap_3
XFILLER_10_133 VPWR VGND VPWR VGND sky130_fd_sc_hd__decap_3
XFILLER_10_144 VPWR VGND VPWR VGND sky130_fd_sc_hd__decap_3
XFILLER_10_177 VPWR VGND VPWR VGND sky130_fd_sc_hd__decap_3
XFILLER_12_62 VPWR VGND VPWR VGND sky130_fd_sc_hd__decap_3
XFILLER_2_321 VPWR VGND VPWR VGND sky130_fd_sc_hd__decap_3
XFILLER_19_9 VPWR VGND VPWR VGND sky130_fd_sc_hd__decap_3
XFILLER_18_277 VPWR VGND VPWR VGND sky130_fd_sc_hd__decap_3
XFILLER_18_233 VPWR VGND VPWR VGND sky130_fd_sc_hd__decap_3
XFILLER_18_200 VPWR VGND VPWR VGND sky130_fd_sc_hd__decap_3
XFILLER_5_181 VPWR VGND VPWR VGND sky130_fd_sc_hd__decap_3
XFILLER_17_18 VPWR VGND VPWR VGND sky130_fd_sc_hd__decap_3
XFILLER_15_225 VPWR VGND VPWR VGND sky130_fd_sc_hd__decap_3
XFILLER_15_214 VPWR VGND VPWR VGND sky130_fd_sc_hd__decap_3
XFILLER_23_50 VPWR VGND VPWR VGND sky130_fd_sc_hd__decap_3
XFILLER_15_258 VPWR VGND VPWR VGND sky130_fd_sc_hd__decap_3
XFILLER_23_94 VPWR VGND VPWR VGND sky130_fd_sc_hd__decap_3
XFILLER_17_6 VPWR VGND VPWR VGND sky130_fd_sc_hd__decap_3
XFILLER_2_162 VPWR VGND VPWR VGND sky130_fd_sc_hd__decap_3
XFILLER_21_228 VPWR VGND VPWR VGND sky130_fd_sc_hd__decap_3
XFILLER_21_217 VPWR VGND VPWR VGND sky130_fd_sc_hd__decap_3
XFILLER_0_21 VPWR VGND VPWR VGND sky130_fd_sc_hd__decap_3
XFILLER_0_32 VPWR VGND VPWR VGND sky130_fd_sc_hd__decap_3
XFILLER_9_30 VPWR VGND VPWR VGND sky130_fd_sc_hd__decap_3
XFILLER_14_280 VPWR VGND VPWR VGND sky130_fd_sc_hd__decap_3
XFILLER_9_63 VPWR VGND VPWR VGND sky130_fd_sc_hd__decap_3
XFILLER_9_96 VPWR VGND VPWR VGND sky130_fd_sc_hd__decap_3
XFILLER_12_206 VPWR VGND VPWR VGND sky130_fd_sc_hd__decap_3
XFILLER_12_239 VPWR VGND VPWR VGND sky130_fd_sc_hd__decap_3
XFILLER_20_283 VPWR VGND VPWR VGND sky130_fd_sc_hd__decap_3
XFILLER_18_94 VPWR VGND VPWR VGND sky130_fd_sc_hd__decap_3
XFILLER_18_50 VPWR VGND VPWR VGND sky130_fd_sc_hd__decap_3
XFILLER_7_243 VPWR VGND VPWR VGND sky130_fd_sc_hd__decap_3
XFILLER_11_261 VPWR VGND VPWR VGND sky130_fd_sc_hd__decap_3
XFILLER_7_276 VPWR VGND VPWR VGND sky130_fd_sc_hd__decap_3
XFILLER_7_287 VPWR VGND VPWR VGND sky130_fd_sc_hd__decap_3
XFILLER_15_3 VPWR VGND VPWR VGND sky130_fd_sc_hd__decap_3
XFILLER_20_62 VPWR VGND VPWR VGND sky130_fd_sc_hd__decap_3
XFILLER_4_224 VPWR VGND VPWR VGND sky130_fd_sc_hd__decap_3
XFILLER_4_268 VPWR VGND VPWR VGND sky130_fd_sc_hd__decap_3
XFILLER_6_53 VPWR VGND VPWR VGND sky130_fd_sc_hd__decap_3
XFILLER_3_290 VPWR VGND VPWR VGND sky130_fd_sc_hd__decap_3
XFILLER_6_97 VPWR VGND VPWR VGND sky130_fd_sc_hd__decap_3
XFILLER_22_312 VPWR VGND VPWR VGND sky130_fd_sc_hd__decap_3
XFILLER_1_249 VPWR VGND VPWR VGND sky130_fd_sc_hd__decap_3
XFILLER_1_205 VPWR VGND VPWR VGND sky130_fd_sc_hd__decap_3
XFILLER_17_128 VPWR VGND VPWR VGND sky130_fd_sc_hd__decap_3
XFILLER_15_84 VPWR VGND VPWR VGND sky130_fd_sc_hd__decap_3
XFILLER_15_51 VPWR VGND VPWR VGND sky130_fd_sc_hd__decap_3
XFILLER_13_323 VPWR VGND VPWR VGND sky130_fd_sc_hd__decap_3
XFILLER_9_305 VPWR VGND VPWR VGND sky130_fd_sc_hd__decap_3
XFILLER_0_271 VPWR VGND VPWR VGND sky130_fd_sc_hd__decap_3
XFILLER_16_150 VPWR VGND VPWR VGND sky130_fd_sc_hd__decap_3
XFILLER_0_293 VPWR VGND VPWR VGND sky130_fd_sc_hd__decap_3
XFILLER_16_183 VPWR VGND VPWR VGND sky130_fd_sc_hd__decap_3
XFILLER_14_109 VPWR VGND VPWR VGND sky130_fd_sc_hd__decap_3
XFILLER_22_186 VPWR VGND VPWR VGND sky130_fd_sc_hd__decap_3
XFILLER_22_153 VPWR VGND VPWR VGND sky130_fd_sc_hd__decap_3
XFILLER_10_304 VPWR VGND VPWR VGND sky130_fd_sc_hd__decap_3
XFILLER_10_315 VPWR VGND VPWR VGND sky130_fd_sc_hd__decap_3
XFILLER_13_175 VPWR VGND VPWR VGND sky130_fd_sc_hd__decap_3
XFILLER_13_164 VPWR VGND VPWR VGND sky130_fd_sc_hd__decap_3
XFILLER_13_131 VPWR VGND VPWR VGND sky130_fd_sc_hd__decap_3
XFILLER_9_102 VPWR VGND VPWR VGND sky130_fd_sc_hd__decap_3
XFILLER_9_113 VPWR VGND VPWR VGND sky130_fd_sc_hd__decap_3
XFILLER_9_146 VPWR VGND VPWR VGND sky130_fd_sc_hd__decap_3
XFILLER_3_21 VPWR VGND VPWR VGND sky130_fd_sc_hd__decap_3
XFILLER_3_87 VPWR VGND VPWR VGND sky130_fd_sc_hd__decap_3
XFILLER_10_112 VPWR VGND VPWR VGND sky130_fd_sc_hd__decap_3
XFILLER_6_127 VPWR VGND VPWR VGND sky130_fd_sc_hd__decap_3
XFILLER_10_156 VPWR VGND VPWR VGND sky130_fd_sc_hd__decap_3
XFILLER_10_189 VPWR VGND VPWR VGND sky130_fd_sc_hd__decap_3
XFILLER_12_41 VPWR VGND VPWR VGND sky130_fd_sc_hd__decap_3
XFILLER_12_74 VPWR VGND VPWR VGND sky130_fd_sc_hd__decap_3
XFILLER_12_85 VPWR VGND VPWR VGND sky130_fd_sc_hd__decap_3
XFILLER_18_289 VPWR VGND VPWR VGND sky130_fd_sc_hd__decap_3
XFILLER_18_256 VPWR VGND VPWR VGND sky130_fd_sc_hd__decap_3
XFILLER_18_245 VPWR VGND VPWR VGND sky130_fd_sc_hd__decap_3
XFILLER_18_212 VPWR VGND VPWR VGND sky130_fd_sc_hd__decap_3
XPHY_EDGE_ROW_16_Right_16 VPWR VGND VPWR VGND sky130_fd_sc_hd__decap_3
XFILLER_5_193 VPWR VGND VPWR VGND sky130_fd_sc_hd__decap_3
XFILLER_3_108 VPWR VGND VPWR VGND sky130_fd_sc_hd__decap_3
XFILLER_3_119 VPWR VGND VPWR VGND sky130_fd_sc_hd__decap_3
XFILLER_15_237 VPWR VGND VPWR VGND sky130_fd_sc_hd__decap_3
XFILLER_23_281 VPWR VGND VPWR VGND sky130_fd_sc_hd__decap_3
XFILLER_2_174 VPWR VGND VPWR VGND sky130_fd_sc_hd__decap_3
XFILLER_2_141 VPWR VGND VPWR VGND sky130_fd_sc_hd__decap_3
XFILLER_2_130 VPWR VGND VPWR VGND sky130_fd_sc_hd__decap_3
XFILLER_0_44 VPWR VGND VPWR VGND sky130_fd_sc_hd__decap_3
XFILLER_14_292 VPWR VGND VPWR VGND sky130_fd_sc_hd__decap_3
XFILLER_0_77 VPWR VGND VPWR VGND sky130_fd_sc_hd__decap_3
XFILLER_0_88 VPWR VGND VPWR VGND sky130_fd_sc_hd__decap_3
XFILLER_9_42 VPWR VGND VPWR VGND sky130_fd_sc_hd__decap_3
XFILLER_9_75 VPWR VGND VPWR VGND sky130_fd_sc_hd__decap_3
XFILLER_20_262 VPWR VGND VPWR VGND sky130_fd_sc_hd__decap_3
XFILLER_12_218 VPWR VGND VPWR VGND sky130_fd_sc_hd__decap_3
XFILLER_20_295 VPWR VGND VPWR VGND sky130_fd_sc_hd__decap_3
XFILLER_18_62 VPWR VGND VPWR VGND sky130_fd_sc_hd__decap_3
XFILLER_7_211 VPWR VGND VPWR VGND sky130_fd_sc_hd__decap_3
XFILLER_7_255 VPWR VGND VPWR VGND sky130_fd_sc_hd__decap_3
XFILLER_7_299 VPWR VGND VPWR VGND sky130_fd_sc_hd__decap_3
XFILLER_11_240 VPWR VGND VPWR VGND sky130_fd_sc_hd__decap_3
XFILLER_11_273 VPWR VGND VPWR VGND sky130_fd_sc_hd__decap_3
XFILLER_11_284 VPWR VGND VPWR VGND sky130_fd_sc_hd__decap_3
XPHY_EDGE_ROW_2_Right_2 VPWR VGND VPWR VGND sky130_fd_sc_hd__decap_3
XFILLER_4_203 VPWR VGND VPWR VGND sky130_fd_sc_hd__decap_3
XFILLER_20_85 VPWR VGND VPWR VGND sky130_fd_sc_hd__decap_3
XFILLER_20_74 VPWR VGND VPWR VGND sky130_fd_sc_hd__decap_3
XFILLER_20_41 VPWR VGND VPWR VGND sky130_fd_sc_hd__decap_3
XFILLER_4_236 VPWR VGND VPWR VGND sky130_fd_sc_hd__decap_3
XFILLER_16_321 VPWR VGND VPWR VGND sky130_fd_sc_hd__decap_3
XFILLER_6_21 VPWR VGND VPWR VGND sky130_fd_sc_hd__decap_3
XFILLER_6_32 VPWR VGND VPWR VGND sky130_fd_sc_hd__decap_3
XFILLER_6_65 VPWR VGND VPWR VGND sky130_fd_sc_hd__decap_3
XFILLER_22_324 VPWR VGND VPWR VGND sky130_fd_sc_hd__decap_3
XFILLER_19_181 VPWR VGND VPWR VGND sky130_fd_sc_hd__decap_3
XFILLER_1_228 VPWR VGND VPWR VGND sky130_fd_sc_hd__decap_3
XFILLER_1_217 VPWR VGND VPWR VGND sky130_fd_sc_hd__decap_3
XFILLER_9_9 VPWR VGND VPWR VGND sky130_fd_sc_hd__decap_3
XFILLER_15_96 VPWR VGND VPWR VGND sky130_fd_sc_hd__decap_3
XFILLER_15_63 VPWR VGND VPWR VGND sky130_fd_sc_hd__decap_3
XFILLER_15_30 VPWR VGND VPWR VGND sky130_fd_sc_hd__decap_3
XFILLER_13_302 VPWR VGND VPWR VGND sky130_fd_sc_hd__decap_3
XFILLER_9_317 VPWR VGND VPWR VGND sky130_fd_sc_hd__decap_3
XFILLER_16_162 VPWR VGND VPWR VGND sky130_fd_sc_hd__decap_3
XFILLER_22_165 VPWR VGND VPWR VGND sky130_fd_sc_hd__decap_3
XFILLER_22_121 VPWR VGND VPWR VGND sky130_fd_sc_hd__decap_3
XFILLER_6_309 VPWR VGND VPWR VGND sky130_fd_sc_hd__decap_3
XFILLER_10_327 VPWR VGND VPWR VGND sky130_fd_sc_hd__decap_3
XFILLER_7_6 VPWR VGND VPWR VGND sky130_fd_sc_hd__decap_3
XFILLER_13_187 VPWR VGND VPWR VGND sky130_fd_sc_hd__decap_3
XFILLER_13_143 VPWR VGND VPWR VGND sky130_fd_sc_hd__decap_3
XFILLER_9_125 VPWR VGND VPWR VGND sky130_fd_sc_hd__decap_3
XFILLER_9_158 VPWR VGND VPWR VGND sky130_fd_sc_hd__decap_3
XFILLER_9_169 VPWR VGND VPWR VGND sky130_fd_sc_hd__decap_3
XFILLER_5_320 VPWR VGND VPWR VGND sky130_fd_sc_hd__decap_3
XFILLER_3_66 VPWR VGND VPWR VGND sky130_fd_sc_hd__decap_3
XFILLER_3_33 VPWR VGND VPWR VGND sky130_fd_sc_hd__decap_3
XFILLER_3_99 VPWR VGND VPWR VGND sky130_fd_sc_hd__decap_3
XFILLER_8_180 VPWR VGND VPWR VGND sky130_fd_sc_hd__decap_3
XFILLER_6_106 VPWR VGND VPWR VGND sky130_fd_sc_hd__decap_3
XFILLER_10_124 VPWR VGND VPWR VGND sky130_fd_sc_hd__decap_3
XFILLER_10_168 VPWR VGND VPWR VGND sky130_fd_sc_hd__decap_3
XFILLER_2_312 VPWR VGND VPWR VGND sky130_fd_sc_hd__decap_3
XFILLER_2_301 VPWR VGND VPWR VGND sky130_fd_sc_hd__decap_3
XFILLER_5_3 VPWR VGND VPWR VGND sky130_fd_sc_hd__decap_3
XFILLER_12_53 VPWR VGND VPWR VGND sky130_fd_sc_hd__decap_3
XFILLER_12_97 VPWR VGND VPWR VGND sky130_fd_sc_hd__decap_3
XFILLER_18_224 VPWR VGND VPWR VGND sky130_fd_sc_hd__decap_3
XFILLER_18_268 VPWR VGND VPWR VGND sky130_fd_sc_hd__decap_3
XFILLER_5_161 VPWR VGND VPWR VGND sky130_fd_sc_hd__decap_3
XFILLER_5_172 VPWR VGND VPWR VGND sky130_fd_sc_hd__decap_3
XFILLER_17_290 VPWR VGND VPWR VGND sky130_fd_sc_hd__decap_3
XFILLER_15_249 VPWR VGND VPWR VGND sky130_fd_sc_hd__decap_3
XFILLER_15_205 VPWR VGND VPWR VGND sky130_fd_sc_hd__decap_3
XFILLER_23_271 VPWR VGND VPWR VGND sky130_fd_sc_hd__decap_3
XFILLER_23_41 VPWR VGND VPWR VGND sky130_fd_sc_hd__decap_3
XFILLER_2_197 VPWR VGND VPWR VGND sky130_fd_sc_hd__decap_3
XFILLER_2_186 VPWR VGND VPWR VGND sky130_fd_sc_hd__decap_3
XFILLER_2_153 VPWR VGND VPWR VGND sky130_fd_sc_hd__decap_3
XFILLER_0_12 VPWR VGND VPWR VGND sky130_fd_sc_hd__decap_3
XFILLER_14_271 VPWR VGND VPWR VGND sky130_fd_sc_hd__decap_3
XFILLER_9_21 VPWR VGND VPWR VGND sky130_fd_sc_hd__decap_3
XFILLER_9_87 VPWR VGND VPWR VGND sky130_fd_sc_hd__decap_3
XFILLER_20_274 VPWR VGND VPWR VGND sky130_fd_sc_hd__decap_3
XFILLER_20_230 VPWR VGND VPWR VGND sky130_fd_sc_hd__decap_3
XFILLER_18_85 VPWR VGND VPWR VGND sky130_fd_sc_hd__decap_3
XFILLER_18_74 VPWR VGND VPWR VGND sky130_fd_sc_hd__decap_3
XFILLER_18_41 VPWR VGND VPWR VGND sky130_fd_sc_hd__decap_3
XFILLER_7_234 VPWR VGND VPWR VGND sky130_fd_sc_hd__decap_3
XFILLER_7_267 VPWR VGND VPWR VGND sky130_fd_sc_hd__decap_3
XFILLER_11_252 VPWR VGND VPWR VGND sky130_fd_sc_hd__decap_3
XFILLER_11_296 VPWR VGND VPWR VGND sky130_fd_sc_hd__decap_3
XFILLER_22_6 VPWR VGND VPWR VGND sky130_fd_sc_hd__decap_3
XFILLER_4_215 VPWR VGND VPWR VGND sky130_fd_sc_hd__decap_3
XFILLER_4_248 VPWR VGND VPWR VGND sky130_fd_sc_hd__decap_3
XFILLER_20_97 VPWR VGND VPWR VGND sky130_fd_sc_hd__decap_3
XFILLER_20_53 VPWR VGND VPWR VGND sky130_fd_sc_hd__decap_3
XFILLER_4_259 VPWR VGND VPWR VGND sky130_fd_sc_hd__decap_3
XFILLER_3_270 VPWR VGND VPWR VGND sky130_fd_sc_hd__decap_3
XFILLER_3_281 VPWR VGND VPWR VGND sky130_fd_sc_hd__decap_3
XFILLER_6_44 VPWR VGND VPWR VGND sky130_fd_sc_hd__decap_3
XFILLER_6_77 VPWR VGND VPWR VGND sky130_fd_sc_hd__decap_3
XFILLER_6_88 VPWR VGND VPWR VGND sky130_fd_sc_hd__decap_3
XFILLER_20_3 VPWR VGND VPWR VGND sky130_fd_sc_hd__decap_3
XFILLER_19_193 VPWR VGND VPWR VGND sky130_fd_sc_hd__decap_3
XFILLER_17_119 VPWR VGND VPWR VGND sky130_fd_sc_hd__decap_3
XFILLER_17_108 VPWR VGND VPWR VGND sky130_fd_sc_hd__decap_3
XFILLER_15_75 VPWR VGND VPWR VGND sky130_fd_sc_hd__decap_3
XFILLER_15_42 VPWR VGND VPWR VGND sky130_fd_sc_hd__decap_3
XFILLER_13_314 VPWR VGND VPWR VGND sky130_fd_sc_hd__decap_3
XFILLER_9_329 VPWR VGND VPWR VGND sky130_fd_sc_hd__decap_3
XFILLER_0_284 VPWR VGND VPWR VGND sky130_fd_sc_hd__decap_3
XFILLER_0_262 VPWR VGND VPWR VGND sky130_fd_sc_hd__decap_3
XFILLER_0_240 VPWR VGND VPWR VGND sky130_fd_sc_hd__decap_3
XFILLER_16_174 VPWR VGND VPWR VGND sky130_fd_sc_hd__decap_3
XFILLER_16_141 VPWR VGND VPWR VGND sky130_fd_sc_hd__decap_3
XFILLER_16_130 VPWR VGND VPWR VGND sky130_fd_sc_hd__decap_3
.ends

.subckt tt_um_misfit01b clk ena rst_n ui_in[0] ui_in[1] ui_in[2] ui_in[3] ui_in[4]
+ ui_in[5] ui_in[6] ui_in[7] uio_in[0] uio_in[1] uio_in[2] uio_in[3] uio_in[4] uio_in[5]
+ uio_in[6] uio_in[7] uio_oe[0] uio_oe[1] uio_oe[2] uio_oe[3] uio_oe[4] uio_oe[5]
+ uio_oe[6] uio_oe[7] uio_out[0] uio_out[1] uio_out[2] uio_out[3] uio_out[4] uio_out[5]
+ uio_out[6] uio_out[7] uo_out[0] uo_out[1] uo_out[2] uo_out[3] uo_out[4] uo_out[5]
+ uo_out[6] uo_out[7] VPWR VGND
Xmisfit_inv_m4_0 misfit_inv_m4_0/A misfit_inv_m4_0/Y VGND VPWR misfit_inv_m4
Xmisfit01_core_0 clk ena misfit_inv_m4_0/A misfit_inv_m4_0/Y ui_in[1] ui_in[2] ui_in[3]
+ ui_in[4] ui_in[5] ui_in[6] ui_in[7] uio_in[0] uio_in[1] uio_in[2] uio_in[3] uio_in[4]
+ uio_in[5] uio_in[6] uio_in[7] uio_oe[1] uio_oe[3] uio_oe[4] uio_oe[6] uio_out[1]
+ uio_out[4] uio_out[6] uio_out[7] uo_out[1] uo_out[3] uo_out[4] uo_out[6] ui_in[0]
+ uo_out[0] uio_oe[0] uio_out[3] uio_out[0] uio_oe[5] uo_out[5] uio_oe[2] uo_out[7]
+ uo_out[2] uio_out[5] uio_out[2] rst_n uio_oe[7] VPWR VGND misfit01_core
.ends
