* NGSPICE file created from u64.ext - technology: sky130A

.subckt u64 SEL0 SEL1 SEL2 SEL3 SEL4 SEL5 SEL6 SEL7 SEL8 SEL9 SEL10 SEL11 SEL12 SEL13
+ SEL14 SEL15 SEL16 SEL17 SEL18 SEL19 SEL20 SEL21 SEL22 SEL23 SEL24 SEL25 SEL26 SEL27
+ SEL28 SEL29 SEL30 SEL31 SEL32 SEL33 SEL34 SEL35 SEL36 SEL37 SEL38 SEL39 SEL40 SEL41
+ SEL42 SEL43 SEL44 SEL45 SEL46 SEL47 SEL48 SEL49 SEL50 SEL51 SEL52 SEL53 SEL54 SEL55
+ SEL56 SEL57 SEL58 SEL59 SEL60 SEL61 SEL62 SEL63 X VB GND
X0 X VB a_10758_n392# GND sky130_fd_pr__nfet_01v8 ad=0.126 pd=1.44 as=0.126 ps=1.44 w=0.42 l=0.15
X1 GND SEL23 a_5106_n392# GND sky130_fd_pr__nfet_01v8 ad=0.252 pd=2.28 as=0.252 ps=2.28 w=0.84 l=0.15
X2 GND SEL9 a_2112_n392# GND sky130_fd_pr__nfet_01v8 ad=0.252 pd=2.28 as=0.252 ps=2.28 w=0.84 l=0.15
X3 GND SEL34 a_7626_n392# GND sky130_fd_pr__nfet_01v8 ad=0.252 pd=2.28 as=0.252 ps=2.28 w=0.84 l=0.15
X4 GND SEL54 a_11982_n392# GND sky130_fd_pr__nfet_01v8 ad=0.252 pd=2.28 as=0.252 ps=2.28 w=0.84 l=0.15
X5 X VB a_7830_n392# GND sky130_fd_pr__nfet_01v8 ad=0.126 pd=1.44 as=0.126 ps=1.44 w=0.42 l=0.15
X6 X VB a_5652_n392# GND sky130_fd_pr__nfet_01v8 ad=0.126 pd=1.44 as=0.126 ps=1.44 w=0.42 l=0.15
X7 X VB a_4290_n392# GND sky130_fd_pr__nfet_01v8 ad=0.126 pd=1.44 as=0.126 ps=1.44 w=0.42 l=0.15
X8 GND SEL25 a_5652_n392# GND sky130_fd_pr__nfet_01v8 ad=0.252 pd=2.28 as=0.252 ps=2.28 w=0.84 l=0.15
X9 X VB a_2928_n392# GND sky130_fd_pr__nfet_01v8 ad=0.126 pd=1.44 as=0.126 ps=1.44 w=0.42 l=0.15
X10 GND SEL39 a_8646_n392# GND sky130_fd_pr__nfet_01v8 ad=0.252 pd=2.28 as=0.252 ps=2.28 w=0.84 l=0.15
X11 X VB a_13752_n392# GND sky130_fd_pr__nfet_01v8 ad=0.126 pd=1.44 as=0.126 ps=1.44 w=0.42 l=0.15
X12 GND SEL37 a_8238_n392# GND sky130_fd_pr__nfet_01v8 ad=0.252 pd=2.28 as=0.252 ps=2.28 w=0.84 l=0.15
X13 X VB a_8646_n392# GND sky130_fd_pr__nfet_01v8 ad=0.126 pd=1.44 as=0.126 ps=1.44 w=0.42 l=0.15
X14 GND SEL56 a_12528_n392# GND sky130_fd_pr__nfet_01v8 ad=0.252 pd=2.28 as=0.252 ps=2.28 w=0.84 l=0.15
X15 GND SEL45 a_10008_n392# GND sky130_fd_pr__nfet_01v8 ad=0.252 pd=2.28 as=0.252 ps=2.28 w=0.84 l=0.15
X16 X VB a_342_n392# GND sky130_fd_pr__nfet_01v8 ad=0.126 pd=1.44 as=0.126 ps=1.44 w=0.42 l=0.15
X17 GND SEL16 a_3678_n392# GND sky130_fd_pr__nfet_01v8 ad=0.252 pd=2.28 as=0.252 ps=2.28 w=0.84 l=0.15
X18 GND SEL5 a_1158_n392# GND sky130_fd_pr__nfet_01v8 ad=0.252 pd=2.28 as=0.252 ps=2.28 w=0.84 l=0.15
X19 X VB a_9396_n392# GND sky130_fd_pr__nfet_01v8 ad=0.126 pd=1.44 as=0.126 ps=1.44 w=0.42 l=0.15
X20 X VB a_10962_n392# GND sky130_fd_pr__nfet_01v8 ad=0.126 pd=1.44 as=0.126 ps=1.44 w=0.42 l=0.15
X21 X VB a_8034_n392# GND sky130_fd_pr__nfet_01v8 ad=0.126 pd=1.44 as=0.126 ps=1.44 w=0.42 l=0.15
X22 GND SEL28 a_6264_n392# GND sky130_fd_pr__nfet_01v8 ad=0.252 pd=2.28 as=0.252 ps=2.28 w=0.84 l=0.15
X23 GND SEL61 a_13548_n392# GND sky130_fd_pr__nfet_01v8 ad=0.252 pd=2.28 as=0.252 ps=2.28 w=0.84 l=0.15
X24 GND SEL3 a_750_n392# GND sky130_fd_pr__nfet_01v8 ad=0.252 pd=2.28 as=0.252 ps=2.28 w=0.84 l=0.15
X25 X VB a_13956_n392# GND sky130_fd_pr__nfet_01v8 ad=0.126 pd=1.44 as=0.126 ps=1.44 w=0.42 l=0.15
X26 X VB a_5856_n392# GND sky130_fd_pr__nfet_01v8 ad=0.126 pd=1.44 as=0.126 ps=1.44 w=0.42 l=0.15
X27 GND SEL59 a_13140_n392# GND sky130_fd_pr__nfet_01v8 ad=0.252 pd=2.28 as=0.252 ps=2.28 w=0.84 l=0.15
X28 GND SEL22 a_4902_n392# GND sky130_fd_pr__nfet_01v8 ad=0.252 pd=2.28 as=0.252 ps=2.28 w=0.84 l=0.15
X29 X VB a_4494_n392# GND sky130_fd_pr__nfet_01v8 ad=0.126 pd=1.44 as=0.126 ps=1.44 w=0.42 l=0.15
X30 X VB a_954_n392# GND sky130_fd_pr__nfet_01v8 ad=0.126 pd=1.44 as=0.126 ps=1.44 w=0.42 l=0.15
X31 X VB a_3132_n392# GND sky130_fd_pr__nfet_01v8 ad=0.126 pd=1.44 as=0.126 ps=1.44 w=0.42 l=0.15
X32 GND SEL42 a_9396_n392# GND sky130_fd_pr__nfet_01v8 ad=0.252 pd=2.28 as=0.252 ps=2.28 w=0.84 l=0.15
X33 GND SEL50 a_11166_n392# GND sky130_fd_pr__nfet_01v8 ad=0.252 pd=2.28 as=0.252 ps=2.28 w=0.84 l=0.15
X34 GND SEL13 a_2928_n392# GND sky130_fd_pr__nfet_01v8 ad=0.252 pd=2.28 as=0.252 ps=2.28 w=0.84 l=0.15
X35 X VB a_546_n392# GND sky130_fd_pr__nfet_01v8 ad=0.126 pd=1.44 as=0.126 ps=1.44 w=0.42 l=0.15
X36 GND SEL11 a_2520_n392# GND sky130_fd_pr__nfet_01v8 ad=0.252 pd=2.28 as=0.252 ps=2.28 w=0.84 l=0.15
X37 X VB a_11166_n392# GND sky130_fd_pr__nfet_01v8 ad=0.126 pd=1.44 as=0.126 ps=1.44 w=0.42 l=0.15
X38 X VB a_8238_n392# GND sky130_fd_pr__nfet_01v8 ad=0.126 pd=1.44 as=0.126 ps=1.44 w=0.42 l=0.15
X39 X VB a_9600_n392# GND sky130_fd_pr__nfet_01v8 ad=0.126 pd=1.44 as=0.126 ps=1.44 w=0.42 l=0.15
X40 X VB a_6060_n392# GND sky130_fd_pr__nfet_01v8 ad=0.126 pd=1.44 as=0.126 ps=1.44 w=0.42 l=0.15
X41 X VB a_4698_n392# GND sky130_fd_pr__nfet_01v8 ad=0.126 pd=1.44 as=0.126 ps=1.44 w=0.42 l=0.15
X42 GND SEL24 a_5448_n392# GND sky130_fd_pr__nfet_01v8 ad=0.252 pd=2.28 as=0.252 ps=2.28 w=0.84 l=0.15
X43 GND SEL14 a_3132_n392# GND sky130_fd_pr__nfet_01v8 ad=0.252 pd=2.28 as=0.252 ps=2.28 w=0.84 l=0.15
X44 X VB a_1158_n392# GND sky130_fd_pr__nfet_01v8 ad=0.126 pd=1.44 as=0.126 ps=1.44 w=0.42 l=0.15
X45 X VB a_3336_n392# GND sky130_fd_pr__nfet_01v8 ad=0.126 pd=1.44 as=0.126 ps=1.44 w=0.42 l=0.15
X46 GND SEL47 a_10416_n392# GND sky130_fd_pr__nfet_01v8 ad=0.252 pd=2.28 as=0.252 ps=2.28 w=0.84 l=0.15
X47 GND SEL58 a_12936_n392# GND sky130_fd_pr__nfet_01v8 ad=0.252 pd=2.28 as=0.252 ps=2.28 w=0.84 l=0.15
X48 GND SEL7 a_1566_n392# GND sky130_fd_pr__nfet_01v8 ad=0.252 pd=2.28 as=0.252 ps=2.28 w=0.84 l=0.15
X49 GND SEL30 a_6672_n392# GND sky130_fd_pr__nfet_01v8 ad=0.252 pd=2.28 as=0.252 ps=2.28 w=0.84 l=0.15
X50 X VB a_10008_n392# GND sky130_fd_pr__nfet_01v8 ad=0.126 pd=1.44 as=0.126 ps=1.44 w=0.42 l=0.15
X51 X VB a_1908_n392# GND sky130_fd_pr__nfet_01v8 ad=0.126 pd=1.44 as=0.126 ps=1.44 w=0.42 l=0.15
X52 X VB a_138_n392# GND sky130_fd_pr__nfet_01v8 ad=0.126 pd=1.44 as=0.126 ps=1.44 w=0.42 l=0.15
X53 X VB a_750_n392# GND sky130_fd_pr__nfet_01v8 ad=0.126 pd=1.44 as=0.126 ps=1.44 w=0.42 l=0.15
X54 GND SEL2 a_546_n392# GND sky130_fd_pr__nfet_01v8 ad=0.252 pd=2.28 as=0.252 ps=2.28 w=0.84 l=0.15
X55 X VB a_9804_n392# GND sky130_fd_pr__nfet_01v8 ad=0.126 pd=1.44 as=0.126 ps=1.44 w=0.42 l=0.15
X56 GND SEL0 a_138_n392# GND sky130_fd_pr__nfet_01v8 ad=0.252 pd=2.28 as=0.252 ps=2.28 w=0.84 l=0.15
X57 X VB a_11370_n392# GND sky130_fd_pr__nfet_01v8 ad=0.126 pd=1.44 as=0.126 ps=1.44 w=0.42 l=0.15
X58 X VB a_6264_n392# GND sky130_fd_pr__nfet_01v8 ad=0.126 pd=1.44 as=0.126 ps=1.44 w=0.42 l=0.15
X59 GND SEL21 a_4698_n392# GND sky130_fd_pr__nfet_01v8 ad=0.252 pd=2.28 as=0.252 ps=2.28 w=0.84 l=0.15
X60 GND SEL19 a_4290_n392# GND sky130_fd_pr__nfet_01v8 ad=0.252 pd=2.28 as=0.252 ps=2.28 w=0.84 l=0.15
X61 GND SEL44 a_9804_n392# GND sky130_fd_pr__nfet_01v8 ad=0.252 pd=2.28 as=0.252 ps=2.28 w=0.84 l=0.15
X62 GND SEL52 a_11574_n392# GND sky130_fd_pr__nfet_01v8 ad=0.252 pd=2.28 as=0.252 ps=2.28 w=0.84 l=0.15
X63 X VB a_4902_n392# GND sky130_fd_pr__nfet_01v8 ad=0.126 pd=1.44 as=0.126 ps=1.44 w=0.42 l=0.15
X64 X VB a_1362_n392# GND sky130_fd_pr__nfet_01v8 ad=0.126 pd=1.44 as=0.126 ps=1.44 w=0.42 l=0.15
X65 GND SEL10 a_2316_n392# GND sky130_fd_pr__nfet_01v8 ad=0.252 pd=2.28 as=0.252 ps=2.28 w=0.84 l=0.15
X66 GND SEL33 a_7422_n392# GND sky130_fd_pr__nfet_01v8 ad=0.252 pd=2.28 as=0.252 ps=2.28 w=0.84 l=0.15
X67 X VB a_2112_n392# GND sky130_fd_pr__nfet_01v8 ad=0.126 pd=1.44 as=0.126 ps=1.44 w=0.42 l=0.15
X68 GND SEL55 a_12186_n392# GND sky130_fd_pr__nfet_01v8 ad=0.252 pd=2.28 as=0.252 ps=2.28 w=0.84 l=0.15
X69 X VB a_11574_n392# GND sky130_fd_pr__nfet_01v8 ad=0.126 pd=1.44 as=0.126 ps=1.44 w=0.42 l=0.15
X70 X VB a_6468_n392# GND sky130_fd_pr__nfet_01v8 ad=0.126 pd=1.44 as=0.126 ps=1.44 w=0.42 l=0.15
X71 GND SEL26 a_5856_n392# GND sky130_fd_pr__nfet_01v8 ad=0.252 pd=2.28 as=0.252 ps=2.28 w=0.84 l=0.15
X72 X VB a_10212_n392# GND sky130_fd_pr__nfet_01v8 ad=0.126 pd=1.44 as=0.126 ps=1.44 w=0.42 l=0.15
X73 X VB a_5106_n392# GND sky130_fd_pr__nfet_01v8 ad=0.126 pd=1.44 as=0.126 ps=1.44 w=0.42 l=0.15
X74 GND SEL38 a_8442_n392# GND sky130_fd_pr__nfet_01v8 ad=0.252 pd=2.28 as=0.252 ps=2.28 w=0.84 l=0.15
X75 X VB a_7218_n392# GND sky130_fd_pr__nfet_01v8 ad=0.126 pd=1.44 as=0.126 ps=1.44 w=0.42 l=0.15
X76 GND SEL36 a_8034_n392# GND sky130_fd_pr__nfet_01v8 ad=0.252 pd=2.28 as=0.252 ps=2.28 w=0.84 l=0.15
X77 X VB a_1566_n392# GND sky130_fd_pr__nfet_01v8 ad=0.126 pd=1.44 as=0.126 ps=1.44 w=0.42 l=0.15
X78 GND SEL4 a_954_n392# GND sky130_fd_pr__nfet_01v8 ad=0.252 pd=2.28 as=0.252 ps=2.28 w=0.84 l=0.15
X79 GND SEL29 a_6468_n392# GND sky130_fd_pr__nfet_01v8 ad=0.252 pd=2.28 as=0.252 ps=2.28 w=0.84 l=0.15
X80 X VB a_3678_n392# GND sky130_fd_pr__nfet_01v8 ad=0.126 pd=1.44 as=0.126 ps=1.44 w=0.42 l=0.15
X81 GND SEL48 a_10758_n392# GND sky130_fd_pr__nfet_01v8 ad=0.252 pd=2.28 as=0.252 ps=2.28 w=0.84 l=0.15
X82 GND SEL27 a_6060_n392# GND sky130_fd_pr__nfet_01v8 ad=0.252 pd=2.28 as=0.252 ps=2.28 w=0.84 l=0.15
X83 X VB a_2316_n392# GND sky130_fd_pr__nfet_01v8 ad=0.126 pd=1.44 as=0.126 ps=1.44 w=0.42 l=0.15
X84 X VB a_13140_n392# GND sky130_fd_pr__nfet_01v8 ad=0.126 pd=1.44 as=0.126 ps=1.44 w=0.42 l=0.15
X85 GND SEL60 a_13344_n392# GND sky130_fd_pr__nfet_01v8 ad=0.252 pd=2.28 as=0.252 ps=2.28 w=0.84 l=0.15
X86 X VB a_11778_n392# GND sky130_fd_pr__nfet_01v8 ad=0.126 pd=1.44 as=0.126 ps=1.44 w=0.42 l=0.15
X87 X VB a_10416_n392# GND sky130_fd_pr__nfet_01v8 ad=0.126 pd=1.44 as=0.126 ps=1.44 w=0.42 l=0.15
X88 GND SEL18 a_4086_n392# GND sky130_fd_pr__nfet_01v8 ad=0.252 pd=2.28 as=0.252 ps=2.28 w=0.84 l=0.15
X89 X VB a_12528_n392# GND sky130_fd_pr__nfet_01v8 ad=0.126 pd=1.44 as=0.126 ps=1.44 w=0.42 l=0.15
X90 X VB a_6672_n392# GND sky130_fd_pr__nfet_01v8 ad=0.126 pd=1.44 as=0.126 ps=1.44 w=0.42 l=0.15
X91 GND SEL41 a_9192_n392# GND sky130_fd_pr__nfet_01v8 ad=0.252 pd=2.28 as=0.252 ps=2.28 w=0.84 l=0.15
X92 GND SEL63 a_13956_n392# GND sky130_fd_pr__nfet_01v8 ad=0.252 pd=2.28 as=0.252 ps=2.28 w=0.84 l=0.15
X93 GND SEL49 a_10962_n392# GND sky130_fd_pr__nfet_01v8 ad=0.252 pd=2.28 as=0.252 ps=2.28 w=0.84 l=0.15
X94 GND SEL12 a_2724_n392# GND sky130_fd_pr__nfet_01v8 ad=0.252 pd=2.28 as=0.252 ps=2.28 w=0.84 l=0.15
X95 X VB a_7422_n392# GND sky130_fd_pr__nfet_01v8 ad=0.126 pd=1.44 as=0.126 ps=1.44 w=0.42 l=0.15
X96 GND SEL35 a_7830_n392# GND sky130_fd_pr__nfet_01v8 ad=0.252 pd=2.28 as=0.252 ps=2.28 w=0.84 l=0.15
X97 GND SEL32 a_7218_n392# GND sky130_fd_pr__nfet_01v8 ad=0.252 pd=2.28 as=0.252 ps=2.28 w=0.84 l=0.15
X98 X VB a_13344_n392# GND sky130_fd_pr__nfet_01v8 ad=0.126 pd=1.44 as=0.126 ps=1.44 w=0.42 l=0.15
X99 X VB a_11982_n392# GND sky130_fd_pr__nfet_01v8 ad=0.126 pd=1.44 as=0.126 ps=1.44 w=0.42 l=0.15
X100 X VB a_3882_n392# GND sky130_fd_pr__nfet_01v8 ad=0.126 pd=1.44 as=0.126 ps=1.44 w=0.42 l=0.15
X101 GND SEL15 a_3336_n392# GND sky130_fd_pr__nfet_01v8 ad=0.252 pd=2.28 as=0.252 ps=2.28 w=0.84 l=0.15
X102 X VB a_8988_n392# GND sky130_fd_pr__nfet_01v8 ad=0.126 pd=1.44 as=0.126 ps=1.44 w=0.42 l=0.15
X103 X VB a_2520_n392# GND sky130_fd_pr__nfet_01v8 ad=0.126 pd=1.44 as=0.126 ps=1.44 w=0.42 l=0.15
X104 X VB a_6876_n392# GND sky130_fd_pr__nfet_01v8 ad=0.126 pd=1.44 as=0.126 ps=1.44 w=0.42 l=0.15
X105 GND SEL57 a_12732_n392# GND sky130_fd_pr__nfet_01v8 ad=0.252 pd=2.28 as=0.252 ps=2.28 w=0.84 l=0.15
X106 GND SEL46 a_10212_n392# GND sky130_fd_pr__nfet_01v8 ad=0.252 pd=2.28 as=0.252 ps=2.28 w=0.84 l=0.15
X107 GND SEL17 a_3882_n392# GND sky130_fd_pr__nfet_01v8 ad=0.252 pd=2.28 as=0.252 ps=2.28 w=0.84 l=0.15
X108 GND SEL6 a_1362_n392# GND sky130_fd_pr__nfet_01v8 ad=0.252 pd=2.28 as=0.252 ps=2.28 w=0.84 l=0.15
X109 X VB a_5448_n392# GND sky130_fd_pr__nfet_01v8 ad=0.126 pd=1.44 as=0.126 ps=1.44 w=0.42 l=0.15
X110 GND SEL31 a_6876_n392# GND sky130_fd_pr__nfet_01v8 ad=0.252 pd=2.28 as=0.252 ps=2.28 w=0.84 l=0.15
X111 X VB a_12732_n392# GND sky130_fd_pr__nfet_01v8 ad=0.126 pd=1.44 as=0.126 ps=1.44 w=0.42 l=0.15
X112 X VB a_7626_n392# GND sky130_fd_pr__nfet_01v8 ad=0.126 pd=1.44 as=0.126 ps=1.44 w=0.42 l=0.15
X113 X VB a_4086_n392# GND sky130_fd_pr__nfet_01v8 ad=0.126 pd=1.44 as=0.126 ps=1.44 w=0.42 l=0.15
X114 X VB a_13548_n392# GND sky130_fd_pr__nfet_01v8 ad=0.126 pd=1.44 as=0.126 ps=1.44 w=0.42 l=0.15
X115 GND SEL62 a_13752_n392# GND sky130_fd_pr__nfet_01v8 ad=0.252 pd=2.28 as=0.252 ps=2.28 w=0.84 l=0.15
X116 GND SEL8 a_1908_n392# GND sky130_fd_pr__nfet_01v8 ad=0.252 pd=2.28 as=0.252 ps=2.28 w=0.84 l=0.15
X117 GND SEL1 a_342_n392# GND sky130_fd_pr__nfet_01v8 ad=0.252 pd=2.28 as=0.252 ps=2.28 w=0.84 l=0.15
X118 X VB a_12186_n392# GND sky130_fd_pr__nfet_01v8 ad=0.126 pd=1.44 as=0.126 ps=1.44 w=0.42 l=0.15
X119 GND SEL20 a_4494_n392# GND sky130_fd_pr__nfet_01v8 ad=0.252 pd=2.28 as=0.252 ps=2.28 w=0.84 l=0.15
X120 X VB a_2724_n392# GND sky130_fd_pr__nfet_01v8 ad=0.126 pd=1.44 as=0.126 ps=1.44 w=0.42 l=0.15
X121 GND SEL53 a_11778_n392# GND sky130_fd_pr__nfet_01v8 ad=0.252 pd=2.28 as=0.252 ps=2.28 w=0.84 l=0.15
X122 X VB a_8442_n392# GND sky130_fd_pr__nfet_01v8 ad=0.126 pd=1.44 as=0.126 ps=1.44 w=0.42 l=0.15
X123 GND SEL43 a_9600_n392# GND sky130_fd_pr__nfet_01v8 ad=0.252 pd=2.28 as=0.252 ps=2.28 w=0.84 l=0.15
X124 GND SEL51 a_11370_n392# GND sky130_fd_pr__nfet_01v8 ad=0.252 pd=2.28 as=0.252 ps=2.28 w=0.84 l=0.15
X125 GND SEL40 a_8988_n392# GND sky130_fd_pr__nfet_01v8 ad=0.252 pd=2.28 as=0.252 ps=2.28 w=0.84 l=0.15
X126 X VB a_12936_n392# GND sky130_fd_pr__nfet_01v8 ad=0.126 pd=1.44 as=0.126 ps=1.44 w=0.42 l=0.15
X127 X VB a_9192_n392# GND sky130_fd_pr__nfet_01v8 ad=0.126 pd=1.44 as=0.126 ps=1.44 w=0.42 l=0.15
C0 SEL1 a_342_n392# 0.0031f
C1 VB a_9396_n392# 0.08024f
C2 SEL26 SEL25 0.09569f
C3 a_3336_n392# X 0.0562f
C4 a_1158_n392# a_954_n392# 0.01932f
C5 SEL51 VB 0.01474f
C6 a_11982_n392# X 0.0562f
C7 SEL20 SEL21 0.09569f
C8 SEL47 a_10758_n392# 0
C9 X a_342_n392# 0.0562f
C10 SEL53 X 0
C11 X SEL40 0
C12 SEL11 SEL12 0.09569f
C13 a_11778_n392# a_11574_n392# 0.01932f
C14 a_8646_n392# X 0.0562f
C15 a_8646_n392# SEL38 0
C16 a_6672_n392# VB 0.08024f
C17 a_13752_n392# a_13548_n392# 0.01932f
C18 SEL43 SEL44 0.09569f
C19 X SEL24 0
C20 a_5106_n392# a_5448_n392# 0.01138f
C21 SEL25 a_5856_n392# 0
C22 SEL59 VB 0.01474f
C23 SEL3 SEL4 0.09569f
C24 VB a_13344_n392# 0.08024f
C25 VB a_4290_n392# 0.08024f
C26 SEL7 X 0
C27 SEL11 SEL10 0.09569f
C28 a_7830_n392# a_7626_n392# 0.01932f
C29 SEL45 VB 0.01474f
C30 SEL9 VB 0.01474f
C31 a_3132_n392# SEL14 0.0031f
C32 a_5106_n392# SEL23 0.0031f
C33 SEL50 SEL51 0.09569f
C34 VB a_10962_n392# 0.08024f
C35 SEL39 SEL40 0.05373f
C36 SEL54 VB 0.01474f
C37 a_2316_n392# VB 0.08024f
C38 a_8646_n392# SEL39 0.0031f
C39 a_7422_n392# VB 0.08024f
C40 X SEL22 0
C41 SEL37 SEL38 0.09569f
C42 SEL37 X 0
C43 SEL59 SEL58 0.09569f
C44 a_12186_n392# SEL54 0
C45 a_9600_n392# X 0.0562f
C46 a_12732_n392# X 0.0562f
C47 a_5652_n392# SEL24 0
C48 SEL59 SEL60 0.09569f
C49 SEL42 X 0
C50 SEL60 a_13344_n392# 0.0031f
C51 SEL36 a_8238_n392# 0
C52 SEL13 VB 0.01474f
C53 SEL5 SEL4 0.09569f
C54 SEL21 SEL22 0.09569f
C55 VB SEL15 0.01474f
C56 VB SEL1 0.01474f
C57 a_12936_n392# a_13140_n392# 0.01932f
C58 a_4698_n392# X 0.0562f
C59 a_6468_n392# a_6672_n392# 0.01932f
C60 a_5448_n392# SEL24 0.0031f
C61 SEL62 VB 0.01474f
C62 a_546_n392# SEL1 0
C63 X VB 3.42681f
C64 SEL38 VB 0.01474f
C65 a_7626_n392# SEL34 0.0031f
C66 SEL1 SEL2 0.09569f
C67 SEL41 a_9396_n392# 0
C68 a_4698_n392# SEL21 0.0031f
C69 SEL32 VB 0.01474f
C70 SEL19 SEL20 0.09569f
C71 X a_6060_n392# 0.0562f
C72 a_12186_n392# X 0.0562f
C73 a_12732_n392# SEL56 0
C74 a_6876_n392# VB 0.08041f
C75 a_546_n392# X 0.0562f
C76 X a_954_n392# 0.0562f
C77 X a_8988_n392# 0.04207f
C78 VB SEL33 0.01474f
C79 VB a_8034_n392# 0.08024f
C80 a_4902_n392# X 0.0562f
C81 X a_10416_n392# 0.0562f
C82 a_10758_n392# VB 0.07335f
C83 X SEL2 0
C84 VB SEL21 0.01474f
C85 SEL26 X 0
C86 SEL6 SEL7 0.09569f
C87 SEL7 a_1908_n392# 0
C88 a_10962_n392# a_11166_n392# 0.01932f
C89 a_10758_n392# a_10416_n392# 0.01138f
C90 SEL23 SEL24 0.05373f
C91 a_4902_n392# SEL21 0
C92 SEL51 a_11574_n392# 0
C93 VB SEL55 0.01474f
C94 a_2112_n392# VB 0.08024f
C95 a_10008_n392# SEL44 0
C96 a_13548_n392# a_13344_n392# 0.01932f
C97 a_12528_n392# X 0.04207f
C98 a_12186_n392# SEL55 0.0031f
C99 a_4086_n392# VB 0.08024f
C100 X a_3882_n392# 0.0562f
C101 VB SEL56 0.01474f
C102 SEL58 X 0
C103 a_1158_n392# SEL4 0
C104 SEL13 SEL14 0.09569f
C105 X a_5856_n392# 0.0562f
C106 VB SEL39 0.01474f
C107 X SEL60 0
C108 SEL29 VB 0.01474f
C109 SEL15 SEL14 0.09569f
C110 SEL53 SEL52 0.09569f
C111 a_9192_n392# SEL40 0
C112 VB a_5652_n392# 0.08024f
C113 a_3336_n392# a_3678_n392# 0.01138f
C114 SEL12 a_2928_n392# 0
C115 SEL50 X 0
C116 a_8988_n392# SEL39 0
C117 a_750_n392# X 0.0562f
C118 X a_8442_n392# 0.0562f
C119 SEL38 a_8442_n392# 0.0031f
C120 SEL18 a_4290_n392# 0
C121 a_13956_n392# VB 0.08036f
C122 X SEL14 0
C123 X a_11166_n392# 0.0562f
C124 SEL23 SEL22 0.09569f
C125 a_7830_n392# X 0.0562f
C126 a_12528_n392# SEL55 0
C127 a_138_n392# a_342_n392# 0.01932f
C128 SEL48 a_10962_n392# 0
C129 a_5448_n392# VB 0.07335f
C130 SEL37 a_8238_n392# 0.0031f
C131 VB SEL63 0.01474f
C132 SEL5 a_1158_n392# 0.0031f
C133 a_6468_n392# X 0.0562f
C134 a_2520_n392# VB 0.08024f
C135 a_4086_n392# a_3882_n392# 0.01932f
C136 a_12528_n392# SEL56 0.0031f
C137 SEL35 X 0
C138 a_7830_n392# a_8034_n392# 0.01932f
C139 SEL31 a_7218_n392# 0
C140 SEL15 SEL16 0.05373f
C141 SEL45 SEL44 0.09569f
C142 SEL6 VB 0.01474f
C143 X a_1566_n392# 0.0562f
C144 a_10212_n392# VB 0.08024f
C145 a_1908_n392# VB 0.07335f
C146 SEL17 VB 0.01474f
C147 SEL35 a_8034_n392# 0
C148 SEL11 X 0
C149 a_5652_n392# a_5856_n392# 0.01932f
C150 a_4290_n392# a_4494_n392# 0.01932f
C151 a_12936_n392# a_12732_n392# 0.01932f
C152 a_10212_n392# a_10416_n392# 0.01932f
C153 SEL41 X 0
C154 SEL23 VB 0.01474f
C155 VB a_8238_n392# 0.08024f
C156 X SEL16 0
C157 SEL27 X 0
C158 a_6264_n392# X 0.0562f
C159 VB a_2724_n392# 0.08024f
C160 a_13548_n392# X 0.0562f
C161 SEL48 X 0
C162 SEL46 SEL45 0.09569f
C163 a_1362_n392# VB 0.08024f
C164 a_3132_n392# a_2928_n392# 0.01932f
C165 VB SEL61 0.01474f
C166 SEL19 VB 0.01474f
C167 SEL53 a_11982_n392# 0
C168 a_6468_n392# SEL29 0.0031f
C169 SEL28 VB 0.01474f
C170 SEL48 a_10758_n392# 0.0031f
C171 a_11574_n392# X 0.0562f
C172 a_5106_n392# SEL22 0
C173 SEL18 X 0
C174 a_12936_n392# VB 0.08024f
C175 SEL43 X 0
C176 SEL17 a_3882_n392# 0.0031f
C177 SEL3 X 0
C178 X SEL34 0
C179 VB a_9192_n392# 0.08024f
C180 SEL49 VB 0.01474f
C181 VB SEL52 0.01474f
C182 SEL0 SEL1 0.09569f
C183 SEL33 SEL34 0.09569f
C184 SEL37 SEL36 0.09569f
C185 a_8988_n392# a_9192_n392# 0.01932f
C186 X SEL44 0
C187 SEL30 VB 0.01474f
C188 a_11778_n392# X 0.0562f
C189 SEL9 SEL10 0.09569f
C190 a_9804_n392# a_9600_n392# 0.01932f
C191 a_3678_n392# VB 0.07335f
C192 X SEL4 0
C193 SEL0 X 0
C194 SEL13 SEL12 0.09569f
C195 a_5106_n392# VB 0.08041f
C196 X SEL57 0
C197 VB a_138_n392# 0.06465f
C198 a_8442_n392# a_8238_n392# 0.01932f
C199 VB a_11370_n392# 0.08024f
C200 SEL60 SEL61 0.09569f
C201 VB a_13140_n392# 0.08024f
C202 SEL10 a_2316_n392# 0.0031f
C203 a_13752_n392# SEL62 0.0031f
C204 X a_4494_n392# 0.0562f
C205 SEL18 a_4086_n392# 0.0031f
C206 a_2520_n392# SEL11 0.0031f
C207 a_13752_n392# X 0.0562f
C208 SEL58 a_12936_n392# 0.0031f
C209 SEL46 X 0
C210 a_5106_n392# a_4902_n392# 0.01932f
C211 SEL6 a_1566_n392# 0
C212 a_1908_n392# a_1566_n392# 0.01138f
C213 SEL36 VB 0.01474f
C214 a_9804_n392# VB 0.08024f
C215 SEL12 X 0
C216 SEL5 X 0
C217 a_4698_n392# SEL20 0
C218 a_10008_n392# SEL45 0.0031f
C219 SEL9 SEL8 0.09569f
C220 a_7422_n392# a_7626_n392# 0.01932f
C221 SEL50 SEL49 0.09569f
C222 a_3678_n392# a_3882_n392# 0.01932f
C223 SEL20 VB 0.01474f
C224 SEL17 SEL16 0.09569f
C225 a_6468_n392# SEL28 0
C226 SEL11 a_2724_n392# 0
C227 SEL47 VB 0.01474f
C228 SEL56 SEL57 0.09569f
C229 SEL10 X 0
C230 SEL31 X 0
C231 a_1362_n392# a_1566_n392# 0.01932f
C232 SEL49 a_11166_n392# 0
C233 SEL58 a_13140_n392# 0
C234 a_3336_n392# VB 0.08041f
C235 a_7218_n392# a_7422_n392# 0.01932f
C236 SEL13 a_2928_n392# 0.0031f
C237 SEL31 SEL32 0.05373f
C238 a_11982_n392# VB 0.08024f
C239 SEL59 a_13344_n392# 0
C240 SEL31 a_6876_n392# 0.0031f
C241 SEL47 a_10416_n392# 0.0031f
C242 VB a_342_n392# 0.08024f
C243 SEL53 VB 0.01474f
C244 a_11982_n392# a_12186_n392# 0.01932f
C245 SEL50 a_11370_n392# 0
C246 a_3132_n392# SEL13 0
C247 SEL18 SEL17 0.09569f
C248 VB SEL40 0.01474f
C249 a_8646_n392# VB 0.08041f
C250 X a_7626_n392# 0.0562f
C251 a_13548_n392# SEL61 0.0031f
C252 a_546_n392# a_342_n392# 0.01932f
C253 VB SEL24 0.01474f
C254 SEL27 SEL28 0.09569f
C255 X a_2928_n392# 0.0562f
C256 a_6264_n392# SEL28 0.0031f
C257 a_11370_n392# a_11166_n392# 0.01932f
C258 a_13752_n392# a_13956_n392# 0.01932f
C259 a_8988_n392# SEL40 0.0031f
C260 a_8646_n392# a_8988_n392# 0.01138f
C261 a_7626_n392# SEL33 0
C262 SEL7 VB 0.01474f
C263 SEL8 X 0
C264 SEL41 a_9192_n392# 0.0031f
C265 SEL25 X 0
C266 a_7218_n392# X 0.04207f
C267 a_3132_n392# X 0.0562f
C268 a_10008_n392# X 0.0562f
C269 SEL32 a_7218_n392# 0.0031f
C270 SEL19 SEL18 0.09569f
C271 a_1158_n392# X 0.0562f
C272 SEL48 SEL49 0.09569f
C273 a_6876_n392# a_7218_n392# 0.01138f
C274 a_9600_n392# SEL42 0
C275 a_3678_n392# SEL16 0.0031f
C276 X a_9396_n392# 0.0562f
C277 SEL35 SEL36 0.09569f
C278 SEL51 X 0
C279 SEL46 a_10212_n392# 0.0031f
C280 a_11574_n392# SEL52 0.0031f
C281 SEL9 a_2316_n392# 0
C282 a_2112_n392# SEL8 0
C283 SEL6 SEL5 0.09569f
C284 a_3336_n392# SEL14 0
C285 VB SEL22 0.01474f
C286 SEL37 VB 0.01474f
C287 a_2520_n392# SEL10 0
C288 a_12732_n392# VB 0.08024f
C289 a_9600_n392# VB 0.08024f
C290 a_6672_n392# X 0.0562f
C291 SEL42 VB 0.01474f
C292 a_4902_n392# SEL22 0.0031f
C293 a_8646_n392# a_8442_n392# 0.01932f
C294 SEL59 X 0
C295 SEL19 a_4494_n392# 0
C296 X a_13344_n392# 0.0562f
C297 a_13752_n392# SEL61 0
C298 X a_4290_n392# 0.0562f
C299 a_11778_n392# SEL52 0
C300 a_6876_n392# a_6672_n392# 0.01932f
C301 SEL12 a_2724_n392# 0.0031f
C302 a_11574_n392# a_11370_n392# 0.01932f
C303 a_12936_n392# SEL57 0
C304 SEL25 a_5652_n392# 0.0031f
C305 a_1362_n392# SEL5 0
C306 a_4698_n392# VB 0.08024f
C307 SEL45 X 0
C308 SEL9 X 0
C309 a_4902_n392# a_4698_n392# 0.01932f
C310 a_9804_n392# SEL43 0
C311 VB a_6060_n392# 0.08024f
C312 SEL48 SEL47 0.05373f
C313 a_12186_n392# VB 0.08041f
C314 SEL0 a_138_n392# 0.0031f
C315 a_12528_n392# a_12732_n392# 0.01932f
C316 X a_10962_n392# 0.0562f
C317 VB a_8988_n392# 0.07335f
C318 SEL54 X 0
C319 a_546_n392# VB 0.08024f
C320 VB a_954_n392# 0.08024f
C321 a_4902_n392# VB 0.08024f
C322 VB a_10416_n392# 0.08041f
C323 a_2316_n392# X 0.0562f
C324 VB SEL2 0.01474f
C325 a_7422_n392# X 0.0562f
C326 SEL26 VB 0.01474f
C327 SEL41 SEL40 0.09569f
C328 SEL29 a_6672_n392# 0
C329 a_4086_n392# a_4290_n392# 0.01932f
C330 SEL7 a_1566_n392# 0.0031f
C331 SEL8 a_1908_n392# 0.0031f
C332 SEL32 a_7422_n392# 0
C333 a_9804_n392# SEL44 0.0031f
C334 a_10758_n392# a_10962_n392# 0.01932f
C335 SEL26 a_6060_n392# 0
C336 SEL37 a_8442_n392# 0
C337 a_7422_n392# SEL33 0.0031f
C338 a_546_n392# SEL2 0.0031f
C339 a_10008_n392# a_10212_n392# 0.01932f
C340 SEL13 X 0
C341 a_2724_n392# a_2928_n392# 0.01932f
C342 a_2112_n392# SEL9 0.0031f
C343 X SEL15 0
C344 a_12528_n392# VB 0.07335f
C345 X SEL1 0
C346 VB a_3882_n392# 0.08024f
C347 SEL58 VB 0.01474f
C348 SEL54 SEL55 0.09569f
C349 VB a_5856_n392# 0.08024f
C350 SEL31 SEL30 0.09569f
C351 VB SEL60 0.01474f
C352 SEL62 X 0
C353 a_12528_n392# a_12186_n392# 0.01138f
C354 a_2112_n392# a_2316_n392# 0.01932f
C355 a_6060_n392# a_5856_n392# 0.01932f
C356 SEL38 X 0
C357 a_11778_n392# a_11982_n392# 0.01932f
C358 a_1362_n392# a_1158_n392# 0.01932f
C359 SEL50 VB 0.01474f
C360 SEL20 a_4494_n392# 0.0031f
C361 SEL32 X 0
C362 a_750_n392# VB 0.08024f
C363 VB a_8442_n392# 0.08024f
C364 SEL26 a_5856_n392# 0.0031f
C365 a_11778_n392# SEL53 0.0031f
C366 SEL0 a_342_n392# 0
C367 a_6876_n392# X 0.0562f
C368 X SEL33 0
C369 X a_8034_n392# 0.0562f
C370 X a_10758_n392# 0.04207f
C371 VB SEL14 0.01474f
C372 VB a_11166_n392# 0.08024f
C373 X SEL21 0
C374 SEL32 SEL33 0.09569f
C375 SEL46 SEL47 0.09569f
C376 a_750_n392# a_546_n392# 0.01932f
C377 a_7830_n392# VB 0.08024f
C378 a_750_n392# a_954_n392# 0.01932f
C379 a_6468_n392# VB 0.08024f
C380 a_750_n392# SEL2 0
C381 SEL41 SEL42 0.09569f
C382 SEL35 VB 0.01474f
C383 SEL45 a_10212_n392# 0
C384 X SEL55 0
C385 a_2112_n392# X 0.0562f
C386 a_9192_n392# a_9396_n392# 0.01932f
C387 VB a_1566_n392# 0.08041f
C388 a_2520_n392# a_2316_n392# 0.01932f
C389 X a_4086_n392# 0.0562f
C390 X SEL56 0
C391 SEL51 SEL52 0.09569f
C392 SEL11 VB 0.01474f
C393 SEL38 SEL39 0.09569f
C394 X SEL39 0
C395 SEL29 X 0
C396 SEL19 a_4290_n392# 0.0031f
C397 a_9600_n392# SEL43 0.0031f
C398 SEL41 VB 0.01474f
C399 X a_5652_n392# 0.0562f
C400 VB SEL16 0.01474f
C401 SEL27 VB 0.01474f
C402 a_6264_n392# VB 0.08024f
C403 SEL42 SEL43 0.09569f
C404 a_13548_n392# VB 0.08024f
C405 a_13956_n392# SEL62 0
C406 SEL27 a_6060_n392# 0.0031f
C407 SEL48 VB 0.01474f
C408 a_13956_n392# X 0.0562f
C409 a_6264_n392# a_6060_n392# 0.01932f
C410 SEL51 a_11370_n392# 0.0031f
C411 SEL62 SEL63 0.09569f
C412 a_9804_n392# a_10008_n392# 0.01932f
C413 SEL30 a_6672_n392# 0.0031f
C414 SEL50 a_11166_n392# 0.0031f
C415 SEL55 SEL56 0.05373f
C416 SEL26 SEL27 0.09569f
C417 a_5448_n392# X 0.04207f
C418 X SEL63 0
C419 a_11574_n392# VB 0.08024f
C420 a_2520_n392# X 0.0562f
C421 SEL18 VB 0.01474f
C422 SEL43 VB 0.01474f
C423 SEL3 VB 0.01474f
C424 a_12732_n392# SEL57 0.0031f
C425 VB SEL34 0.01474f
C426 SEL6 X 0
C427 X a_1908_n392# 0.04207f
C428 a_10212_n392# X 0.0562f
C429 a_3132_n392# a_3336_n392# 0.01932f
C430 SEL17 X 0
C431 a_3882_n392# SEL16 0
C432 SEL3 a_954_n392# 0
C433 SEL59 a_13140_n392# 0.0031f
C434 a_13140_n392# a_13344_n392# 0.01932f
C435 SEL49 a_10962_n392# 0.0031f
C436 SEL35 a_7830_n392# 0.0031f
C437 VB SEL44 0.01474f
C438 SEL3 SEL2 0.09569f
C439 a_11778_n392# VB 0.08024f
C440 VB SEL4 0.01474f
C441 SEL0 VB 0.01474f
C442 SEL23 X 0
C443 X a_8238_n392# 0.0562f
C444 a_13548_n392# SEL60 0
C445 a_4698_n392# a_4494_n392# 0.01932f
C446 X a_2724_n392# 0.0562f
C447 VB SEL57 0.01474f
C448 SEL25 SEL24 0.09569f
C449 a_1362_n392# X 0.0562f
C450 SEL62 SEL61 0.09569f
C451 SEL4 a_954_n392# 0.0031f
C452 VB a_4494_n392# 0.08024f
C453 X SEL61 0
C454 a_8034_n392# a_8238_n392# 0.01932f
C455 SEL19 X 0
C456 a_13752_n392# VB 0.08024f
C457 SEL7 SEL8 0.05373f
C458 SEL46 VB 0.01474f
C459 a_2112_n392# a_1908_n392# 0.01932f
C460 a_5448_n392# a_5652_n392# 0.01932f
C461 SEL28 X 0
C462 a_6468_n392# a_6264_n392# 0.01932f
C463 SEL12 VB 0.01474f
C464 a_12936_n392# X 0.0562f
C465 SEL17 a_4086_n392# 0
C466 SEL5 VB 0.01474f
C467 a_13956_n392# SEL63 0.0031f
C468 SEL46 a_10416_n392# 0
C469 a_3678_n392# SEL15 0
C470 X a_9192_n392# 0.0562f
C471 SEL49 X 0
C472 a_750_n392# SEL3 0.0031f
C473 X SEL52 0
C474 SEL10 VB 0.01474f
C475 SEL30 X 0
C476 SEL58 SEL57 0.09569f
C477 a_7830_n392# SEL34 0
C478 SEL31 VB 0.01474f
C479 a_3678_n392# X 0.04207f
C480 a_6264_n392# SEL27 0
C481 SEL35 SEL34 0.09569f
C482 SEL30 a_6876_n392# 0
C483 a_5106_n392# X 0.0562f
C484 X a_138_n392# 0.03199f
C485 X a_11370_n392# 0.0562f
C486 X a_13140_n392# 0.0562f
C487 a_11982_n392# SEL54 0.0031f
C488 SEL29 SEL28 0.09569f
C489 VB a_7626_n392# 0.08024f
C490 a_5448_n392# SEL23 0
C491 SEL53 SEL54 0.09569f
C492 a_9600_n392# a_9396_n392# 0.01932f
C493 VB a_2928_n392# 0.08024f
C494 SEL36 X 0
C495 a_9804_n392# X 0.0562f
C496 SEL42 a_9396_n392# 0.0031f
C497 a_2520_n392# a_2724_n392# 0.01932f
C498 SEL8 VB 0.01474f
C499 SEL25 VB 0.01474f
C500 a_3336_n392# SEL15 0.0031f
C501 a_7218_n392# VB 0.07335f
C502 a_3132_n392# VB 0.08024f
C503 SEL36 a_8034_n392# 0.0031f
C504 SEL20 X 0
C505 a_10008_n392# VB 0.08024f
C506 a_1158_n392# VB 0.08024f
C507 SEL30 SEL29 0.09569f
C508 SEL6 a_1362_n392# 0.0031f
C509 SEL47 X 0
C510 SEL63 GND 0.31454f
C511 SEL62 GND 0.24626f
C512 SEL61 GND 0.24626f
C513 SEL60 GND 0.24626f
C514 SEL59 GND 0.24626f
C515 SEL58 GND 0.24626f
C516 SEL57 GND 0.24626f
C517 SEL56 GND 0.26331f
C518 SEL55 GND 0.26337f
C519 SEL54 GND 0.24626f
C520 SEL53 GND 0.24626f
C521 SEL52 GND 0.24626f
C522 SEL51 GND 0.24626f
C523 SEL50 GND 0.24626f
C524 SEL49 GND 0.24626f
C525 SEL48 GND 0.26331f
C526 SEL47 GND 0.26337f
C527 SEL46 GND 0.24626f
C528 SEL45 GND 0.24626f
C529 SEL44 GND 0.24626f
C530 SEL43 GND 0.24626f
C531 SEL42 GND 0.24626f
C532 SEL41 GND 0.24626f
C533 SEL40 GND 0.26331f
C534 SEL39 GND 0.26337f
C535 SEL38 GND 0.24626f
C536 SEL37 GND 0.24626f
C537 SEL36 GND 0.24626f
C538 SEL35 GND 0.24626f
C539 SEL34 GND 0.24626f
C540 SEL33 GND 0.24626f
C541 SEL32 GND 0.26331f
C542 SEL31 GND 0.26337f
C543 SEL30 GND 0.24626f
C544 SEL29 GND 0.24626f
C545 SEL28 GND 0.24626f
C546 SEL27 GND 0.24626f
C547 SEL26 GND 0.24626f
C548 SEL25 GND 0.24626f
C549 SEL24 GND 0.26331f
C550 SEL23 GND 0.26337f
C551 SEL22 GND 0.24626f
C552 SEL21 GND 0.24626f
C553 SEL20 GND 0.24626f
C554 SEL19 GND 0.24626f
C555 SEL18 GND 0.24626f
C556 SEL17 GND 0.24626f
C557 SEL16 GND 0.26331f
C558 SEL15 GND 0.26337f
C559 SEL14 GND 0.24626f
C560 SEL13 GND 0.24626f
C561 SEL12 GND 0.24626f
C562 SEL11 GND 0.24626f
C563 SEL10 GND 0.24626f
C564 SEL9 GND 0.24626f
C565 SEL8 GND 0.26331f
C566 SEL7 GND 0.26337f
C567 SEL6 GND 0.24626f
C568 SEL5 GND 0.24626f
C569 SEL4 GND 0.24626f
C570 SEL3 GND 0.24626f
C571 SEL2 GND 0.24626f
C572 SEL1 GND 0.24626f
C573 SEL0 GND 0.31444f
C574 X GND 6.50752f
C575 VB GND 13.5106f
C576 a_13956_n392# GND 0.19344f
C577 a_13752_n392# GND 0.17382f
C578 a_13548_n392# GND 0.17382f
C579 a_13344_n392# GND 0.17382f
C580 a_13140_n392# GND 0.17382f
C581 a_12936_n392# GND 0.17382f
C582 a_12732_n392# GND 0.17382f
C583 a_12528_n392# GND 0.17671f
C584 a_12186_n392# GND 0.17944f
C585 a_11982_n392# GND 0.17382f
C586 a_11778_n392# GND 0.17382f
C587 a_11574_n392# GND 0.17382f
C588 a_11370_n392# GND 0.17382f
C589 a_11166_n392# GND 0.17382f
C590 a_10962_n392# GND 0.17382f
C591 a_10758_n392# GND 0.17671f
C592 a_10416_n392# GND 0.17944f
C593 a_10212_n392# GND 0.17382f
C594 a_10008_n392# GND 0.17382f
C595 a_9804_n392# GND 0.17382f
C596 a_9600_n392# GND 0.17382f
C597 a_9396_n392# GND 0.17382f
C598 a_9192_n392# GND 0.17382f
C599 a_8988_n392# GND 0.17671f
C600 a_8646_n392# GND 0.17944f
C601 a_8442_n392# GND 0.17382f
C602 a_8238_n392# GND 0.17382f
C603 a_8034_n392# GND 0.17382f
C604 a_7830_n392# GND 0.17382f
C605 a_7626_n392# GND 0.17382f
C606 a_7422_n392# GND 0.17382f
C607 a_7218_n392# GND 0.17671f
C608 a_6876_n392# GND 0.17944f
C609 a_6672_n392# GND 0.17382f
C610 a_6468_n392# GND 0.17382f
C611 a_6264_n392# GND 0.17382f
C612 a_6060_n392# GND 0.17382f
C613 a_5856_n392# GND 0.17382f
C614 a_5652_n392# GND 0.17382f
C615 a_5448_n392# GND 0.17671f
C616 a_5106_n392# GND 0.17944f
C617 a_4902_n392# GND 0.17382f
C618 a_4698_n392# GND 0.17382f
C619 a_4494_n392# GND 0.17382f
C620 a_4290_n392# GND 0.17382f
C621 a_4086_n392# GND 0.17382f
C622 a_3882_n392# GND 0.17382f
C623 a_3678_n392# GND 0.17671f
C624 a_3336_n392# GND 0.17944f
C625 a_3132_n392# GND 0.17382f
C626 a_2928_n392# GND 0.17382f
C627 a_2724_n392# GND 0.17382f
C628 a_2520_n392# GND 0.17382f
C629 a_2316_n392# GND 0.17382f
C630 a_2112_n392# GND 0.17382f
C631 a_1908_n392# GND 0.17671f
C632 a_1566_n392# GND 0.17944f
C633 a_1362_n392# GND 0.17382f
C634 a_1158_n392# GND 0.17382f
C635 a_954_n392# GND 0.17382f
C636 a_750_n392# GND 0.17382f
C637 a_546_n392# GND 0.17382f
C638 a_342_n392# GND 0.17382f
C639 a_138_n392# GND 0.21057f
.ends
