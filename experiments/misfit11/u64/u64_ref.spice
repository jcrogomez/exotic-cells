* Reference for LVS, generated from table 'u64'. Do not edit by hand.
.subckt u64 X VB GND SEL0 SEL1 SEL2 SEL3 SEL4 SEL5 SEL6 SEL7 SEL8 SEL9 SEL10 SEL11 SEL12 SEL13 SEL14 SEL15 SEL16 SEL17 SEL18 SEL19 SEL20 SEL21 SEL22 SEL23 SEL24 SEL25 SEL26 SEL27 SEL28 SEL29 SEL30 SEL31 SEL32 SEL33 SEL34 SEL35 SEL36 SEL37 SEL38 SEL39 SEL40 SEL41 SEL42 SEL43 SEL44 SEL45 SEL46 SEL47 SEL48 SEL49 SEL50 SEL51 SEL52 SEL53 SEL54 SEL55 SEL56 SEL57 SEL58 SEL59 SEL60 SEL61 SEL62 SEL63
XD0 X VB s0 GND sky130_fd_pr__nfet_01v8 w=0.42 l=0.15
XS0 s0 SEL0 GND GND sky130_fd_pr__nfet_01v8 w=0.84 l=0.15
XD1 X VB s1 GND sky130_fd_pr__nfet_01v8 w=0.42 l=0.15
XS1 s1 SEL1 GND GND sky130_fd_pr__nfet_01v8 w=0.84 l=0.15
XD2 X VB s2 GND sky130_fd_pr__nfet_01v8 w=0.42 l=0.15
XS2 s2 SEL2 GND GND sky130_fd_pr__nfet_01v8 w=0.84 l=0.15
XD3 X VB s3 GND sky130_fd_pr__nfet_01v8 w=0.42 l=0.15
XS3 s3 SEL3 GND GND sky130_fd_pr__nfet_01v8 w=0.84 l=0.15
XD4 X VB s4 GND sky130_fd_pr__nfet_01v8 w=0.42 l=0.15
XS4 s4 SEL4 GND GND sky130_fd_pr__nfet_01v8 w=0.84 l=0.15
XD5 X VB s5 GND sky130_fd_pr__nfet_01v8 w=0.42 l=0.15
XS5 s5 SEL5 GND GND sky130_fd_pr__nfet_01v8 w=0.84 l=0.15
XD6 X VB s6 GND sky130_fd_pr__nfet_01v8 w=0.42 l=0.15
XS6 s6 SEL6 GND GND sky130_fd_pr__nfet_01v8 w=0.84 l=0.15
XD7 X VB s7 GND sky130_fd_pr__nfet_01v8 w=0.42 l=0.15
XS7 s7 SEL7 GND GND sky130_fd_pr__nfet_01v8 w=0.84 l=0.15
XD8 X VB s8 GND sky130_fd_pr__nfet_01v8 w=0.42 l=0.15
XS8 s8 SEL8 GND GND sky130_fd_pr__nfet_01v8 w=0.84 l=0.15
XD9 X VB s9 GND sky130_fd_pr__nfet_01v8 w=0.42 l=0.15
XS9 s9 SEL9 GND GND sky130_fd_pr__nfet_01v8 w=0.84 l=0.15
XD10 X VB s10 GND sky130_fd_pr__nfet_01v8 w=0.42 l=0.15
XS10 s10 SEL10 GND GND sky130_fd_pr__nfet_01v8 w=0.84 l=0.15
XD11 X VB s11 GND sky130_fd_pr__nfet_01v8 w=0.42 l=0.15
XS11 s11 SEL11 GND GND sky130_fd_pr__nfet_01v8 w=0.84 l=0.15
XD12 X VB s12 GND sky130_fd_pr__nfet_01v8 w=0.42 l=0.15
XS12 s12 SEL12 GND GND sky130_fd_pr__nfet_01v8 w=0.84 l=0.15
XD13 X VB s13 GND sky130_fd_pr__nfet_01v8 w=0.42 l=0.15
XS13 s13 SEL13 GND GND sky130_fd_pr__nfet_01v8 w=0.84 l=0.15
XD14 X VB s14 GND sky130_fd_pr__nfet_01v8 w=0.42 l=0.15
XS14 s14 SEL14 GND GND sky130_fd_pr__nfet_01v8 w=0.84 l=0.15
XD15 X VB s15 GND sky130_fd_pr__nfet_01v8 w=0.42 l=0.15
XS15 s15 SEL15 GND GND sky130_fd_pr__nfet_01v8 w=0.84 l=0.15
XD16 X VB s16 GND sky130_fd_pr__nfet_01v8 w=0.42 l=0.15
XS16 s16 SEL16 GND GND sky130_fd_pr__nfet_01v8 w=0.84 l=0.15
XD17 X VB s17 GND sky130_fd_pr__nfet_01v8 w=0.42 l=0.15
XS17 s17 SEL17 GND GND sky130_fd_pr__nfet_01v8 w=0.84 l=0.15
XD18 X VB s18 GND sky130_fd_pr__nfet_01v8 w=0.42 l=0.15
XS18 s18 SEL18 GND GND sky130_fd_pr__nfet_01v8 w=0.84 l=0.15
XD19 X VB s19 GND sky130_fd_pr__nfet_01v8 w=0.42 l=0.15
XS19 s19 SEL19 GND GND sky130_fd_pr__nfet_01v8 w=0.84 l=0.15
XD20 X VB s20 GND sky130_fd_pr__nfet_01v8 w=0.42 l=0.15
XS20 s20 SEL20 GND GND sky130_fd_pr__nfet_01v8 w=0.84 l=0.15
XD21 X VB s21 GND sky130_fd_pr__nfet_01v8 w=0.42 l=0.15
XS21 s21 SEL21 GND GND sky130_fd_pr__nfet_01v8 w=0.84 l=0.15
XD22 X VB s22 GND sky130_fd_pr__nfet_01v8 w=0.42 l=0.15
XS22 s22 SEL22 GND GND sky130_fd_pr__nfet_01v8 w=0.84 l=0.15
XD23 X VB s23 GND sky130_fd_pr__nfet_01v8 w=0.42 l=0.15
XS23 s23 SEL23 GND GND sky130_fd_pr__nfet_01v8 w=0.84 l=0.15
XD24 X VB s24 GND sky130_fd_pr__nfet_01v8 w=0.42 l=0.15
XS24 s24 SEL24 GND GND sky130_fd_pr__nfet_01v8 w=0.84 l=0.15
XD25 X VB s25 GND sky130_fd_pr__nfet_01v8 w=0.42 l=0.15
XS25 s25 SEL25 GND GND sky130_fd_pr__nfet_01v8 w=0.84 l=0.15
XD26 X VB s26 GND sky130_fd_pr__nfet_01v8 w=0.42 l=0.15
XS26 s26 SEL26 GND GND sky130_fd_pr__nfet_01v8 w=0.84 l=0.15
XD27 X VB s27 GND sky130_fd_pr__nfet_01v8 w=0.42 l=0.15
XS27 s27 SEL27 GND GND sky130_fd_pr__nfet_01v8 w=0.84 l=0.15
XD28 X VB s28 GND sky130_fd_pr__nfet_01v8 w=0.42 l=0.15
XS28 s28 SEL28 GND GND sky130_fd_pr__nfet_01v8 w=0.84 l=0.15
XD29 X VB s29 GND sky130_fd_pr__nfet_01v8 w=0.42 l=0.15
XS29 s29 SEL29 GND GND sky130_fd_pr__nfet_01v8 w=0.84 l=0.15
XD30 X VB s30 GND sky130_fd_pr__nfet_01v8 w=0.42 l=0.15
XS30 s30 SEL30 GND GND sky130_fd_pr__nfet_01v8 w=0.84 l=0.15
XD31 X VB s31 GND sky130_fd_pr__nfet_01v8 w=0.42 l=0.15
XS31 s31 SEL31 GND GND sky130_fd_pr__nfet_01v8 w=0.84 l=0.15
XD32 X VB s32 GND sky130_fd_pr__nfet_01v8 w=0.42 l=0.15
XS32 s32 SEL32 GND GND sky130_fd_pr__nfet_01v8 w=0.84 l=0.15
XD33 X VB s33 GND sky130_fd_pr__nfet_01v8 w=0.42 l=0.15
XS33 s33 SEL33 GND GND sky130_fd_pr__nfet_01v8 w=0.84 l=0.15
XD34 X VB s34 GND sky130_fd_pr__nfet_01v8 w=0.42 l=0.15
XS34 s34 SEL34 GND GND sky130_fd_pr__nfet_01v8 w=0.84 l=0.15
XD35 X VB s35 GND sky130_fd_pr__nfet_01v8 w=0.42 l=0.15
XS35 s35 SEL35 GND GND sky130_fd_pr__nfet_01v8 w=0.84 l=0.15
XD36 X VB s36 GND sky130_fd_pr__nfet_01v8 w=0.42 l=0.15
XS36 s36 SEL36 GND GND sky130_fd_pr__nfet_01v8 w=0.84 l=0.15
XD37 X VB s37 GND sky130_fd_pr__nfet_01v8 w=0.42 l=0.15
XS37 s37 SEL37 GND GND sky130_fd_pr__nfet_01v8 w=0.84 l=0.15
XD38 X VB s38 GND sky130_fd_pr__nfet_01v8 w=0.42 l=0.15
XS38 s38 SEL38 GND GND sky130_fd_pr__nfet_01v8 w=0.84 l=0.15
XD39 X VB s39 GND sky130_fd_pr__nfet_01v8 w=0.42 l=0.15
XS39 s39 SEL39 GND GND sky130_fd_pr__nfet_01v8 w=0.84 l=0.15
XD40 X VB s40 GND sky130_fd_pr__nfet_01v8 w=0.42 l=0.15
XS40 s40 SEL40 GND GND sky130_fd_pr__nfet_01v8 w=0.84 l=0.15
XD41 X VB s41 GND sky130_fd_pr__nfet_01v8 w=0.42 l=0.15
XS41 s41 SEL41 GND GND sky130_fd_pr__nfet_01v8 w=0.84 l=0.15
XD42 X VB s42 GND sky130_fd_pr__nfet_01v8 w=0.42 l=0.15
XS42 s42 SEL42 GND GND sky130_fd_pr__nfet_01v8 w=0.84 l=0.15
XD43 X VB s43 GND sky130_fd_pr__nfet_01v8 w=0.42 l=0.15
XS43 s43 SEL43 GND GND sky130_fd_pr__nfet_01v8 w=0.84 l=0.15
XD44 X VB s44 GND sky130_fd_pr__nfet_01v8 w=0.42 l=0.15
XS44 s44 SEL44 GND GND sky130_fd_pr__nfet_01v8 w=0.84 l=0.15
XD45 X VB s45 GND sky130_fd_pr__nfet_01v8 w=0.42 l=0.15
XS45 s45 SEL45 GND GND sky130_fd_pr__nfet_01v8 w=0.84 l=0.15
XD46 X VB s46 GND sky130_fd_pr__nfet_01v8 w=0.42 l=0.15
XS46 s46 SEL46 GND GND sky130_fd_pr__nfet_01v8 w=0.84 l=0.15
XD47 X VB s47 GND sky130_fd_pr__nfet_01v8 w=0.42 l=0.15
XS47 s47 SEL47 GND GND sky130_fd_pr__nfet_01v8 w=0.84 l=0.15
XD48 X VB s48 GND sky130_fd_pr__nfet_01v8 w=0.42 l=0.15
XS48 s48 SEL48 GND GND sky130_fd_pr__nfet_01v8 w=0.84 l=0.15
XD49 X VB s49 GND sky130_fd_pr__nfet_01v8 w=0.42 l=0.15
XS49 s49 SEL49 GND GND sky130_fd_pr__nfet_01v8 w=0.84 l=0.15
XD50 X VB s50 GND sky130_fd_pr__nfet_01v8 w=0.42 l=0.15
XS50 s50 SEL50 GND GND sky130_fd_pr__nfet_01v8 w=0.84 l=0.15
XD51 X VB s51 GND sky130_fd_pr__nfet_01v8 w=0.42 l=0.15
XS51 s51 SEL51 GND GND sky130_fd_pr__nfet_01v8 w=0.84 l=0.15
XD52 X VB s52 GND sky130_fd_pr__nfet_01v8 w=0.42 l=0.15
XS52 s52 SEL52 GND GND sky130_fd_pr__nfet_01v8 w=0.84 l=0.15
XD53 X VB s53 GND sky130_fd_pr__nfet_01v8 w=0.42 l=0.15
XS53 s53 SEL53 GND GND sky130_fd_pr__nfet_01v8 w=0.84 l=0.15
XD54 X VB s54 GND sky130_fd_pr__nfet_01v8 w=0.42 l=0.15
XS54 s54 SEL54 GND GND sky130_fd_pr__nfet_01v8 w=0.84 l=0.15
XD55 X VB s55 GND sky130_fd_pr__nfet_01v8 w=0.42 l=0.15
XS55 s55 SEL55 GND GND sky130_fd_pr__nfet_01v8 w=0.84 l=0.15
XD56 X VB s56 GND sky130_fd_pr__nfet_01v8 w=0.42 l=0.15
XS56 s56 SEL56 GND GND sky130_fd_pr__nfet_01v8 w=0.84 l=0.15
XD57 X VB s57 GND sky130_fd_pr__nfet_01v8 w=0.42 l=0.15
XS57 s57 SEL57 GND GND sky130_fd_pr__nfet_01v8 w=0.84 l=0.15
XD58 X VB s58 GND sky130_fd_pr__nfet_01v8 w=0.42 l=0.15
XS58 s58 SEL58 GND GND sky130_fd_pr__nfet_01v8 w=0.84 l=0.15
XD59 X VB s59 GND sky130_fd_pr__nfet_01v8 w=0.42 l=0.15
XS59 s59 SEL59 GND GND sky130_fd_pr__nfet_01v8 w=0.84 l=0.15
XD60 X VB s60 GND sky130_fd_pr__nfet_01v8 w=0.42 l=0.15
XS60 s60 SEL60 GND GND sky130_fd_pr__nfet_01v8 w=0.84 l=0.15
XD61 X VB s61 GND sky130_fd_pr__nfet_01v8 w=0.42 l=0.15
XS61 s61 SEL61 GND GND sky130_fd_pr__nfet_01v8 w=0.84 l=0.15
XD62 X VB s62 GND sky130_fd_pr__nfet_01v8 w=0.42 l=0.15
XS62 s62 SEL62 GND GND sky130_fd_pr__nfet_01v8 w=0.84 l=0.15
XD63 X VB s63 GND sky130_fd_pr__nfet_01v8 w=0.42 l=0.15
XS63 s63 SEL63 GND GND sky130_fd_pr__nfet_01v8 w=0.84 l=0.15
.ends
