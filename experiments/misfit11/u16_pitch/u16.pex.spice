* NGSPICE file created from u16.ext - technology: sky130A

.subckt u16 SEL0 SEL1 SEL2 SEL3 SEL4 SEL5 SEL6 SEL7 SEL8 SEL9 SEL10 SEL11 SEL12 SEL13
+ SEL14 SEL15 X VB GND
X0 X VB a_1426_n392# GND sky130_fd_pr__nfet_01v8 ad=0.126 pd=1.44 as=0.126 ps=1.44 w=0.42 l=0.15
X1 GND SEL7 a_1426_n392# GND sky130_fd_pr__nfet_01v8 ad=0.252 pd=2.28 as=0.252 ps=2.28 w=0.84 l=0.15
X2 X VB a_690_n392# GND sky130_fd_pr__nfet_01v8 ad=0.126 pd=1.44 as=0.126 ps=1.44 w=0.42 l=0.15
X3 X VB a_1932_n392# GND sky130_fd_pr__nfet_01v8 ad=0.126 pd=1.44 as=0.126 ps=1.44 w=0.42 l=0.15
X4 X VB a_1058_n392# GND sky130_fd_pr__nfet_01v8 ad=0.126 pd=1.44 as=0.126 ps=1.44 w=0.42 l=0.15
X5 X VB a_2852_n392# GND sky130_fd_pr__nfet_01v8 ad=0.126 pd=1.44 as=0.126 ps=1.44 w=0.42 l=0.15
X6 GND SEL3 a_690_n392# GND sky130_fd_pr__nfet_01v8 ad=0.252 pd=2.28 as=0.252 ps=2.28 w=0.84 l=0.15
X7 X VB a_874_n392# GND sky130_fd_pr__nfet_01v8 ad=0.126 pd=1.44 as=0.126 ps=1.44 w=0.42 l=0.15
X8 X VB a_2116_n392# GND sky130_fd_pr__nfet_01v8 ad=0.126 pd=1.44 as=0.126 ps=1.44 w=0.42 l=0.15
X9 GND SEL4 a_874_n392# GND sky130_fd_pr__nfet_01v8 ad=0.252 pd=2.28 as=0.252 ps=2.28 w=0.84 l=0.15
X10 GND SEL11 a_2300_n392# GND sky130_fd_pr__nfet_01v8 ad=0.252 pd=2.28 as=0.252 ps=2.28 w=0.84 l=0.15
X11 GND SEL5 a_1058_n392# GND sky130_fd_pr__nfet_01v8 ad=0.252 pd=2.28 as=0.252 ps=2.28 w=0.84 l=0.15
X12 X VB a_1242_n392# GND sky130_fd_pr__nfet_01v8 ad=0.126 pd=1.44 as=0.126 ps=1.44 w=0.42 l=0.15
X13 X VB a_138_n392# GND sky130_fd_pr__nfet_01v8 ad=0.126 pd=1.44 as=0.126 ps=1.44 w=0.42 l=0.15
X14 GND SEL0 a_138_n392# GND sky130_fd_pr__nfet_01v8 ad=0.252 pd=2.28 as=0.252 ps=2.28 w=0.84 l=0.15
X15 GND SEL12 a_2484_n392# GND sky130_fd_pr__nfet_01v8 ad=0.252 pd=2.28 as=0.252 ps=2.28 w=0.84 l=0.15
X16 X VB a_1748_n392# GND sky130_fd_pr__nfet_01v8 ad=0.126 pd=1.44 as=0.126 ps=1.44 w=0.42 l=0.15
X17 GND SEL13 a_2668_n392# GND sky130_fd_pr__nfet_01v8 ad=0.252 pd=2.28 as=0.252 ps=2.28 w=0.84 l=0.15
X18 X VB a_2300_n392# GND sky130_fd_pr__nfet_01v8 ad=0.126 pd=1.44 as=0.126 ps=1.44 w=0.42 l=0.15
X19 GND SEL9 a_1932_n392# GND sky130_fd_pr__nfet_01v8 ad=0.252 pd=2.28 as=0.252 ps=2.28 w=0.84 l=0.15
X20 GND SEL15 a_3036_n392# GND sky130_fd_pr__nfet_01v8 ad=0.252 pd=2.28 as=0.252 ps=2.28 w=0.84 l=0.15
X21 X VB a_322_n392# GND sky130_fd_pr__nfet_01v8 ad=0.126 pd=1.44 as=0.126 ps=1.44 w=0.42 l=0.15
X22 GND SEL6 a_1242_n392# GND sky130_fd_pr__nfet_01v8 ad=0.252 pd=2.28 as=0.252 ps=2.28 w=0.84 l=0.15
X23 X VB a_2484_n392# GND sky130_fd_pr__nfet_01v8 ad=0.126 pd=1.44 as=0.126 ps=1.44 w=0.42 l=0.15
X24 GND SEL1 a_322_n392# GND sky130_fd_pr__nfet_01v8 ad=0.252 pd=2.28 as=0.252 ps=2.28 w=0.84 l=0.15
X25 X VB a_3036_n392# GND sky130_fd_pr__nfet_01v8 ad=0.126 pd=1.44 as=0.126 ps=1.44 w=0.42 l=0.15
X26 X VB a_506_n392# GND sky130_fd_pr__nfet_01v8 ad=0.126 pd=1.44 as=0.126 ps=1.44 w=0.42 l=0.15
X27 GND SEL2 a_506_n392# GND sky130_fd_pr__nfet_01v8 ad=0.252 pd=2.28 as=0.252 ps=2.28 w=0.84 l=0.15
X28 GND SEL14 a_2852_n392# GND sky130_fd_pr__nfet_01v8 ad=0.252 pd=2.28 as=0.252 ps=2.28 w=0.84 l=0.15
X29 X VB a_2668_n392# GND sky130_fd_pr__nfet_01v8 ad=0.126 pd=1.44 as=0.126 ps=1.44 w=0.42 l=0.15
X30 GND SEL8 a_1748_n392# GND sky130_fd_pr__nfet_01v8 ad=0.252 pd=2.28 as=0.252 ps=2.28 w=0.84 l=0.15
X31 GND SEL10 a_2116_n392# GND sky130_fd_pr__nfet_01v8 ad=0.252 pd=2.28 as=0.252 ps=2.28 w=0.84 l=0.15
C0 a_2300_n392# SEL10 0
C1 VB SEL2 0.01474f
C2 SEL3 a_874_n392# 0
C3 SEL2 X 0
C4 VB SEL10 0.01474f
C5 SEL1 a_506_n392# 0
C6 SEL10 X 0
C7 a_1426_n392# a_1748_n392# 0.0121f
C8 VB a_138_n392# 0.06461f
C9 a_2668_n392# SEL13 0.0031f
C10 a_138_n392# X 0.03199f
C11 a_2852_n392# a_3036_n392# 0.02149f
C12 a_1426_n392# a_1242_n392# 0.02149f
C13 a_2668_n392# a_2484_n392# 0.02149f
C14 VB a_2668_n392# 0.08264f
C15 a_2668_n392# X 0.06235f
C16 VB SEL7 0.01474f
C17 SEL7 X 0
C18 SEL0 a_138_n392# 0.0031f
C19 SEL3 SEL4 0.10797f
C20 SEL1 VB 0.01474f
C21 SEL1 X 0
C22 SEL9 a_2116_n392# 0
C23 VB a_506_n392# 0.08264f
C24 a_506_n392# X 0.06235f
C25 a_1426_n392# SEL6 0
C26 SEL7 SEL8 0.05737f
C27 SEL10 SEL11 0.10797f
C28 SEL3 a_690_n392# 0.0031f
C29 a_2300_n392# a_2484_n392# 0.02149f
C30 SEL1 SEL0 0.10797f
C31 a_2300_n392# VB 0.08264f
C32 a_2300_n392# X 0.06235f
C33 VB SEL13 0.01474f
C34 SEL13 X 0
C35 a_1748_n392# SEL7 0
C36 VB a_2484_n392# 0.08264f
C37 a_2484_n392# X 0.06235f
C38 a_1932_n392# VB 0.08264f
C39 SEL14 SEL13 0.10797f
C40 VB X 0.81627f
C41 a_1932_n392# X 0.06235f
C42 SEL14 VB 0.01474f
C43 SEL14 X 0
C44 VB SEL5 0.01474f
C45 VB SEL8 0.01474f
C46 a_1932_n392# SEL8 0
C47 X SEL5 0
C48 SEL8 X 0
C49 SEL2 a_690_n392# 0
C50 SEL0 VB 0.01474f
C51 SEL0 X 0
C52 SEL9 SEL10 0.10797f
C53 SEL7 SEL6 0.10797f
C54 a_2300_n392# SEL11 0.0031f
C55 SEL3 SEL2 0.10797f
C56 a_1748_n392# VB 0.0738f
C57 a_874_n392# VB 0.08264f
C58 a_1748_n392# a_1932_n392# 0.02149f
C59 a_1748_n392# X 0.043f
C60 a_874_n392# X 0.06235f
C61 a_2484_n392# SEL11 0
C62 a_2668_n392# SEL12 0
C63 VB SEL11 0.01474f
C64 a_1242_n392# VB 0.08264f
C65 a_2116_n392# SEL10 0.0031f
C66 SEL11 X 0
C67 a_1242_n392# X 0.06235f
C68 a_322_n392# a_138_n392# 0.02149f
C69 a_1058_n392# VB 0.08264f
C70 a_1058_n392# X 0.06235f
C71 a_1748_n392# SEL8 0.0031f
C72 a_1242_n392# SEL5 0
C73 VB SEL15 0.01474f
C74 VB a_3036_n392# 0.08278f
C75 a_2852_n392# a_2668_n392# 0.02149f
C76 SEL15 X 0
C77 a_1058_n392# SEL5 0.0031f
C78 a_3036_n392# X 0.06235f
C79 VB SEL6 0.01474f
C80 a_690_n392# a_506_n392# 0.02149f
C81 X SEL6 0
C82 SEL1 a_322_n392# 0.0031f
C83 SEL14 SEL15 0.10797f
C84 SEL14 a_3036_n392# 0
C85 a_322_n392# a_506_n392# 0.02149f
C86 VB SEL4 0.01474f
C87 SEL13 SEL12 0.10797f
C88 X SEL4 0
C89 SEL6 SEL5 0.10797f
C90 a_1058_n392# a_874_n392# 0.02149f
C91 a_2484_n392# SEL12 0.0031f
C92 SEL9 VB 0.01474f
C93 SEL9 a_1932_n392# 0.0031f
C94 VB SEL12 0.01474f
C95 SEL9 X 0
C96 SEL12 X 0
C97 a_1058_n392# a_1242_n392# 0.02149f
C98 a_1426_n392# SEL7 0.0031f
C99 SEL5 SEL4 0.10797f
C100 a_2300_n392# a_2116_n392# 0.02149f
C101 VB a_690_n392# 0.08264f
C102 a_690_n392# X 0.06235f
C103 a_2852_n392# SEL13 0
C104 VB a_322_n392# 0.08264f
C105 SEL9 SEL8 0.10797f
C106 a_322_n392# X 0.06235f
C107 VB a_2116_n392# 0.08264f
C108 a_1932_n392# a_2116_n392# 0.02149f
C109 a_1242_n392# SEL6 0.0031f
C110 a_2116_n392# X 0.06235f
C111 a_2852_n392# VB 0.08264f
C112 a_2852_n392# X 0.06235f
C113 SEL3 VB 0.01474f
C114 a_874_n392# SEL4 0.0031f
C115 SEL3 X 0
C116 SEL1 SEL2 0.10797f
C117 SEL2 a_506_n392# 0.0031f
C118 a_2852_n392# SEL14 0.0031f
C119 SEL0 a_322_n392# 0
C120 a_3036_n392# SEL15 0.0031f
C121 a_1058_n392# SEL4 0
C122 SEL12 SEL11 0.10797f
C123 a_1426_n392# VB 0.08285f
C124 a_874_n392# a_690_n392# 0.02149f
C125 a_1426_n392# X 0.06235f
C126 SEL15 GND 0.31099f
C127 SEL14 GND 0.23913f
C128 SEL13 GND 0.23913f
C129 SEL12 GND 0.23913f
C130 SEL11 GND 0.23913f
C131 SEL10 GND 0.23913f
C132 SEL9 GND 0.23913f
C133 SEL8 GND 0.2578f
C134 SEL7 GND 0.25788f
C135 SEL6 GND 0.23913f
C136 SEL5 GND 0.23913f
C137 SEL4 GND 0.23913f
C138 SEL3 GND 0.23913f
C139 SEL2 GND 0.23913f
C140 SEL1 GND 0.23913f
C141 SEL0 GND 0.31087f
C142 X GND 1.55815f
C143 VB GND 3.26051f
C144 a_3036_n392# GND 0.20104f
C145 a_2852_n392# GND 0.18036f
C146 a_2668_n392# GND 0.18036f
C147 a_2484_n392# GND 0.18036f
C148 a_2300_n392# GND 0.18036f
C149 a_2116_n392# GND 0.18036f
C150 a_1932_n392# GND 0.18036f
C151 a_1748_n392# GND 0.17431f
C152 a_1426_n392# GND 0.18639f
C153 a_1242_n392# GND 0.18036f
C154 a_1058_n392# GND 0.18036f
C155 a_874_n392# GND 0.18036f
C156 a_690_n392# GND 0.18036f
C157 a_506_n392# GND 0.18036f
C158 a_322_n392# GND 0.18036f
C159 a_138_n392# GND 0.20951f
.ends
