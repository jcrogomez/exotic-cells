* NGSPICE file created from u1.ext - technology: sky130A

.subckt u1 SEL0 X VB GND
X0 X VB a_138_n392# GND sky130_fd_pr__nfet_01v8 ad=0.126 pd=1.44 as=0.126 ps=1.44 w=0.42 l=0.15
X1 GND SEL0 a_138_n392# GND sky130_fd_pr__nfet_01v8 ad=0.252 pd=2.28 as=0.252 ps=2.28 w=0.84 l=0.15
C0 VB a_138_n392# 0.06477f
C1 X a_138_n392# 0.03199f
C2 SEL0 a_138_n392# 0.0031f
C3 VB X 0.08633f
C4 VB SEL0 0.01474f
C5 X SEL0 0
C6 SEL0 GND 0.38273f
C7 X GND 0.24283f
C8 VB GND 0.35083f
C9 a_138_n392# GND 0.23019f
.ends
