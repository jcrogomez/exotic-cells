* NGSPICE file created from lod12.ext - technology: sky130A

.subckt lod12 SEL0 SEL1 SEL2 SEL3 SEL4 SEL5 SEL6 SEL7 SEL8 SEL9 SEL10 SEL11 X VB GND
X0 GND SEL10 a_6330_n392# GND sky130_fd_pr__nfet_01v8 ad=0.252 pd=2.28 as=0.252 ps=2.28 w=0.84 l=0.15
X1 X VB a_342_n392# GND sky130_fd_pr__nfet_01v8 ad=0.126 pd=1.44 as=0.126 ps=1.44 w=0.42 l=0.15
X2 X VB a_546_n392# GND sky130_fd_pr__nfet_01v8 ad=0.189 pd=1.74 as=0.189 ps=1.74 w=0.42 l=0.15
X3 X VB a_1212_n392# GND sky130_fd_pr__nfet_01v8 ad=0.315 pd=2.34 as=0.315 ps=2.34 w=0.42 l=0.15
X4 X VB a_1980_n392# GND sky130_fd_pr__nfet_01v8 ad=0.63 pd=3.84 as=0.63 ps=3.84 w=0.42 l=0.15
X5 GND SEL3 a_810_n392# GND sky130_fd_pr__nfet_01v8 ad=0.252 pd=2.28 as=0.252 ps=2.28 w=0.84 l=0.15
X6 X VB a_138_n392# GND sky130_fd_pr__nfet_01v8 ad=0.126 pd=1.44 as=0.126 ps=1.44 w=0.42 l=0.15
X7 GND SEL0 a_138_n392# GND sky130_fd_pr__nfet_01v8 ad=0.252 pd=2.28 as=0.252 ps=2.28 w=0.84 l=0.15
X8 GND SEL2 a_546_n392# GND sky130_fd_pr__nfet_01v8 ad=0.252 pd=2.28 as=0.252 ps=2.28 w=0.84 l=0.15
X9 GND SEL11 a_8952_n392# GND sky130_fd_pr__nfet_01v8 ad=0.252 pd=2.28 as=0.252 ps=2.28 w=0.84 l=0.15
X10 X VB a_8952_n392# GND sky130_fd_pr__nfet_01v8 ad=2.52 pd=12.84 as=2.52 ps=12.84 w=0.42 l=0.15
X11 GND SEL5 a_1596_n392# GND sky130_fd_pr__nfet_01v8 ad=0.252 pd=2.28 as=0.252 ps=2.28 w=0.84 l=0.15
X12 X VB a_2802_n392# GND sky130_fd_pr__nfet_01v8 ad=0.63 pd=3.84 as=0.63 ps=3.84 w=0.42 l=0.15
X13 X VB a_3486_n392# GND sky130_fd_pr__nfet_01v8 ad=1.26 pd=6.84 as=1.26 ps=6.84 w=0.42 l=0.15
X14 X VB a_810_n392# GND sky130_fd_pr__nfet_01v8 ad=0.189 pd=1.74 as=0.189 ps=1.74 w=0.42 l=0.15
X15 GND SEL7 a_2802_n392# GND sky130_fd_pr__nfet_01v8 ad=0.252 pd=2.28 as=0.252 ps=2.28 w=0.84 l=0.15
X16 GND SEL9 a_4908_n392# GND sky130_fd_pr__nfet_01v8 ad=0.252 pd=2.28 as=0.252 ps=2.28 w=0.84 l=0.15
X17 GND SEL6 a_1980_n392# GND sky130_fd_pr__nfet_01v8 ad=0.252 pd=2.28 as=0.252 ps=2.28 w=0.84 l=0.15
X18 X VB a_1596_n392# GND sky130_fd_pr__nfet_01v8 ad=0.315 pd=2.34 as=0.315 ps=2.34 w=0.42 l=0.15
X19 X VB a_6330_n392# GND sky130_fd_pr__nfet_01v8 ad=2.52 pd=12.84 as=2.52 ps=12.84 w=0.42 l=0.15
X20 GND SEL8 a_3486_n392# GND sky130_fd_pr__nfet_01v8 ad=0.252 pd=2.28 as=0.252 ps=2.28 w=0.84 l=0.15
X21 GND SEL4 a_1212_n392# GND sky130_fd_pr__nfet_01v8 ad=0.252 pd=2.28 as=0.252 ps=2.28 w=0.84 l=0.15
X22 X VB a_4908_n392# GND sky130_fd_pr__nfet_01v8 ad=1.26 pd=6.84 as=1.26 ps=6.84 w=0.42 l=0.15
X23 GND SEL1 a_342_n392# GND sky130_fd_pr__nfet_01v8 ad=0.252 pd=2.28 as=0.252 ps=2.28 w=0.84 l=0.15
C0 SEL4 SEL5 0.04741f
C1 a_2802_n392# SEL7 0.00409f
C2 X a_2802_n392# 0.0305f
C3 X a_546_n392# 0.04826f
C4 a_6330_n392# SEL9 0
C5 a_342_n392# VB 0.08024f
C6 SEL2 SEL3 0.07141f
C7 SEL8 SEL7 0.02578f
C8 a_810_n392# SEL3 0.00351f
C9 a_1596_n392# a_1980_n392# 0.01012f
C10 SEL8 X 0
C11 a_3486_n392# VB 0.06441f
C12 a_4908_n392# VB 0.06229f
C13 X SEL7 0
C14 SEL0 VB 0.01474f
C15 SEL2 VB 0.00546f
C16 a_810_n392# VB 0.07044f
C17 a_342_n392# a_546_n392# 0.01932f
C18 a_1596_n392# VB 0.06142f
C19 SEL9 SEL10 0.01216f
C20 a_2802_n392# a_3486_n392# 0.00564f
C21 SEL6 a_1980_n392# 0.00409f
C22 a_1212_n392# SEL3 0
C23 SEL2 a_546_n392# 0.00351f
C24 a_546_n392# a_810_n392# 0.01483f
C25 a_6330_n392# VB 0.08121f
C26 SEL4 SEL3 0.04514f
C27 SEL1 VB 0.01474f
C28 SEL8 a_3486_n392# 0.00409f
C29 a_8952_n392# VB 0.08051f
C30 SEL6 VB 0.00233f
C31 SEL8 a_4908_n392# 0
C32 X a_342_n392# 0.0562f
C33 a_1212_n392# VB 0.05939f
C34 a_8952_n392# SEL11 0.00409f
C35 a_3486_n392# SEL7 0
C36 SEL4 VB 0.00233f
C37 X a_3486_n392# 0.05223f
C38 SEL5 a_1980_n392# 0
C39 X a_4908_n392# 0.0381f
C40 a_546_n392# SEL1 0
C41 SEL0 X 0
C42 X SEL2 0
C43 X a_810_n392# 0.04826f
C44 SEL6 a_2802_n392# 0
C45 X a_1596_n392# 0.04423f
C46 VB SEL10 0.00233f
C47 SEL5 VB 0.00233f
C48 a_6330_n392# X 0.05612f
C49 X SEL1 0
C50 a_8952_n392# X 0.05612f
C51 SEL6 SEL7 0.02131f
C52 SEL0 a_342_n392# 0
C53 X SEL6 0
C54 a_1212_n392# X 0.0301f
C55 a_3486_n392# a_4908_n392# 0.0027f
C56 a_138_n392# VB 0.06465f
C57 X SEL4 0
C58 SEL9 VB 0.00233f
C59 SEL2 a_810_n392# 0
C60 X SEL10 0
C61 a_342_n392# SEL1 0.0031f
C62 X SEL5 0
C63 a_6330_n392# a_4908_n392# 0.0027f
C64 a_1980_n392# VB 0.06011f
C65 SEL0 SEL1 0.09569f
C66 SEL2 SEL1 0.09569f
C67 SEL3 VB 0.00546f
C68 SEL8 SEL9 0.01216f
C69 a_1212_n392# a_810_n392# 0.00966f
C70 a_1212_n392# a_1596_n392# 0.01012f
C71 X a_138_n392# 0.03199f
C72 a_2802_n392# a_1980_n392# 0.00469f
C73 X SEL9 0
C74 a_1596_n392# SEL4 0
C75 VB SEL11 0.00233f
C76 a_2802_n392# VB 0.05597f
C77 a_546_n392# VB 0.07283f
C78 a_1596_n392# SEL5 0.00409f
C79 X a_1980_n392# 0.04463f
C80 a_342_n392# a_138_n392# 0.01932f
C81 a_1212_n392# SEL4 0.00409f
C82 X SEL3 0
C83 a_6330_n392# SEL10 0.00409f
C84 SEL8 VB 0.00233f
C85 SEL9 a_4908_n392# 0.00409f
C86 SEL7 VB 0.00233f
C87 SEL0 a_138_n392# 0.0031f
C88 X VB 2.1776f
C89 SEL5 SEL6 0.04741f
C90 X SEL11 0
C91 SEL11 GND 0.39259f
C92 SEL10 GND 0.37685f
C93 SEL9 GND 0.36111f
C94 SEL8 GND 0.34604f
C95 SEL7 GND 0.33549f
C96 SEL6 GND 0.31881f
C97 SEL5 GND 0.29758f
C98 SEL4 GND 0.29901f
C99 SEL3 GND 0.28409f
C100 SEL2 GND 0.26193f
C101 SEL1 GND 0.24626f
C102 SEL0 GND 0.31444f
C103 X GND 4.1695f
C104 VB GND 6.13614f
C105 a_8952_n392# GND 0.24223f
C106 a_6330_n392# GND 0.23657f
C107 a_4908_n392# GND 0.22825f
C108 a_3486_n392# GND 0.20868f
C109 a_2802_n392# GND 0.21412f
C110 a_1980_n392# GND 0.1927f
C111 a_1596_n392# GND 0.17949f
C112 a_1212_n392# GND 0.19328f
C113 a_810_n392# GND 0.17455f
C114 a_546_n392# GND 0.17931f
C115 a_342_n392# GND 0.17382f
C116 a_138_n392# GND 0.21057f
.ends
