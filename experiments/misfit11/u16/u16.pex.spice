* NGSPICE file created from u16.ext - technology: sky130A

.subckt u16 SEL0 SEL1 SEL2 SEL3 SEL4 SEL5 SEL6 SEL7 SEL8 SEL9 SEL10 SEL11 SEL12 SEL13
+ SEL14 SEL15 X VB GND
X0 GND SEL9 a_2112_n392# GND sky130_fd_pr__nfet_01v8 ad=0.252 pd=2.28 as=0.252 ps=2.28 w=0.84 l=0.15
X1 X VB a_2928_n392# GND sky130_fd_pr__nfet_01v8 ad=0.126 pd=1.44 as=0.126 ps=1.44 w=0.42 l=0.15
X2 X VB a_342_n392# GND sky130_fd_pr__nfet_01v8 ad=0.126 pd=1.44 as=0.126 ps=1.44 w=0.42 l=0.15
X3 GND SEL5 a_1158_n392# GND sky130_fd_pr__nfet_01v8 ad=0.252 pd=2.28 as=0.252 ps=2.28 w=0.84 l=0.15
X4 GND SEL3 a_750_n392# GND sky130_fd_pr__nfet_01v8 ad=0.252 pd=2.28 as=0.252 ps=2.28 w=0.84 l=0.15
X5 X VB a_954_n392# GND sky130_fd_pr__nfet_01v8 ad=0.126 pd=1.44 as=0.126 ps=1.44 w=0.42 l=0.15
X6 X VB a_3132_n392# GND sky130_fd_pr__nfet_01v8 ad=0.126 pd=1.44 as=0.126 ps=1.44 w=0.42 l=0.15
X7 X VB a_546_n392# GND sky130_fd_pr__nfet_01v8 ad=0.126 pd=1.44 as=0.126 ps=1.44 w=0.42 l=0.15
X8 GND SEL13 a_2928_n392# GND sky130_fd_pr__nfet_01v8 ad=0.252 pd=2.28 as=0.252 ps=2.28 w=0.84 l=0.15
X9 GND SEL11 a_2520_n392# GND sky130_fd_pr__nfet_01v8 ad=0.252 pd=2.28 as=0.252 ps=2.28 w=0.84 l=0.15
X10 X VB a_1158_n392# GND sky130_fd_pr__nfet_01v8 ad=0.126 pd=1.44 as=0.126 ps=1.44 w=0.42 l=0.15
X11 X VB a_3336_n392# GND sky130_fd_pr__nfet_01v8 ad=0.126 pd=1.44 as=0.126 ps=1.44 w=0.42 l=0.15
X12 GND SEL14 a_3132_n392# GND sky130_fd_pr__nfet_01v8 ad=0.252 pd=2.28 as=0.252 ps=2.28 w=0.84 l=0.15
X13 GND SEL7 a_1566_n392# GND sky130_fd_pr__nfet_01v8 ad=0.252 pd=2.28 as=0.252 ps=2.28 w=0.84 l=0.15
X14 X VB a_1908_n392# GND sky130_fd_pr__nfet_01v8 ad=0.126 pd=1.44 as=0.126 ps=1.44 w=0.42 l=0.15
X15 X VB a_138_n392# GND sky130_fd_pr__nfet_01v8 ad=0.126 pd=1.44 as=0.126 ps=1.44 w=0.42 l=0.15
X16 X VB a_750_n392# GND sky130_fd_pr__nfet_01v8 ad=0.126 pd=1.44 as=0.126 ps=1.44 w=0.42 l=0.15
X17 GND SEL0 a_138_n392# GND sky130_fd_pr__nfet_01v8 ad=0.252 pd=2.28 as=0.252 ps=2.28 w=0.84 l=0.15
X18 GND SEL2 a_546_n392# GND sky130_fd_pr__nfet_01v8 ad=0.252 pd=2.28 as=0.252 ps=2.28 w=0.84 l=0.15
X19 X VB a_1362_n392# GND sky130_fd_pr__nfet_01v8 ad=0.126 pd=1.44 as=0.126 ps=1.44 w=0.42 l=0.15
X20 GND SEL10 a_2316_n392# GND sky130_fd_pr__nfet_01v8 ad=0.252 pd=2.28 as=0.252 ps=2.28 w=0.84 l=0.15
X21 X VB a_2112_n392# GND sky130_fd_pr__nfet_01v8 ad=0.126 pd=1.44 as=0.126 ps=1.44 w=0.42 l=0.15
X22 X VB a_1566_n392# GND sky130_fd_pr__nfet_01v8 ad=0.126 pd=1.44 as=0.126 ps=1.44 w=0.42 l=0.15
X23 GND SEL4 a_954_n392# GND sky130_fd_pr__nfet_01v8 ad=0.252 pd=2.28 as=0.252 ps=2.28 w=0.84 l=0.15
X24 X VB a_2316_n392# GND sky130_fd_pr__nfet_01v8 ad=0.126 pd=1.44 as=0.126 ps=1.44 w=0.42 l=0.15
X25 GND SEL12 a_2724_n392# GND sky130_fd_pr__nfet_01v8 ad=0.252 pd=2.28 as=0.252 ps=2.28 w=0.84 l=0.15
X26 X VB a_2520_n392# GND sky130_fd_pr__nfet_01v8 ad=0.126 pd=1.44 as=0.126 ps=1.44 w=0.42 l=0.15
X27 GND SEL15 a_3336_n392# GND sky130_fd_pr__nfet_01v8 ad=0.252 pd=2.28 as=0.252 ps=2.28 w=0.84 l=0.15
X28 GND SEL6 a_1362_n392# GND sky130_fd_pr__nfet_01v8 ad=0.252 pd=2.28 as=0.252 ps=2.28 w=0.84 l=0.15
X29 GND SEL1 a_342_n392# GND sky130_fd_pr__nfet_01v8 ad=0.252 pd=2.28 as=0.252 ps=2.28 w=0.84 l=0.15
X30 GND SEL8 a_1908_n392# GND sky130_fd_pr__nfet_01v8 ad=0.252 pd=2.28 as=0.252 ps=2.28 w=0.84 l=0.15
X31 X VB a_2724_n392# GND sky130_fd_pr__nfet_01v8 ad=0.126 pd=1.44 as=0.126 ps=1.44 w=0.42 l=0.15
C0 SEL9 X 0
C1 SEL12 X 0
C2 a_1158_n392# a_1362_n392# 0.01932f
C3 a_1566_n392# SEL7 0.0031f
C4 SEL5 SEL4 0.09569f
C5 a_2520_n392# a_2316_n392# 0.01932f
C6 VB a_750_n392# 0.08024f
C7 a_750_n392# X 0.0562f
C8 a_3132_n392# SEL13 0
C9 VB a_342_n392# 0.08024f
C10 SEL9 SEL8 0.09569f
C11 a_342_n392# X 0.0562f
C12 VB a_2316_n392# 0.08024f
C13 a_2112_n392# a_2316_n392# 0.01932f
C14 a_1362_n392# SEL6 0.0031f
C15 a_2316_n392# X 0.0562f
C16 a_3132_n392# VB 0.08024f
C17 a_3132_n392# X 0.0562f
C18 SEL3 VB 0.01474f
C19 a_954_n392# SEL4 0.0031f
C20 SEL3 X 0
C21 SEL1 SEL2 0.09569f
C22 SEL2 a_546_n392# 0.0031f
C23 a_3132_n392# SEL14 0.0031f
C24 SEL0 a_342_n392# 0
C25 a_3336_n392# SEL15 0.0031f
C26 a_1158_n392# SEL4 0
C27 SEL12 SEL11 0.09569f
C28 a_1566_n392# VB 0.08041f
C29 a_954_n392# a_750_n392# 0.01932f
C30 a_1566_n392# X 0.0562f
C31 VB SEL2 0.01474f
C32 a_2520_n392# SEL10 0
C33 SEL3 a_954_n392# 0
C34 SEL2 X 0
C35 VB SEL10 0.01474f
C36 SEL1 a_546_n392# 0
C37 SEL10 X 0
C38 a_1566_n392# a_1908_n392# 0.01138f
C39 VB a_138_n392# 0.06465f
C40 a_2928_n392# SEL13 0.0031f
C41 a_138_n392# X 0.03199f
C42 a_3132_n392# a_3336_n392# 0.01932f
C43 a_1566_n392# a_1362_n392# 0.01932f
C44 a_2928_n392# a_2724_n392# 0.01932f
C45 VB a_2928_n392# 0.08024f
C46 a_2928_n392# X 0.0562f
C47 VB SEL7 0.01474f
C48 SEL7 X 0
C49 SEL0 a_138_n392# 0.0031f
C50 SEL3 SEL4 0.09569f
C51 SEL1 VB 0.01474f
C52 SEL1 X 0
C53 SEL9 a_2316_n392# 0
C54 VB a_546_n392# 0.08024f
C55 a_546_n392# X 0.0562f
C56 a_1566_n392# SEL6 0
C57 SEL7 SEL8 0.05373f
C58 SEL10 SEL11 0.09569f
C59 SEL3 a_750_n392# 0.0031f
C60 a_2520_n392# a_2724_n392# 0.01932f
C61 SEL1 SEL0 0.09569f
C62 a_2520_n392# VB 0.08024f
C63 a_2520_n392# X 0.0562f
C64 VB SEL13 0.01474f
C65 SEL13 X 0
C66 a_1908_n392# SEL7 0
C67 VB a_2724_n392# 0.08024f
C68 a_2724_n392# X 0.0562f
C69 a_2112_n392# VB 0.08024f
C70 SEL14 SEL13 0.09569f
C71 VB X 0.86687f
C72 a_2112_n392# X 0.0562f
C73 SEL14 VB 0.01474f
C74 SEL14 X 0
C75 VB SEL5 0.01474f
C76 VB SEL8 0.01474f
C77 a_2112_n392# SEL8 0
C78 X SEL5 0
C79 SEL8 X 0
C80 SEL2 a_750_n392# 0
C81 SEL0 VB 0.01474f
C82 SEL9 SEL10 0.09569f
C83 SEL0 X 0
C84 SEL7 SEL6 0.09569f
C85 a_2520_n392# SEL11 0.0031f
C86 SEL3 SEL2 0.09569f
C87 a_1908_n392# VB 0.07335f
C88 a_954_n392# VB 0.08024f
C89 a_1908_n392# a_2112_n392# 0.01932f
C90 a_1908_n392# X 0.04207f
C91 a_954_n392# X 0.0562f
C92 a_2724_n392# SEL11 0
C93 a_2928_n392# SEL12 0
C94 VB SEL11 0.01474f
C95 a_1362_n392# VB 0.08024f
C96 a_2316_n392# SEL10 0.0031f
C97 a_1362_n392# X 0.0562f
C98 SEL11 X 0
C99 a_342_n392# a_138_n392# 0.01932f
C100 a_1158_n392# VB 0.08024f
C101 a_1158_n392# X 0.0562f
C102 a_1908_n392# SEL8 0.0031f
C103 a_1362_n392# SEL5 0
C104 VB SEL15 0.01474f
C105 VB a_3336_n392# 0.08036f
C106 a_3132_n392# a_2928_n392# 0.01932f
C107 SEL15 X 0
C108 a_1158_n392# SEL5 0.0031f
C109 a_3336_n392# X 0.0562f
C110 VB SEL6 0.01474f
C111 a_750_n392# a_546_n392# 0.01932f
C112 X SEL6 0
C113 SEL1 a_342_n392# 0.0031f
C114 SEL14 SEL15 0.09569f
C115 SEL14 a_3336_n392# 0
C116 a_342_n392# a_546_n392# 0.01932f
C117 VB SEL4 0.01474f
C118 SEL13 SEL12 0.09569f
C119 X SEL4 0
C120 SEL6 SEL5 0.09569f
C121 a_1158_n392# a_954_n392# 0.01932f
C122 a_2724_n392# SEL12 0.0031f
C123 SEL9 VB 0.01474f
C124 SEL9 a_2112_n392# 0.0031f
C125 VB SEL12 0.01474f
C126 SEL15 GND 0.31454f
C127 SEL14 GND 0.24626f
C128 SEL13 GND 0.24626f
C129 SEL12 GND 0.24626f
C130 SEL11 GND 0.24626f
C131 SEL10 GND 0.24626f
C132 SEL9 GND 0.24626f
C133 SEL8 GND 0.26331f
C134 SEL7 GND 0.26337f
C135 SEL6 GND 0.24626f
C136 SEL5 GND 0.24626f
C137 SEL4 GND 0.24626f
C138 SEL3 GND 0.24626f
C139 SEL2 GND 0.24626f
C140 SEL1 GND 0.24626f
C141 SEL0 GND 0.31444f
C142 X GND 1.69602f
C143 VB GND 3.43823f
C144 a_3336_n392# GND 0.19344f
C145 a_3132_n392# GND 0.17382f
C146 a_2928_n392# GND 0.17382f
C147 a_2724_n392# GND 0.17382f
C148 a_2520_n392# GND 0.17382f
C149 a_2316_n392# GND 0.17382f
C150 a_2112_n392# GND 0.17382f
C151 a_1908_n392# GND 0.17671f
C152 a_1566_n392# GND 0.17944f
C153 a_1362_n392# GND 0.17382f
C154 a_1158_n392# GND 0.17382f
C155 a_954_n392# GND 0.17382f
C156 a_750_n392# GND 0.17382f
C157 a_546_n392# GND 0.17382f
C158 a_342_n392# GND 0.17382f
C159 a_138_n392# GND 0.21057f
.ends
