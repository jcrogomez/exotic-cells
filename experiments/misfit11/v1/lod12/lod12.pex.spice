* NGSPICE file created from lod12.ext - technology: sky130A

.subckt lod12 SEL0 SEL1 SEL2 SEL3 SEL4 SEL5 SEL6 SEL7 SEL8 SEL9 SEL10 SEL11 X VB GND
X0 X VB a_342_n392# GND sky130_fd_pr__nfet_01v8 ad=0.126 pd=1.44 as=0.126 ps=1.44 w=0.42 l=0.15
X1 X VB a_8538_n392# GND sky130_fd_pr__nfet_01v8 ad=2.52 pd=12.84 as=2.52 ps=12.84 w=0.42 l=0.15
X2 X VB a_546_n392# GND sky130_fd_pr__nfet_01v8 ad=0.189 pd=1.74 as=0.189 ps=1.74 w=0.42 l=0.15
X3 X VB a_1212_n392# GND sky130_fd_pr__nfet_01v8 ad=0.315 pd=2.34 as=0.315 ps=2.34 w=0.42 l=0.15
X4 X VB a_1980_n392# GND sky130_fd_pr__nfet_01v8 ad=0.63 pd=3.84 as=0.63 ps=3.84 w=0.42 l=0.15
X5 GND SEL3 a_810_n392# GND sky130_fd_pr__nfet_01v8 ad=0.252 pd=2.28 as=0.252 ps=2.28 w=0.84 l=0.15
X6 GND SEL11 a_8538_n392# GND sky130_fd_pr__nfet_01v8 ad=0.252 pd=2.28 as=0.252 ps=2.28 w=0.84 l=0.15
X7 X VB a_2664_n392# GND sky130_fd_pr__nfet_01v8 ad=0.63 pd=3.84 as=0.63 ps=3.84 w=0.42 l=0.15
X8 X VB a_138_n392# GND sky130_fd_pr__nfet_01v8 ad=0.126 pd=1.44 as=0.126 ps=1.44 w=0.42 l=0.15
X9 GND SEL0 a_138_n392# GND sky130_fd_pr__nfet_01v8 ad=0.252 pd=2.28 as=0.252 ps=2.28 w=0.84 l=0.15
X10 GND SEL2 a_546_n392# GND sky130_fd_pr__nfet_01v8 ad=0.252 pd=2.28 as=0.252 ps=2.28 w=0.84 l=0.15
X11 GND SEL5 a_1596_n392# GND sky130_fd_pr__nfet_01v8 ad=0.252 pd=2.28 as=0.252 ps=2.28 w=0.84 l=0.15
X12 GND SEL7 a_2664_n392# GND sky130_fd_pr__nfet_01v8 ad=0.252 pd=2.28 as=0.252 ps=2.28 w=0.84 l=0.15
X13 X VB a_3486_n392# GND sky130_fd_pr__nfet_01v8 ad=1.26 pd=6.84 as=1.26 ps=6.84 w=0.42 l=0.15
X14 X VB a_810_n392# GND sky130_fd_pr__nfet_01v8 ad=0.189 pd=1.74 as=0.189 ps=1.74 w=0.42 l=0.15
X15 GND SEL6 a_1980_n392# GND sky130_fd_pr__nfet_01v8 ad=0.252 pd=2.28 as=0.252 ps=2.28 w=0.84 l=0.15
X16 X VB a_1596_n392# GND sky130_fd_pr__nfet_01v8 ad=0.315 pd=2.34 as=0.315 ps=2.34 w=0.42 l=0.15
X17 X VB a_4770_n392# GND sky130_fd_pr__nfet_01v8 ad=1.26 pd=6.84 as=1.26 ps=6.84 w=0.42 l=0.15
X18 GND SEL8 a_3486_n392# GND sky130_fd_pr__nfet_01v8 ad=0.252 pd=2.28 as=0.252 ps=2.28 w=0.84 l=0.15
X19 GND SEL9 a_4770_n392# GND sky130_fd_pr__nfet_01v8 ad=0.252 pd=2.28 as=0.252 ps=2.28 w=0.84 l=0.15
X20 GND SEL4 a_1212_n392# GND sky130_fd_pr__nfet_01v8 ad=0.252 pd=2.28 as=0.252 ps=2.28 w=0.84 l=0.15
X21 X VB a_6054_n392# GND sky130_fd_pr__nfet_01v8 ad=2.52 pd=12.84 as=2.52 ps=12.84 w=0.42 l=0.15
X22 GND SEL1 a_342_n392# GND sky130_fd_pr__nfet_01v8 ad=0.252 pd=2.28 as=0.252 ps=2.28 w=0.84 l=0.15
X23 GND SEL10 a_6054_n392# GND sky130_fd_pr__nfet_01v8 ad=0.252 pd=2.28 as=0.252 ps=2.28 w=0.84 l=0.15
C0 VB SEL7 0.00233f
C1 VB SEL6 0.00233f
C2 SEL11 X 0
C3 SEL3 a_1212_n392# 0
C4 VB SEL0 0.01474f
C5 SEL0 a_342_n392# 0
C6 X SEL2 0
C7 X SEL3 0
C8 a_1980_n392# SEL6 0.00409f
C9 X SEL7 0
C10 X SEL6 0
C11 VB SEL9 0.00233f
C12 a_810_n392# a_546_n392# 0.01483f
C13 SEL2 SEL1 0.09569f
C14 VB a_138_n392# 0.06465f
C15 X SEL0 0
C16 SEL4 SEL5 0.04741f
C17 a_138_n392# a_342_n392# 0.01932f
C18 VB a_2664_n392# 0.0571f
C19 VB SEL8 0.00233f
C20 VB a_3486_n392# 0.06329f
C21 SEL0 SEL1 0.09569f
C22 SEL2 SEL3 0.07141f
C23 X SEL9 0
C24 VB a_4770_n392# 0.06263f
C25 VB SEL10 0.00233f
C26 VB SEL5 0.00233f
C27 a_2664_n392# a_1980_n392# 0.00564f
C28 X a_138_n392# 0.03199f
C29 VB a_6054_n392# 0.08156f
C30 VB a_546_n392# 0.07283f
C31 a_1596_n392# SEL5 0.00409f
C32 a_2664_n392# X 0.04463f
C33 SEL7 SEL6 0.02578f
C34 X SEL8 0
C35 a_342_n392# a_546_n392# 0.01932f
C36 a_1980_n392# SEL5 0
C37 a_3486_n392# X 0.0381f
C38 a_4770_n392# X 0.05223f
C39 X SEL10 0
C40 X SEL5 0
C41 VB a_810_n392# 0.07044f
C42 X a_6054_n392# 0.07025f
C43 X a_546_n392# 0.04826f
C44 a_810_n392# a_1212_n392# 0.00966f
C45 a_546_n392# SEL1 0
C46 VB SEL4 0.00233f
C47 a_2664_n392# SEL7 0.00409f
C48 a_810_n392# X 0.04826f
C49 SEL7 SEL8 0.02131f
C50 a_2664_n392# SEL6 0
C51 a_3486_n392# SEL7 0
C52 a_138_n392# SEL0 0.0031f
C53 a_1596_n392# SEL4 0
C54 SEL4 a_1212_n392# 0.00409f
C55 SEL6 SEL5 0.04741f
C56 VB a_342_n392# 0.08024f
C57 SEL2 a_546_n392# 0.00351f
C58 VB a_8538_n392# 0.08061f
C59 X SEL4 0
C60 VB a_1596_n392# 0.06142f
C61 VB a_1980_n392# 0.06009f
C62 VB a_1212_n392# 0.05939f
C63 SEL9 SEL8 0.01349f
C64 a_810_n392# SEL2 0
C65 a_810_n392# SEL3 0.00351f
C66 VB X 2.10969f
C67 a_4770_n392# SEL9 0.00409f
C68 SEL10 SEL9 0.01349f
C69 X a_342_n392# 0.0562f
C70 a_1596_n392# a_1980_n392# 0.01012f
C71 a_1596_n392# a_1212_n392# 0.01012f
C72 X a_8538_n392# 0.07025f
C73 a_3486_n392# a_2664_n392# 0.00469f
C74 X a_1596_n392# 0.04423f
C75 a_3486_n392# SEL8 0.00409f
C76 SEL9 a_6054_n392# 0
C77 VB SEL1 0.01474f
C78 X a_1980_n392# 0.04463f
C79 a_342_n392# SEL1 0.0031f
C80 X a_1212_n392# 0.0301f
C81 a_4770_n392# SEL8 0
C82 SEL3 SEL4 0.04514f
C83 a_4770_n392# a_3486_n392# 0.00299f
C84 VB SEL11 0.00233f
C85 VB SEL2 0.00546f
C86 SEL11 a_8538_n392# 0.00409f
C87 VB SEL3 0.00546f
C88 a_4770_n392# a_6054_n392# 0.00299f
C89 X SEL1 0
C90 SEL10 a_6054_n392# 0.00409f
C91 SEL11 GND 0.39259f
C92 SEL10 GND 0.37521f
C93 SEL9 GND 0.35784f
C94 SEL8 GND 0.34893f
C95 SEL7 GND 0.3355f
C96 SEL6 GND 0.31429f
C97 SEL5 GND 0.29758f
C98 SEL4 GND 0.29901f
C99 SEL3 GND 0.28409f
C100 SEL2 GND 0.26193f
C101 SEL1 GND 0.24626f
C102 SEL0 GND 0.31444f
C103 X GND 4.02137f
C104 VB GND 5.97277f
C105 a_8538_n392# GND 0.23166f
C106 a_6054_n392# GND 0.22434f
C107 a_4770_n392# GND 0.21563f
C108 a_3486_n392# GND 0.22299f
C109 a_2664_n392# GND 0.20065f
C110 a_1980_n392# GND 0.19146f
C111 a_1596_n392# GND 0.17949f
C112 a_1212_n392# GND 0.19328f
C113 a_810_n392# GND 0.17455f
C114 a_546_n392# GND 0.17931f
C115 a_342_n392# GND 0.17382f
C116 a_138_n392# GND 0.21057f
.ends
