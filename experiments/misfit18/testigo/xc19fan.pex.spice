* NGSPICE file created from xc19fan.ext - technology: sky130A

.subckt xc19fan SEL0 SEL1 SEL2 SEL3 SEL4 SEL5 SEL6 SEL7 SEL8 SEL9 SEL10 SEL11 SEL12
+ SEL13 SEL14 SEL15 SEL16 SEL17 X VB GND
X0 X VB a_3408_n392# GND sky130_fd_pr__nfet_01v8 ad=0.126 pd=1.44 as=0.126 ps=1.44 w=0.42 l=0.15
X1 X VB a_342_n392# GND sky130_fd_pr__nfet_01v8 ad=0.126 pd=1.44 as=0.126 ps=1.44 w=0.42 l=0.15
X2 GND SEL10 a_3120_n392# GND sky130_fd_pr__nfet_01v8 ad=0.252 pd=2.28 as=0.252 ps=2.28 w=0.84 l=0.15
X3 X VB a_1922_n392# GND sky130_fd_pr__nfet_01v8 ad=0.2205 pd=2.28 as=0.126 ps=1.44 w=0.42 l=0.15
X4 X VB a_3612_n392# GND sky130_fd_pr__nfet_01v8 ad=0.252 pd=2.28 as=0.252 ps=2.28 w=0.84 l=0.15
X5 GND SEL3 a_750_n392# GND sky130_fd_pr__nfet_01v8 ad=0.252 pd=2.28 as=0.252 ps=2.28 w=0.84 l=0.15
X6 GND SEL13 a_3816_n392# GND sky130_fd_pr__nfet_01v8 ad=0.252 pd=2.28 as=0.252 ps=2.28 w=0.84 l=0.15
X7 GND SEL16 a_4746_n392# GND sky130_fd_pr__nfet_01v8 ad=0.252 pd=2.28 as=0.252 ps=2.28 w=0.84 l=0.15
X8 X VB a_546_n392# GND sky130_fd_pr__nfet_01v8 ad=0.126 pd=1.44 as=0.126 ps=1.44 w=0.42 l=0.15
X9 X VB a_954_n392# GND sky130_fd_pr__nfet_01v8 ad=0.42 pd=2.84 as=0.42 ps=2.84 w=0.42 l=0.15
X10 GND SEL5 a_1438_n392# GND sky130_fd_pr__nfet_01v8 ad=0.252 pd=2.28 as=0.252 ps=2.28 w=0.84 l=0.15
X11 X VB a_3816_n392# GND sky130_fd_pr__nfet_01v8 ad=0.252 pd=2.28 as=0.252 ps=2.28 w=0.84 l=0.15
X12 X VB a_4746_n392# GND sky130_fd_pr__nfet_01v8 ad=0.504 pd=3.96 as=0.504 ps=3.96 w=1.68 l=0.3
X13 X VB a_4980_n392# GND sky130_fd_pr__nfet_01v8 ad=0.504 pd=3.96 as=0.504 ps=3.96 w=1.68 l=0.3
X14 GND SEL17 a_4980_n392# GND sky130_fd_pr__nfet_01v8 ad=0.252 pd=2.28 as=0.252 ps=2.28 w=0.84 l=0.15
X15 X VB a_138_n392# GND sky130_fd_pr__nfet_01v8 ad=0.126 pd=1.44 as=0.126 ps=1.44 w=0.42 l=0.15
X16 X VB a_750_n392# GND sky130_fd_pr__nfet_01v8 ad=0.126 pd=1.44 as=0.126 ps=1.44 w=0.42 l=0.15
X17 X VB a_2508_n392# GND sky130_fd_pr__nfet_01v8 ad=0.126 pd=1.44 as=0.126 ps=1.44 w=0.42 l=0.15
X18 GND SEL0 a_138_n392# GND sky130_fd_pr__nfet_01v8 ad=0.252 pd=2.28 as=0.252 ps=2.28 w=0.84 l=0.15
X19 GND SEL2 a_546_n392# GND sky130_fd_pr__nfet_01v8 ad=0.252 pd=2.28 as=0.252 ps=2.28 w=0.84 l=0.15
X20 X VB a_2264_n392# GND sky130_fd_pr__nfet_01v8 ad=0.2205 pd=2.28 as=0.126 ps=1.44 w=0.42 l=0.15
X21 GND SEL7 a_2264_n392# GND sky130_fd_pr__nfet_01v8 ad=0.252 pd=2.28 as=0.252 ps=2.28 w=0.84 l=0.15
X22 X VB a_4158_n392# GND sky130_fd_pr__nfet_01v8 ad=0.126 pd=1.44 as=0.126 ps=1.44 w=0.42 l=0.6
X23 GND SEL4 a_954_n392# GND sky130_fd_pr__nfet_01v8 ad=0.252 pd=2.28 as=0.252 ps=2.28 w=0.84 l=0.15
X24 GND SEL15 a_4452_n392# GND sky130_fd_pr__nfet_01v8 ad=0.252 pd=2.28 as=0.252 ps=2.28 w=0.84 l=0.15
X25 GND SEL12 a_3612_n392# GND sky130_fd_pr__nfet_01v8 ad=0.252 pd=2.28 as=0.252 ps=2.28 w=0.84 l=0.15
X26 GND SEL8 a_2508_n392# GND sky130_fd_pr__nfet_01v8 ad=0.252 pd=2.28 as=0.252 ps=2.28 w=0.84 l=0.15
X27 X VB a_2792_n392# GND sky130_fd_pr__nfet_01v8 ad=0.126 pd=1.44 as=0.126 ps=1.44 w=0.42 l=0.15
X28 X VB a_3120_n392# GND sky130_fd_pr__nfet_01v8 ad=0.126 pd=1.44 as=0.126 ps=1.44 w=0.42 l=0.15
X29 GND SEL6 a_1922_n392# GND sky130_fd_pr__nfet_01v8 ad=0.252 pd=2.28 as=0.252 ps=2.28 w=0.84 l=0.15
X30 GND SEL14 a_4158_n392# GND sky130_fd_pr__nfet_01v8 ad=0.252 pd=2.28 as=0.252 ps=2.28 w=0.84 l=0.15
X31 GND SEL1 a_342_n392# GND sky130_fd_pr__nfet_01v8 ad=0.252 pd=2.28 as=0.252 ps=2.28 w=0.84 l=0.15
X32 GND SEL9 a_2792_n392# GND sky130_fd_pr__nfet_01v8 ad=0.252 pd=2.28 as=0.252 ps=2.28 w=0.84 l=0.15
X33 X VB a_4452_n392# GND sky130_fd_pr__nfet_01v8 ad=0.126 pd=1.44 as=0.126 ps=1.44 w=0.42 l=0.6
X34 GND SEL11 a_3408_n392# GND sky130_fd_pr__nfet_01v8 ad=0.252 pd=2.28 as=0.252 ps=2.28 w=0.84 l=0.15
X35 X VB a_1438_n392# GND sky130_fd_pr__nfet_01v8 ad=0.42 pd=2.84 as=0.42 ps=2.84 w=0.42 l=0.15
C0 a_3120_n392# a_2792_n392# 0.01188f
C1 a_2752_n26# a_2508_n392# 0
C2 a_3612_n392# a_3408_n392# 0.01932f
C3 a_138_n392# a_342_n392# 0.01932f
C4 a_3120_n392# a_2952_n26# 0.00119f
C5 SEL10 X 0.00108f
C6 SEL6 a_1922_n392# 0.0031f
C7 SEL2 VB 0.01474f
C8 a_750_n392# a_546_n392# 0.01932f
C9 SEL14 VB 0.01573f
C10 SEL8 VB 0.01474f
C11 VB a_4158_n392# 0.08043f
C12 SEL13 X 0.00124f
C13 VB a_2668_n26# 0.01439f
C14 VB SEL15 0.01573f
C15 X a_2468_n26# 0.00594f
C16 VB a_4980_n392# 0.08542f
C17 a_3816_n392# a_4158_n392# 0.01138f
C18 SEL0 a_342_n392# 0
C19 SEL9 VB 0.01474f
C20 SEL2 SEL3 0.09569f
C21 a_546_n392# X 0.05098f
C22 VB a_3408_n392# 0.07493f
C23 SEL14 a_4452_n392# 0
C24 a_3612_n392# X 0.09732f
C25 SEL8 a_2792_n392# 0
C26 SEL11 a_3408_n392# 0.0031f
C27 a_4746_n392# SEL15 0
C28 a_4452_n392# a_4158_n392# 0.01328f
C29 VB SEL17 0.0167f
C30 a_4746_n392# a_4980_n392# 0.01678f
C31 SEL1 X 0.00108f
C32 a_2792_n392# a_2668_n26# 0.00114f
C33 a_4452_n392# SEL15 0.0031f
C34 a_750_n392# VB 0.08024f
C35 a_4158_n392# a_2952_n26# 0
C36 SEL8 a_2508_n392# 0.0031f
C37 SEL9 a_2792_n392# 0.0031f
C38 a_138_n392# SEL0 0.0031f
C39 SEL8 SEL7 0.078f
C40 a_2668_n26# a_2508_n392# 0.00123f
C41 a_2952_n26# a_3408_n392# 0
C42 a_750_n392# SEL3 0.0031f
C43 VB X 0.75913f
C44 SEL1 a_546_n392# 0
C45 SEL10 VB 0.01474f
C46 SEL11 X 0.00108f
C47 X a_1438_n392# 0.03586f
C48 SEL11 SEL10 0.06484f
C49 X a_3816_n392# 0.09693f
C50 SEL4 X 0
C51 a_2752_n26# a_2668_n26# 0.0403f
C52 a_4746_n392# X 0.17178f
C53 VB SEL13 0.015f
C54 SEL5 X 0
C55 SEL3 X 0.00108f
C56 X a_4452_n392# 0.03857f
C57 VB a_2468_n26# 0.02168f
C58 X a_2792_n392# 0.04014f
C59 a_2264_n392# X 0.03687f
C60 SEL16 SEL15 0.06338f
C61 VB a_546_n392# 0.08024f
C62 SEL13 a_3816_n392# 0.00311f
C63 a_1438_n392# a_2468_n26# 0
C64 SEL9 a_3120_n392# 0
C65 X a_2952_n26# 0.00647f
C66 SEL16 a_4980_n392# 0
C67 VB a_3612_n392# 0.08215f
C68 a_3120_n392# a_3408_n392# 0.01356f
C69 SEL11 a_3612_n392# 0
C70 X a_2508_n392# 0.04402f
C71 a_342_n392# X 0.05098f
C72 SEL1 VB 0.01474f
C73 a_3612_n392# a_3816_n392# 0.01932f
C74 SEL16 SEL17 0.08177f
C75 SEL7 X 0.00111f
C76 SEL6 X 0.00111f
C77 a_750_n392# a_954_n392# 0.01932f
C78 a_2264_n392# a_2468_n26# 0
C79 SEL12 X 0.00124f
C80 SEL14 a_4158_n392# 0.0031f
C81 X a_2752_n26# 0.00333f
C82 X a_1922_n392# 0.05099f
C83 a_2508_n392# a_2468_n26# 0.00491f
C84 a_3612_n392# a_2952_n26# 0
C85 a_138_n392# X 0.02678f
C86 a_546_n392# a_342_n392# 0.01932f
C87 SEL14 SEL15 0.06338f
C88 SEL11 VB 0.01474f
C89 SEL9 SEL8 0.06585f
C90 X a_954_n392# 0.03586f
C91 X a_3120_n392# 0.02678f
C92 VB a_1438_n392# 0.05845f
C93 SEL16 X 0
C94 SEL10 a_3120_n392# 0.0031f
C95 SEL13 SEL12 0.09569f
C96 VB a_3816_n392# 0.0822f
C97 SEL1 a_342_n392# 0.0031f
C98 VB SEL4 0.00233f
C99 a_4746_n392# VB 0.08604f
C100 a_1922_n392# a_2468_n26# 0
C101 SEL4 a_1438_n392# 0
C102 SEL5 VB 0.00233f
C103 SEL2 a_750_n392# 0
C104 VB SEL3 0.01474f
C105 VB a_4452_n392# 0.08642f
C106 a_3612_n392# SEL12 0.00311f
C107 VB a_2792_n392# 0.07511f
C108 SEL0 X 0.00108f
C109 SEL5 a_1438_n392# 0.00409f
C110 VB a_2264_n392# 0.07342f
C111 a_2468_n26# a_954_n392# 0
C112 a_4980_n392# SEL17 0.00313f
C113 VB a_2952_n26# 0.01859f
C114 SEL5 SEL4 0.03705f
C115 SEL3 SEL4 0.09569f
C116 a_4746_n392# a_4452_n392# 0.01328f
C117 VB a_2508_n392# 0.07696f
C118 VB a_342_n392# 0.08024f
C119 a_3816_n392# a_2952_n26# 0
C120 SEL2 X 0.00108f
C121 VB SEL7 0.01474f
C122 SEL14 X 0
C123 SEL8 X 0.00108f
C124 SEL6 VB 0.01474f
C125 X a_4158_n392# 0.02442f
C126 a_4452_n392# a_2952_n26# 0
C127 a_2792_n392# a_2952_n26# 0.00123f
C128 X a_2668_n26# 0.00607f
C129 VB SEL12 0.015f
C130 X SEL15 0
C131 VB a_1922_n392# 0.07355f
C132 VB a_2752_n26# 0.01439f
C133 a_2792_n392# a_2508_n392# 0.01376f
C134 a_4980_n392# X 0.17046f
C135 SEL9 X 0.00108f
C136 a_2264_n392# a_2508_n392# 0.01607f
C137 SEL11 SEL12 0.09569f
C138 SEL14 SEL13 0.05373f
C139 SEL9 SEL10 0.05622f
C140 a_138_n392# VB 0.06465f
C141 SEL0 SEL1 0.09569f
C142 a_1922_n392# a_1438_n392# 0.008f
C143 SEL6 SEL5 0.03705f
C144 X a_3408_n392# 0.02678f
C145 SEL13 a_4158_n392# 0
C146 SEL12 a_3816_n392# 0
C147 SEL10 a_3408_n392# 0
C148 a_2264_n392# SEL7 0.0031f
C149 SEL2 a_546_n392# 0.0031f
C150 VB a_954_n392# 0.06531f
C151 VB a_3120_n392# 0.07371f
C152 SEL17 X 0
C153 SEL6 a_2264_n392# 0
C154 SEL16 VB 0.0167f
C155 a_1438_n392# a_954_n392# 0.008f
C156 SEL5 a_1922_n392# 0
C157 a_2668_n26# a_2468_n26# 0.00791f
C158 a_750_n392# X 0.05098f
C159 SEL7 a_2508_n392# 0
C160 SEL1 SEL2 0.09569f
C161 a_2792_n392# a_2752_n26# 0.00491f
C162 SEL4 a_954_n392# 0.00409f
C163 a_2264_n392# a_1922_n392# 0.01138f
C164 SEL16 a_4746_n392# 0.00313f
C165 a_2952_n26# a_2752_n26# 0.00791f
C166 SEL0 VB 0.01474f
C167 SEL6 SEL7 0.05373f
C168 SEL3 a_954_n392# 0
C169 SEL17 GND 0.31762f
C170 SEL16 GND 0.26154f
C171 SEL15 GND 0.27055f
C172 SEL14 GND 0.27542f
C173 SEL13 GND 0.26265f
C174 SEL12 GND 0.24554f
C175 SEL11 GND 0.25747f
C176 SEL10 GND 0.27323f
C177 SEL9 GND 0.27278f
C178 SEL8 GND 0.2631f
C179 SEL7 GND 0.26905f
C180 SEL6 GND 0.29079f
C181 SEL5 GND 0.31187f
C182 SEL4 GND 0.28412f
C183 SEL3 GND 0.24596f
C184 SEL2 GND 0.24596f
C185 SEL1 GND 0.24596f
C186 SEL0 GND 0.31415f
C187 X GND 3.6009f
C188 VB GND 4.88967f
C189 a_4980_n392# GND 0.20621f
C190 a_4452_n392# GND 0.16589f
C191 a_4158_n392# GND 0.1808f
C192 a_3816_n392# GND 0.1848f
C193 a_3408_n392# GND 0.20135f
C194 a_3120_n392# GND 0.20515f
C195 a_2952_n26# GND 0.08504f $ **FLOATING
C196 a_2792_n392# GND 0.17136f
C197 a_2752_n26# GND 0.06166f $ **FLOATING
C198 a_2668_n26# GND 0.06166f $ **FLOATING
C199 a_2508_n392# GND 0.17064f
C200 a_2468_n26# GND 0.08047f $ **FLOATING
C201 a_2264_n392# GND 0.1784f
C202 a_1922_n392# GND 0.17325f
C203 a_1438_n392# GND 0.18755f
C204 a_954_n392# GND 0.19374f
C205 a_750_n392# GND 0.17382f
C206 a_546_n392# GND 0.17382f
C207 a_342_n392# GND 0.17382f
C208 a_138_n392# GND 0.21057f
C209 a_3612_n392# GND 0.17923f
C210 a_4746_n392# GND 0.18277f
.ends
