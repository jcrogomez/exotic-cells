* NGSPICE file created from xc19fan.ext - technology: sky130A

.subckt xc19fan SEL0 SEL1 SEL2 SEL3 SEL4 SEL5 SEL6 SEL7 SEL8 SEL9 SEL10 SEL11 SEL12
+ SEL13 SEL14 SEL15 SEL16 SEL17 X VB GND
X0 GND SEL15 a_4472_n392# GND sky130_fd_pr__nfet_01v8 ad=0.252 pd=2.28 as=0.252 ps=2.28 w=0.84 l=0.15
X1 X VB a_342_n392# GND sky130_fd_pr__nfet_01v8 ad=0.126 pd=1.44 as=0.126 ps=1.44 w=0.42 l=0.15
X2 X VB a_3632_n392# GND sky130_fd_pr__nfet_01v8 ad=0.252 pd=2.28 as=0.252 ps=2.28 w=0.84 l=0.15
X3 GND SEL12 a_3632_n392# GND sky130_fd_pr__nfet_01v8 ad=0.252 pd=2.28 as=0.252 ps=2.28 w=0.84 l=0.15
X4 X VB a_1922_n392# GND sky130_fd_pr__nfet_01v8 ad=0.2205 pd=2.28 as=0.126 ps=1.44 w=0.42 l=0.15
X5 GND SEL3 a_750_n392# GND sky130_fd_pr__nfet_01v8 ad=0.252 pd=2.28 as=0.252 ps=2.28 w=0.84 l=0.15
X6 X VB a_546_n392# GND sky130_fd_pr__nfet_01v8 ad=0.126 pd=1.44 as=0.126 ps=1.44 w=0.42 l=0.15
X7 X VB a_954_n392# GND sky130_fd_pr__nfet_01v8 ad=0.42 pd=2.84 as=0.42 ps=2.84 w=0.42 l=0.15
X8 X VB a_3836_n392# GND sky130_fd_pr__nfet_01v8 ad=0.252 pd=2.28 as=0.252 ps=2.28 w=0.84 l=0.15
X9 X VB a_4766_n392# GND sky130_fd_pr__nfet_01v8 ad=0.504 pd=3.96 as=0.504 ps=3.96 w=1.68 l=0.3
X10 X VB a_5000_n392# GND sky130_fd_pr__nfet_01v8 ad=0.504 pd=3.96 as=0.504 ps=3.96 w=1.68 l=0.3
X11 GND SEL5 a_1438_n392# GND sky130_fd_pr__nfet_01v8 ad=0.252 pd=2.28 as=0.252 ps=2.28 w=0.84 l=0.15
X12 GND SEL14 a_4178_n392# GND sky130_fd_pr__nfet_01v8 ad=0.252 pd=2.28 as=0.252 ps=2.28 w=0.84 l=0.15
X13 X VB a_2807_n392# GND sky130_fd_pr__nfet_01v8 ad=0.126 pd=1.44 as=0.126 ps=1.44 w=0.42 l=0.15
X14 GND SEL10 a_3140_n392# GND sky130_fd_pr__nfet_01v8 ad=0.252 pd=2.28 as=0.252 ps=2.28 w=0.84 l=0.15
X15 X VB a_3140_n392# GND sky130_fd_pr__nfet_01v8 ad=0.126 pd=1.44 as=0.126 ps=1.44 w=0.42 l=0.15
X16 GND SEL9 a_2807_n392# GND sky130_fd_pr__nfet_01v8 ad=0.252 pd=2.28 as=0.252 ps=2.28 w=0.84 l=0.15
X17 GND SEL11 a_3428_n392# GND sky130_fd_pr__nfet_01v8 ad=0.252 pd=2.28 as=0.252 ps=2.28 w=0.84 l=0.15
X18 X VB a_138_n392# GND sky130_fd_pr__nfet_01v8 ad=0.126 pd=1.44 as=0.126 ps=1.44 w=0.42 l=0.15
X19 X VB a_750_n392# GND sky130_fd_pr__nfet_01v8 ad=0.126 pd=1.44 as=0.126 ps=1.44 w=0.42 l=0.15
X20 GND SEL0 a_138_n392# GND sky130_fd_pr__nfet_01v8 ad=0.252 pd=2.28 as=0.252 ps=2.28 w=0.84 l=0.15
X21 GND SEL2 a_546_n392# GND sky130_fd_pr__nfet_01v8 ad=0.252 pd=2.28 as=0.252 ps=2.28 w=0.84 l=0.15
X22 X VB a_2264_n392# GND sky130_fd_pr__nfet_01v8 ad=0.2205 pd=2.28 as=0.126 ps=1.44 w=0.42 l=0.15
X23 X VB a_4178_n392# GND sky130_fd_pr__nfet_01v8 ad=0.126 pd=1.44 as=0.126 ps=1.44 w=0.42 l=0.6
X24 GND SEL7 a_2264_n392# GND sky130_fd_pr__nfet_01v8 ad=0.252 pd=2.28 as=0.252 ps=2.28 w=0.84 l=0.15
X25 GND SEL13 a_3836_n392# GND sky130_fd_pr__nfet_01v8 ad=0.252 pd=2.28 as=0.252 ps=2.28 w=0.84 l=0.15
X26 GND SEL16 a_4766_n392# GND sky130_fd_pr__nfet_01v8 ad=0.252 pd=2.28 as=0.252 ps=2.28 w=0.84 l=0.15
X27 GND SEL4 a_954_n392# GND sky130_fd_pr__nfet_01v8 ad=0.252 pd=2.28 as=0.252 ps=2.28 w=0.84 l=0.15
X28 GND SEL8 a_2513_n392# GND sky130_fd_pr__nfet_01v8 ad=0.252 pd=2.28 as=0.252 ps=2.28 w=0.84 l=0.15
X29 GND SEL17 a_5000_n392# GND sky130_fd_pr__nfet_01v8 ad=0.252 pd=2.28 as=0.252 ps=2.28 w=0.84 l=0.15
X30 GND SEL6 a_1922_n392# GND sky130_fd_pr__nfet_01v8 ad=0.252 pd=2.28 as=0.252 ps=2.28 w=0.84 l=0.15
X31 X VB a_4472_n392# GND sky130_fd_pr__nfet_01v8 ad=0.126 pd=1.44 as=0.126 ps=1.44 w=0.42 l=0.6
X32 X VB a_3428_n392# GND sky130_fd_pr__nfet_01v8 ad=0.126 pd=1.44 as=0.126 ps=1.44 w=0.42 l=0.15
X33 GND SEL1 a_342_n392# GND sky130_fd_pr__nfet_01v8 ad=0.252 pd=2.28 as=0.252 ps=2.28 w=0.84 l=0.15
X34 X VB a_2513_n392# GND sky130_fd_pr__nfet_01v8 ad=0.126 pd=1.44 as=0.126 ps=1.44 w=0.42 l=0.15
X35 X VB a_1438_n392# GND sky130_fd_pr__nfet_01v8 ad=0.42 pd=2.84 as=0.42 ps=2.84 w=0.42 l=0.15
C0 VB a_2762_n26# 0.01359f
C1 X a_4472_n392# 0.03857f
C2 VB SEL16 0.0167f
C3 SEL10 VB 0.01474f
C4 X a_2762_n26# 0.00322f
C5 X SEL16 0
C6 VB a_3836_n392# 0.0822f
C7 a_4178_n392# a_4472_n392# 0.01328f
C8 SEL1 a_546_n392# 0
C9 SEL10 X 0.00108f
C10 SEL3 SEL4 0.09569f
C11 X a_3836_n392# 0.09693f
C12 a_138_n392# SEL0 0.0031f
C13 SEL12 a_3836_n392# 0
C14 a_954_n392# VB 0.06531f
C15 a_2972_n26# a_4472_n392# 0
C16 a_4178_n392# a_3836_n392# 0.01138f
C17 SEL9 a_3140_n392# 0
C18 a_3632_n392# a_3836_n392# 0.01932f
C19 a_2972_n26# a_2762_n26# 0.00747f
C20 a_954_n392# X 0.03586f
C21 a_5000_n392# SEL16 0
C22 a_342_n392# SEL1 0.0031f
C23 a_2972_n26# a_3836_n392# 0
C24 SEL9 SEL8 0.06338f
C25 SEL10 a_3140_n392# 0.0031f
C26 a_2762_n26# a_2678_n26# 0.0403f
C27 VB SEL0 0.01474f
C28 SEL11 VB 0.01474f
C29 a_954_n392# SEL4 0.00409f
C30 X SEL0 0.00108f
C31 SEL9 a_2807_n392# 0.0031f
C32 a_954_n392# a_2468_n26# 0
C33 SEL2 a_750_n392# 0
C34 SEL11 X 0.00108f
C35 SEL12 SEL11 0.09569f
C36 VB SEL14 0.01573f
C37 a_2807_n392# a_2762_n26# 0.00477f
C38 a_3632_n392# SEL11 0
C39 VB a_2513_n392# 0.07669f
C40 SEL15 a_4766_n392# 0
C41 X SEL14 0
C42 SEL13 a_3836_n392# 0.00311f
C43 a_4766_n392# a_4472_n392# 0.01328f
C44 VB a_750_n392# 0.08024f
C45 X a_2513_n392# 0.04342f
C46 a_138_n392# VB 0.06465f
C47 SEL17 SEL16 0.08177f
C48 SEL14 a_4178_n392# 0.0031f
C49 X a_750_n392# 0.05098f
C50 SEL10 a_3428_n392# 0
C51 a_4766_n392# SEL16 0.00313f
C52 X a_138_n392# 0.02678f
C53 SEL2 VB 0.01474f
C54 SEL2 X 0.00108f
C55 a_954_n392# a_1438_n392# 0.008f
C56 a_2468_n26# a_2513_n392# 0.00477f
C57 SEL15 a_4472_n392# 0.0031f
C58 a_2678_n26# a_2513_n392# 0.00117f
C59 X VB 0.76079f
C60 SEL12 VB 0.015f
C61 a_342_n392# SEL0 0
C62 a_750_n392# a_546_n392# 0.01932f
C63 VB a_1922_n392# 0.07355f
C64 SEL15 SEL16 0.06338f
C65 SEL8 a_2513_n392# 0.0031f
C66 SEL7 a_2513_n392# 0
C67 VB a_4178_n392# 0.08043f
C68 SEL12 X 0.00124f
C69 SEL10 SEL9 0.0553f
C70 X a_1922_n392# 0.05099f
C71 VB SEL5 0.00233f
C72 a_3632_n392# VB 0.08215f
C73 SEL11 a_3428_n392# 0.0031f
C74 X a_4178_n392# 0.02442f
C75 SEL14 SEL13 0.05373f
C76 SEL2 a_546_n392# 0.0031f
C77 X SEL5 0
C78 SEL6 VB 0.01474f
C79 a_3632_n392# X 0.09732f
C80 VB SEL4 0.00233f
C81 VB a_5000_n392# 0.08542f
C82 a_2264_n392# a_2513_n392# 0.01574f
C83 a_2807_n392# a_2513_n392# 0.01328f
C84 SEL12 a_3632_n392# 0.00311f
C85 VB a_2972_n26# 0.0178f
C86 SEL5 a_1922_n392# 0
C87 SEL3 a_954_n392# 0
C88 SEL6 X 0.00111f
C89 VB a_2468_n26# 0.02089f
C90 X SEL4 0
C91 X a_5000_n392# 0.17046f
C92 X a_2972_n26# 0.00634f
C93 VB a_3140_n392# 0.07359f
C94 SEL1 SEL0 0.09569f
C95 SEL6 a_1922_n392# 0.0031f
C96 X a_2468_n26# 0.00588f
C97 VB a_2678_n26# 0.01359f
C98 VB a_546_n392# 0.08024f
C99 a_342_n392# a_138_n392# 0.01932f
C100 X a_3140_n392# 0.02678f
C101 SEL6 SEL5 0.03705f
C102 a_2468_n26# a_1922_n392# 0
C103 SEL4 SEL5 0.03705f
C104 a_4178_n392# a_2972_n26# 0
C105 X a_2678_n26# 0.00592f
C106 X a_546_n392# 0.05098f
C107 a_3632_n392# a_2972_n26# 0
C108 VB SEL8 0.01474f
C109 SEL7 VB 0.01474f
C110 X SEL8 0.00108f
C111 SEL7 X 0.00111f
C112 VB SEL13 0.015f
C113 VB a_2264_n392# 0.07343f
C114 VB a_2807_n392# 0.07475f
C115 a_2972_n26# a_3140_n392# 0.00119f
C116 X SEL13 0.00124f
C117 a_342_n392# VB 0.08024f
C118 X a_2264_n392# 0.03687f
C119 X a_2807_n392# 0.03943f
C120 a_2468_n26# a_2678_n26# 0.00747f
C121 SEL12 SEL13 0.09569f
C122 SEL15 SEL14 0.06338f
C123 SEL10 SEL11 0.06484f
C124 VB a_1438_n392# 0.05845f
C125 a_342_n392# X 0.05098f
C126 a_2264_n392# a_1922_n392# 0.01138f
C127 SEL1 SEL2 0.09569f
C128 VB a_3428_n392# 0.07493f
C129 SEL7 SEL6 0.05373f
C130 SEL17 VB 0.0167f
C131 SEL13 a_4178_n392# 0
C132 SEL14 a_4472_n392# 0
C133 VB a_4766_n392# 0.08604f
C134 SEL3 a_750_n392# 0.0031f
C135 X a_1438_n392# 0.03586f
C136 X a_3428_n392# 0.02678f
C137 SEL17 X 0
C138 X a_4766_n392# 0.17178f
C139 a_1922_n392# a_1438_n392# 0.008f
C140 SEL6 a_2264_n392# 0
C141 a_2762_n26# a_2513_n392# 0
C142 SEL2 SEL3 0.09569f
C143 a_2972_n26# a_2807_n392# 0.00117f
C144 SEL5 a_1438_n392# 0.00409f
C145 a_3632_n392# a_3428_n392# 0.01932f
C146 SEL1 VB 0.01474f
C147 a_2468_n26# a_2264_n392# 0
C148 a_3140_n392# a_2807_n392# 0.0117f
C149 SEL1 X 0.00108f
C150 SEL7 SEL8 0.07624f
C151 SEL4 a_1438_n392# 0
C152 SEL17 a_5000_n392# 0.00313f
C153 a_3428_n392# a_2972_n26# 0
C154 a_2807_n392# a_2678_n26# 0.00109f
C155 a_4766_n392# a_5000_n392# 0.01678f
C156 a_2468_n26# a_1438_n392# 0
C157 a_342_n392# a_546_n392# 0.01932f
C158 SEL3 VB 0.01474f
C159 a_3428_n392# a_3140_n392# 0.01356f
C160 SEL8 a_2807_n392# 0
C161 SEL15 VB 0.01573f
C162 SEL7 a_2264_n392# 0.0031f
C163 SEL9 VB 0.01474f
C164 SEL3 X 0.00108f
C165 a_954_n392# a_750_n392# 0.01932f
C166 VB a_4472_n392# 0.08642f
C167 SEL15 X 0
C168 SEL9 X 0.00108f
C169 SEL17 GND 0.31762f
C170 SEL16 GND 0.26154f
C171 SEL15 GND 0.27055f
C172 SEL14 GND 0.27542f
C173 SEL13 GND 0.26265f
C174 SEL12 GND 0.24554f
C175 SEL11 GND 0.25747f
C176 SEL10 GND 0.27371f
C177 SEL9 GND 0.27439f
C178 SEL8 GND 0.26491f
C179 SEL7 GND 0.26973f
C180 SEL6 GND 0.29079f
C181 SEL5 GND 0.31187f
C182 SEL4 GND 0.28412f
C183 SEL3 GND 0.24596f
C184 SEL2 GND 0.24596f
C185 SEL1 GND 0.24596f
C186 SEL0 GND 0.31415f
C187 X GND 3.61224f
C188 VB GND 4.90099f
C189 a_5000_n392# GND 0.20621f
C190 a_4472_n392# GND 0.16589f
C191 a_4178_n392# GND 0.1808f
C192 a_3836_n392# GND 0.1848f
C193 a_3428_n392# GND 0.20135f
C194 a_3140_n392# GND 0.20525f
C195 a_2972_n26# GND 0.0857f $ **FLOATING
C196 a_2807_n392# GND 0.17179f
C197 a_2762_n26# GND 0.06231f $ **FLOATING
C198 a_2678_n26# GND 0.06231f $ **FLOATING
C199 a_2513_n392# GND 0.1708f
C200 a_2468_n26# GND 0.08113f $ **FLOATING
C201 a_2264_n392# GND 0.17862f
C202 a_1922_n392# GND 0.17325f
C203 a_1438_n392# GND 0.18755f
C204 a_954_n392# GND 0.19374f
C205 a_750_n392# GND 0.17382f
C206 a_546_n392# GND 0.17382f
C207 a_342_n392# GND 0.17382f
C208 a_138_n392# GND 0.21057f
C209 a_3632_n392# GND 0.17923f
C210 a_4766_n392# GND 0.18277f
.ends
