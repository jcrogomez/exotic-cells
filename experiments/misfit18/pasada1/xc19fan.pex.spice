* NGSPICE file created from xc19fan.ext - technology: sky130A

.subckt xc19fan SEL0 SEL1 SEL2 SEL3 SEL4 SEL5 SEL6 SEL7 SEL8 SEL9 SEL10 SEL11 SEL12
+ SEL13 SEL14 SEL15 SEL16 SEL17 X VB GND
X0 GND SEL15 a_4472_n392# GND sky130_fd_pr__nfet_01v8 ad=0.252 pd=2.28 as=0.252 ps=2.28 w=0.84 l=0.15
X1 X VB a_342_n392# GND sky130_fd_pr__nfet_01v8 ad=0.126 pd=1.44 as=0.126 ps=1.44 w=0.42 l=0.15
X2 X VB a_3632_n392# GND sky130_fd_pr__nfet_01v8 ad=0.252 pd=2.28 as=0.252 ps=2.28 w=0.84 l=0.15
X3 GND SEL12 a_3632_n392# GND sky130_fd_pr__nfet_01v8 ad=0.252 pd=2.28 as=0.252 ps=2.28 w=0.84 l=0.15
X4 X VB a_1922_n392# GND sky130_fd_pr__nfet_01v8 ad=0.2205 pd=2.28 as=0.126 ps=1.44 w=0.42 l=0.15
X5 GND SEL3 a_750_n392# GND sky130_fd_pr__nfet_01v8 ad=0.252 pd=2.28 as=0.252 ps=2.28 w=0.84 l=0.15
X6 X VB a_546_n392# GND sky130_fd_pr__nfet_01v8 ad=0.126 pd=1.44 as=0.126 ps=1.44 w=0.42 l=0.15
X7 X VB a_954_n392# GND sky130_fd_pr__nfet_01v8 ad=0.42 pd=2.84 as=0.42 ps=2.84 w=0.42 l=0.15
X8 X VB a_3836_n392# GND sky130_fd_pr__nfet_01v8 ad=0.252 pd=2.28 as=0.252 ps=2.28 w=0.84 l=0.15
X9 X VB a_4766_n392# GND sky130_fd_pr__nfet_01v8 ad=0.504 pd=3.96 as=0.504 ps=3.96 w=1.68 l=0.3
X10 X VB a_5000_n392# GND sky130_fd_pr__nfet_01v8 ad=0.504 pd=3.96 as=0.504 ps=3.96 w=1.68 l=0.3
X11 GND SEL5 a_1438_n392# GND sky130_fd_pr__nfet_01v8 ad=0.252 pd=2.28 as=0.252 ps=2.28 w=0.84 l=0.15
X12 GND SEL14 a_4178_n392# GND sky130_fd_pr__nfet_01v8 ad=0.252 pd=2.28 as=0.252 ps=2.28 w=0.84 l=0.15
X13 X VB a_2807_n392# GND sky130_fd_pr__nfet_01v8 ad=0.126 pd=1.44 as=0.126 ps=1.44 w=0.42 l=0.15
X14 GND SEL10 a_3140_n392# GND sky130_fd_pr__nfet_01v8 ad=0.252 pd=2.28 as=0.252 ps=2.28 w=0.84 l=0.15
X15 X VB a_3140_n392# GND sky130_fd_pr__nfet_01v8 ad=0.126 pd=1.44 as=0.126 ps=1.44 w=0.42 l=0.15
X16 GND SEL9 a_2807_n392# GND sky130_fd_pr__nfet_01v8 ad=0.252 pd=2.28 as=0.252 ps=2.28 w=0.84 l=0.15
X17 GND SEL11 a_3428_n392# GND sky130_fd_pr__nfet_01v8 ad=0.252 pd=2.28 as=0.252 ps=2.28 w=0.84 l=0.15
X18 X VB a_138_n392# GND sky130_fd_pr__nfet_01v8 ad=0.126 pd=1.44 as=0.126 ps=1.44 w=0.42 l=0.15
X19 X VB a_750_n392# GND sky130_fd_pr__nfet_01v8 ad=0.126 pd=1.44 as=0.126 ps=1.44 w=0.42 l=0.15
X20 GND SEL0 a_138_n392# GND sky130_fd_pr__nfet_01v8 ad=0.252 pd=2.28 as=0.252 ps=2.28 w=0.84 l=0.15
X21 GND SEL2 a_546_n392# GND sky130_fd_pr__nfet_01v8 ad=0.252 pd=2.28 as=0.252 ps=2.28 w=0.84 l=0.15
X22 X VB a_2264_n392# GND sky130_fd_pr__nfet_01v8 ad=0.2205 pd=2.28 as=0.126 ps=1.44 w=0.42 l=0.15
X23 X VB a_4178_n392# GND sky130_fd_pr__nfet_01v8 ad=0.126 pd=1.44 as=0.126 ps=1.44 w=0.42 l=0.6
X24 GND SEL7 a_2264_n392# GND sky130_fd_pr__nfet_01v8 ad=0.252 pd=2.28 as=0.252 ps=2.28 w=0.84 l=0.15
X25 GND SEL13 a_3836_n392# GND sky130_fd_pr__nfet_01v8 ad=0.252 pd=2.28 as=0.252 ps=2.28 w=0.84 l=0.15
X26 GND SEL16 a_4766_n392# GND sky130_fd_pr__nfet_01v8 ad=0.252 pd=2.28 as=0.252 ps=2.28 w=0.84 l=0.15
X27 GND SEL4 a_954_n392# GND sky130_fd_pr__nfet_01v8 ad=0.252 pd=2.28 as=0.252 ps=2.28 w=0.84 l=0.15
X28 GND SEL8 a_2513_n392# GND sky130_fd_pr__nfet_01v8 ad=0.252 pd=2.28 as=0.252 ps=2.28 w=0.84 l=0.15
X29 GND SEL17 a_5000_n392# GND sky130_fd_pr__nfet_01v8 ad=0.252 pd=2.28 as=0.252 ps=2.28 w=0.84 l=0.15
X30 GND SEL6 a_1922_n392# GND sky130_fd_pr__nfet_01v8 ad=0.252 pd=2.28 as=0.252 ps=2.28 w=0.84 l=0.15
X31 X VB a_4472_n392# GND sky130_fd_pr__nfet_01v8 ad=0.126 pd=1.44 as=0.126 ps=1.44 w=0.42 l=0.6
X32 X VB a_3428_n392# GND sky130_fd_pr__nfet_01v8 ad=0.126 pd=1.44 as=0.126 ps=1.44 w=0.42 l=0.15
X33 GND SEL1 a_342_n392# GND sky130_fd_pr__nfet_01v8 ad=0.252 pd=2.28 as=0.252 ps=2.28 w=0.84 l=0.15
X34 X VB a_2513_n392# GND sky130_fd_pr__nfet_01v8 ad=0.126 pd=1.44 as=0.126 ps=1.44 w=0.42 l=0.15
X35 X VB a_1438_n392# GND sky130_fd_pr__nfet_01v8 ad=0.42 pd=2.84 as=0.42 ps=2.84 w=0.42 l=0.15
C0 X SEL7 0.00111f
C1 a_3836_n392# a_4178_n392# 0.01138f
C2 VB a_3140_n392# 0.07359f
C3 X SEL12 0.00124f
C4 a_546_n392# X 0.05098f
C5 SEL16 a_5000_n392# 0
C6 VB a_3428_n392# 0.07493f
C7 a_1922_n392# X 0.05099f
C8 VB a_2762_n26# 0.01359f
C9 SEL7 SEL6 0.05373f
C10 SEL12 a_3836_n392# 0
C11 SEL17 a_5000_n392# 0.00313f
C12 a_750_n392# X 0.05098f
C13 a_4766_n392# a_4472_n392# 0.01328f
C14 X SEL5 0
C15 a_3632_n392# a_3428_n392# 0.01932f
C16 a_1922_n392# a_2468_n26# 0
C17 a_1922_n392# SEL6 0.0031f
C18 SEL10 a_3140_n392# 0.0031f
C19 SEL9 a_2807_n392# 0.0031f
C20 X SEL3 0.00108f
C21 X SEL15 0
C22 X VB 0.76079f
C23 SEL10 a_3428_n392# 0
C24 VB a_2972_n26# 0.0178f
C25 VB a_2678_n26# 0.01359f
C26 SEL6 SEL5 0.03705f
C27 a_2264_n392# a_2513_n392# 0.01574f
C28 SEL14 a_4472_n392# 0
C29 VB SEL0 0.01474f
C30 a_1438_n392# a_1922_n392# 0.008f
C31 VB a_2468_n26# 0.02089f
C32 VB SEL6 0.01474f
C33 VB a_3836_n392# 0.0822f
C34 a_3632_n392# X 0.09732f
C35 a_138_n392# X 0.02678f
C36 a_3632_n392# a_2972_n26# 0
C37 SEL8 a_2513_n392# 0.0031f
C38 a_138_n392# SEL0 0.0031f
C39 SEL13 X 0.00124f
C40 X SEL10 0.00108f
C41 SEL4 SEL5 0.03705f
C42 a_1438_n392# SEL5 0.00409f
C43 a_3632_n392# a_3836_n392# 0.01932f
C44 a_4766_n392# X 0.17178f
C45 SEL16 SEL15 0.06338f
C46 VB SEL16 0.0167f
C47 a_546_n392# SEL1 0
C48 SEL4 SEL3 0.09569f
C49 SEL13 a_3836_n392# 0.00311f
C50 SEL4 VB 0.00233f
C51 a_2513_n392# a_2762_n26# 0
C52 a_1438_n392# VB 0.05845f
C53 a_342_n392# X 0.05098f
C54 SEL17 VB 0.0167f
C55 a_342_n392# SEL0 0
C56 SEL14 X 0
C57 a_3140_n392# a_3428_n392# 0.01356f
C58 VB SEL9 0.01474f
C59 a_2264_n392# X 0.03687f
C60 SEL11 SEL12 0.09569f
C61 X a_954_n392# 0.03586f
C62 VB a_5000_n392# 0.08542f
C63 X a_2513_n392# 0.04342f
C64 SEL2 X 0.00108f
C65 a_2678_n26# a_2513_n392# 0.00117f
C66 X a_4472_n392# 0.03857f
C67 VB a_2807_n392# 0.07475f
C68 SEL1 VB 0.01474f
C69 a_4472_n392# a_2972_n26# 0
C70 a_2264_n392# a_2468_n26# 0
C71 a_2264_n392# SEL6 0
C72 X SEL8 0.00108f
C73 a_4766_n392# SEL16 0.00313f
C74 a_954_n392# a_2468_n26# 0
C75 a_2513_n392# a_2468_n26# 0.00477f
C76 VB a_4178_n392# 0.08043f
C77 X a_3140_n392# 0.03725f
C78 SEL10 SEL9 0.0553f
C79 a_546_n392# a_750_n392# 0.01932f
C80 a_3140_n392# a_2972_n26# 0.00164f
C81 X a_3428_n392# 0.03985f
C82 a_1922_n392# SEL5 0
C83 a_3428_n392# a_2972_n26# 0
C84 SEL11 VB 0.01474f
C85 VB SEL7 0.01474f
C86 X a_2762_n26# 0.00322f
C87 VB SEL12 0.015f
C88 a_2678_n26# a_2762_n26# 0.0403f
C89 a_4766_n392# a_5000_n392# 0.01678f
C90 a_2972_n26# a_2762_n26# 0.00747f
C91 a_546_n392# VB 0.08024f
C92 a_1922_n392# VB 0.07355f
C93 SEL4 a_954_n392# 0.00409f
C94 SEL13 a_4178_n392# 0
C95 a_1438_n392# a_954_n392# 0.008f
C96 SEL11 a_3632_n392# 0
C97 a_3632_n392# SEL12 0.00311f
C98 a_750_n392# SEL3 0.0031f
C99 a_750_n392# VB 0.08024f
C100 a_342_n392# SEL1 0.0031f
C101 VB SEL5 0.00233f
C102 X a_2678_n26# 0.00592f
C103 X a_2972_n26# 0.00634f
C104 SEL11 SEL10 0.06484f
C105 SEL13 SEL12 0.09569f
C106 X SEL0 0.00108f
C107 SEL8 SEL9 0.06338f
C108 VB SEL3 0.01474f
C109 VB SEL15 0.01573f
C110 X a_2468_n26# 0.00588f
C111 X a_3836_n392# 0.09693f
C112 a_2513_n392# a_2807_n392# 0.01328f
C113 X SEL6 0.00111f
C114 SEL14 a_4178_n392# 0.0031f
C115 a_2678_n26# a_2468_n26# 0.00747f
C116 a_3836_n392# a_2972_n26# 0
C117 SEL1 SEL2 0.09569f
C118 SEL9 a_3140_n392# 0
C119 SEL8 a_2807_n392# 0
C120 a_546_n392# a_342_n392# 0.01932f
C121 a_3632_n392# VB 0.08215f
C122 a_4472_n392# a_4178_n392# 0.01328f
C123 a_138_n392# VB 0.06465f
C124 a_3140_n392# a_2807_n392# 0.0117f
C125 a_2264_n392# SEL7 0.0031f
C126 X SEL16 0
C127 SEL13 VB 0.015f
C128 SEL4 X 0
C129 SEL7 a_2513_n392# 0
C130 VB SEL10 0.01474f
C131 a_1438_n392# X 0.03586f
C132 a_2264_n392# a_1922_n392# 0.01138f
C133 a_546_n392# SEL2 0.0031f
C134 a_2807_n392# a_2762_n26# 0.00477f
C135 a_4766_n392# SEL15 0
C136 a_4766_n392# VB 0.08604f
C137 SEL17 X 0
C138 SEL8 SEL7 0.07624f
C139 X SEL9 0.00108f
C140 a_1438_n392# a_2468_n26# 0
C141 a_342_n392# VB 0.08024f
C142 a_750_n392# a_954_n392# 0.01932f
C143 X a_5000_n392# 0.17046f
C144 SEL2 a_750_n392# 0
C145 SEL11 a_3428_n392# 0.0031f
C146 SEL14 SEL15 0.06338f
C147 SEL14 VB 0.01573f
C148 X a_2807_n392# 0.03943f
C149 SEL1 X 0.00108f
C150 a_2264_n392# VB 0.07343f
C151 a_2972_n26# a_2807_n392# 0.00117f
C152 a_2678_n26# a_2807_n392# 0.00109f
C153 SEL3 a_954_n392# 0
C154 VB a_954_n392# 0.06531f
C155 SEL2 SEL3 0.09569f
C156 a_138_n392# a_342_n392# 0.01932f
C157 VB a_2513_n392# 0.07669f
C158 SEL1 SEL0 0.09569f
C159 SEL2 VB 0.01474f
C160 X a_4178_n392# 0.02442f
C161 SEL15 a_4472_n392# 0.0031f
C162 VB a_4472_n392# 0.08642f
C163 a_4178_n392# a_2972_n26# 0
C164 a_1438_n392# SEL4 0
C165 VB SEL8 0.01474f
C166 SEL17 SEL16 0.08177f
C167 SEL11 X 0.00108f
C168 SEL14 SEL13 0.05373f
C169 SEL17 GND 0.31762f
C170 SEL16 GND 0.26154f
C171 SEL15 GND 0.27055f
C172 SEL14 GND 0.27542f
C173 SEL13 GND 0.26265f
C174 SEL12 GND 0.24554f
C175 SEL11 GND 0.25747f
C176 SEL10 GND 0.27371f
C177 SEL9 GND 0.27439f
C178 SEL8 GND 0.26491f
C179 SEL7 GND 0.26973f
C180 SEL6 GND 0.29079f
C181 SEL5 GND 0.31187f
C182 SEL4 GND 0.28412f
C183 SEL3 GND 0.24596f
C184 SEL2 GND 0.24596f
C185 SEL1 GND 0.24596f
C186 SEL0 GND 0.31415f
C187 X GND 3.58136f
C188 VB GND 4.89534f
C189 a_5000_n392# GND 0.20621f
C190 a_4472_n392# GND 0.16589f
C191 a_4178_n392# GND 0.1808f
C192 a_3836_n392# GND 0.1848f
C193 a_3428_n392# GND 0.16804f
C194 a_3140_n392# GND 0.17299f
C195 a_2972_n26# GND 0.08338f $ **FLOATING
C196 a_2807_n392# GND 0.17179f
C197 a_2762_n26# GND 0.06231f $ **FLOATING
C198 a_2678_n26# GND 0.06231f $ **FLOATING
C199 a_2513_n392# GND 0.1708f
C200 a_2468_n26# GND 0.08113f $ **FLOATING
C201 a_2264_n392# GND 0.17862f
C202 a_1922_n392# GND 0.17325f
C203 a_1438_n392# GND 0.18755f
C204 a_954_n392# GND 0.19374f
C205 a_750_n392# GND 0.17382f
C206 a_546_n392# GND 0.17382f
C207 a_342_n392# GND 0.17382f
C208 a_138_n392# GND 0.21057f
C209 a_3632_n392# GND 0.17923f
C210 a_4766_n392# GND 0.18277f
.ends
