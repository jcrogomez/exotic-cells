* MISFIT-03 etapa a · enmienda 2 Monte Carlo tt_mm · esquina tt_mm 27 C. Generado por gen_contrato.py (no editar a mano).
* Macro: cells/xc19_slot_core/xc19_slot_core_lod.inc (Magic, extraccion con capacidades, LOD anotado por Residual).
* Decodificador: celdas sky130_fd_sc_hd en SPICE (E7). El contador es aritmetico: cuentas = (t_xa - t_pre) * 50 MHz.
.lib /pdk/libs.tech/ngspice/sky130.lib.spice tt_mm
.include /pdk/libs.ref/sky130_fd_sc_hd/spice/sky130_fd_sc_hd.spice
.options gmin=1e-18 abstol=1e-15 reltol=1e-5
.temp 27
.subckt trap XB_OUT SB0B SB1B REFB XA_OUT SA0B SA1B SA2B REFA VDD GND VBIAS C1 PREA XA DUTA PREB XB DUTB VB CALA CALB GT
X5 GND VB GND GND sky130_fd_pr__nfet_01v8 ad=1.65 pd=6.1 as=117.474 ps=596.35999 w=5.5 l=10
X6 GND VB GND GND sky130_fd_pr__nfet_01v8 ad=1.65 pd=6.1 as=0 ps=0 w=5.5 l=10
X7 GND XB GND GND sky130_fd_pr__nfet_01v8 ad=1.29 pd=9.2 as=0 ps=0 w=4.3 l=4
X12 GND VB GND GND sky130_fd_pr__nfet_01v8 ad=1.65 pd=6.1 as=0 ps=0 w=5.5 l=10
X13 GND VB GND GND sky130_fd_pr__nfet_01v8 ad=1.65 pd=11.6 as=0 ps=0 w=5.5 l=10
X16 GND VB GND GND sky130_fd_pr__nfet_01v8 ad=1.65 pd=11.6 as=0 ps=0 w=5.5 l=10
X17 GND VB GND GND sky130_fd_pr__nfet_01v8 ad=1.65 pd=6.1 as=0 ps=0 w=5.5 l=10
X19 GND XA GND GND sky130_fd_pr__nfet_01v8 ad=1.29 pd=9.2 as=0 ps=0 w=4.3 l=4
X23 GND VB GND GND sky130_fd_pr__nfet_01v8 ad=1.65 pd=6.1 as=0 ps=0 w=5.5 l=10
X24 GND VB GND GND sky130_fd_pr__nfet_01v8 ad=1.65 pd=6.1 as=0 ps=0 w=5.5 l=10
X25 GND VB GND GND sky130_fd_pr__nfet_01v8 ad=1.65 pd=11.6 as=0 ps=0 w=5.5 l=10
X27 GND VB GND GND sky130_fd_pr__nfet_01v8 ad=1.65 pd=6.1 as=0 ps=0 w=5.5 l=10
X32 GND VB GND GND sky130_fd_pr__nfet_01v8 ad=1.65 pd=6.1 as=0 ps=0 w=5.5 l=10
X34 GND VB GND GND sky130_fd_pr__nfet_01v8 ad=1.65 pd=11.6 as=0 ps=0 w=5.5 l=10
X42 GND VB GND GND sky130_fd_pr__nfet_01v8 ad=1.65 pd=6.1 as=0 ps=0 w=5.5 l=10
X43 GND VB GND GND sky130_fd_pr__nfet_01v8 ad=1.65 pd=6.1 as=0 ps=0 w=5.5 l=10
X50 GND VB GND GND sky130_fd_pr__nfet_01v8 ad=1.65 pd=11.6 as=0 ps=0 w=5.5 l=10
X53 GND VB GND GND sky130_fd_pr__nfet_01v8 ad=1.65 pd=6.1 as=0 ps=0 w=5.5 l=10
X54 GND VB GND GND sky130_fd_pr__nfet_01v8 ad=1.65 pd=6.1 as=0 ps=0 w=5.5 l=10
X55 GND VB GND GND sky130_fd_pr__nfet_01v8 ad=1.65 pd=6.1 as=0 ps=0 w=5.5 l=10
X58 GND VB GND GND sky130_fd_pr__nfet_01v8 ad=1.65 pd=6.1 as=0 ps=0 w=5.5 l=10
X59 GND VB GND GND sky130_fd_pr__nfet_01v8 ad=1.65 pd=11.6 as=0 ps=0 w=5.5 l=10
X62 GND VB GND GND sky130_fd_pr__nfet_01v8 ad=1.65 pd=11.6 as=0 ps=0 w=5.5 l=10
X63 GND VB GND GND sky130_fd_pr__nfet_01v8 ad=1.65 pd=6.1 as=0 ps=0 w=5.5 l=10
X64 GND VB GND GND sky130_fd_pr__nfet_01v8 ad=1.65 pd=6.1 as=0 ps=0 w=5.5 l=10
X68 GND VB GND GND sky130_fd_pr__nfet_01v8 ad=1.65 pd=11.6 as=0 ps=0 w=5.5 l=10
X72 GND VB GND GND sky130_fd_pr__nfet_01v8 ad=1.65 pd=11.6 as=0 ps=0 w=5.5 l=10
X73 GND VB GND GND sky130_fd_pr__nfet_01v8 ad=1.65 pd=6.1 as=0 ps=0 w=5.5 l=10
X74 GND VB GND GND sky130_fd_pr__nfet_01v8 ad=1.65 pd=6.1 as=0 ps=0 w=5.5 l=10
X80 GND VB GND GND sky130_fd_pr__nfet_01v8 ad=1.65 pd=6.1 as=0 ps=0 w=5.5 l=10
X81 GND VB GND GND sky130_fd_pr__nfet_01v8 ad=1.65 pd=11.6 as=0 ps=0 w=5.5 l=10
X85 GND VB GND GND sky130_fd_pr__nfet_01v8 ad=1.65 pd=6.1 as=0 ps=0 w=5.5 l=10
X90 GND VB GND GND sky130_fd_pr__nfet_01v8 ad=1.65 pd=6.1 as=0 ps=0 w=5.5 l=10
X92 GND VB GND GND sky130_fd_pr__nfet_01v8 ad=1.65 pd=6.1 as=0 ps=0 w=5.5 l=10
X95 GND VB GND GND sky130_fd_pr__nfet_01v8 ad=1.65 pd=11.6 as=0 ps=0 w=5.5 l=10
X0 XB PREB VDD VDD sky130_fd_pr__pfet_01v8_hvt ad=0.126 pd=1.44 as=0.126 ps=1.44 w=0.42 l=0.5 sa=0.3 sb=0.3
X1 VB VB GND GND sky130_fd_pr__nfet_01v8 ad=0.126 pd=1.44 as=0.126 ps=1.44 w=0.42 l=0.15 sa=0.3 sb=0.3
X2 a_n2000_n1632# VB a_n2090_n1632# GND sky130_fd_pr__nfet_01v8 ad=0.126 pd=1.44 as=0.126 ps=1.44 w=0.42 l=0.15 sa=0.3 sb=0.3
X3 a_7130_n1632# VB a_7040_n2004# GND sky130_fd_pr__nfet_01v8 ad=0.126 pd=1.44 as=0.126 ps=1.44 w=0.42 l=0.15 sa=0.3 sb=0.3
X4 a_7130_n1632# VB a_7040_n2004# GND sky130_fd_pr__nfet_01v8 ad=0.126 pd=1.44 as=0.126 ps=1.44 w=0.42 l=0.15 sa=0.3 sb=0.3
X8 XA PREA VDD VDD sky130_fd_pr__pfet_01v8_hvt ad=0.126 pd=1.44 as=0.126 ps=1.44 w=0.42 l=0.5 sa=0.3 sb=0.3
X9 VB VB GND GND sky130_fd_pr__nfet_01v8 ad=0.126 pd=1.44 as=0.126 ps=1.44 w=0.42 l=0.15 sa=0.3 sb=0.3
X10 VB VB GND GND sky130_fd_pr__nfet_01v8 ad=0.126 pd=1.44 as=0.126 ps=1.44 w=0.42 l=0.15 sa=0.3 sb=0.3
X11 XA VB a_n2090_n1632# GND sky130_fd_pr__nfet_01v8 ad=0.126 pd=1.44 as=0.126 ps=1.44 w=0.42 l=0.15 sa=0.3 sb=0.3
X14 XA VB a_n2090_n1632# GND sky130_fd_pr__nfet_01v8 ad=0.126 pd=1.44 as=0.126 ps=1.44 w=0.42 l=0.15 sa=0.3 sb=0.3
X15 GND REFB a_7040_n2004# GND sky130_fd_pr__nfet_01v8 ad=0.252 pd=2.28 as=0.252 ps=2.28 w=0.84 l=0.15 sa=0.3 sb=0.3
X18 XB_OUT XB VDD VDD sky130_fd_pr__pfet_01v8 ad=0.3 pd=2.6 as=0.3 ps=2.6 w=1 l=0.15 sa=0.3 sb=0.3
X20 a_7650_n924# VDD XB VDD sky130_fd_pr__pfet_01v8 ad=0.126 pd=1.44 as=0.126 ps=1.44 w=0.42 l=0.15 sa=0.3 sb=0.3
X21 a_7130_n1632# VB XB GND sky130_fd_pr__nfet_01v8 ad=0.126 pd=1.44 as=0.126 ps=1.44 w=0.42 l=0.15 sa=0.3 sb=0.3
X22 a_7130_n1632# VB XB GND sky130_fd_pr__nfet_01v8 ad=0.126 pd=1.44 as=0.126 ps=1.44 w=0.42 l=0.15 sa=0.3 sb=0.3
X26 VB VB GND GND sky130_fd_pr__nfet_01v8 ad=0.126 pd=1.44 as=0.126 ps=1.44 w=0.42 l=0.15 sa=0.3 sb=0.3
X28 XB_OUT XB GND GND sky130_fd_pr__nfet_01v8 ad=0.195 pd=1.9 as=0.195 ps=1.9 w=0.65 l=0.15 sa=0.3 sb=0.3
X29 VB VB GND GND sky130_fd_pr__nfet_01v8 ad=0.126 pd=1.44 as=0.126 ps=1.44 w=0.42 l=0.15 sa=0.3 sb=0.3
X30 XA SA2B a_n1510_n924# VDD sky130_fd_pr__pfet_01v8 ad=0.126 pd=1.44 as=0.126 ps=1.44 w=0.42 l=0.15 sa=0.3 sb=0.3
X31 a_7370_n924# SB1B XB VDD sky130_fd_pr__pfet_01v8 ad=0.126 pd=1.44 as=0.126 ps=1.44 w=0.42 l=0.15 sa=0.3 sb=0.3
X33 VB VB GND GND sky130_fd_pr__nfet_01v8 ad=0.126 pd=1.44 as=0.126 ps=1.44 w=0.42 l=0.15 sa=0.3 sb=0.3
X35 a_n2000_n1632# VB a_n2090_n1632# GND sky130_fd_pr__nfet_01v8 ad=0.126 pd=1.44 as=0.126 ps=1.44 w=0.42 l=0.15 sa=0.3 sb=0.3
X36 VB VB GND GND sky130_fd_pr__nfet_01v8 ad=0.126 pd=1.44 as=0.126 ps=1.44 w=0.42 l=0.15 sa=0.3 sb=0.3
X37 XA GT a_3900_n392# GND sky130_fd_pr__nfet_01v8 ad=0.126 pd=1.44 as=0.126 ps=1.44 w=0.42 l=0.15 sa=0.3 sb=0.3
X38 a_7130_n1632# VB a_7040_n2004# GND sky130_fd_pr__nfet_01v8 ad=0.126 pd=1.44 as=0.126 ps=1.44 w=0.42 l=0.15 sa=0.3 sb=0.3
X39 XB VB a_4500_n392# GND sky130_fd_pr__nfet_01v8 ad=0.126 pd=1.44 as=0.126 ps=1.44 w=0.42 l=0.15 sa=0.3 sb=0.3
X40 XA SA1B a_n1230_n924# VDD sky130_fd_pr__pfet_01v8 ad=0.126 pd=1.44 as=0.126 ps=1.44 w=0.42 l=0.15 sa=0.3 sb=0.3
X41 a_7090_n924# SB0B XB VDD sky130_fd_pr__pfet_01v8 ad=0.126 pd=1.44 as=0.126 ps=1.44 w=0.42 l=0.15 sa=0.3 sb=0.3
X44 XA VB a_n2090_n1632# GND sky130_fd_pr__nfet_01v8 ad=0.126 pd=1.44 as=0.126 ps=1.44 w=0.42 l=0.15 sa=0.3 sb=0.3
X45 a_n2000_n1632# REFA GND GND sky130_fd_pr__nfet_01v8 ad=0.252 pd=2.28 as=0.252 ps=2.28 w=0.84 l=0.15 sa=0.3 sb=0.3
X46 VDD XA XA_OUT VDD sky130_fd_pr__pfet_01v8 ad=0.3 pd=2.6 as=0.3 ps=2.6 w=1 l=0.15 sa=0.3 sb=0.3
X47 VB VB GND GND sky130_fd_pr__nfet_01v8 ad=0.126 pd=1.44 as=0.126 ps=1.44 w=0.42 l=0.15 sa=0.3 sb=0.3
X48 XA SA0B a_n950_n924# VDD sky130_fd_pr__pfet_01v8 ad=0.126 pd=1.44 as=0.126 ps=1.44 w=0.42 l=0.15 sa=0.3 sb=0.3
X49 a_7130_n1632# VB XB GND sky130_fd_pr__nfet_01v8 ad=0.126 pd=1.44 as=0.126 ps=1.44 w=0.42 l=0.15 sa=0.3 sb=0.3
X51 VB VB GND GND sky130_fd_pr__nfet_01v8 ad=0.126 pd=1.44 as=0.126 ps=1.44 w=0.42 l=0.15 sa=0.3 sb=0.3
X52 VB VB GND GND sky130_fd_pr__nfet_01v8 ad=0.126 pd=1.44 as=0.126 ps=1.44 w=0.42 l=0.15 sa=0.3 sb=0.3
X56 GND XA XA_OUT GND sky130_fd_pr__nfet_01v8 ad=0.195 pd=1.9 as=0.195 ps=1.9 w=0.65 l=0.15 sa=0.3 sb=0.3
X57 VB VB GND GND sky130_fd_pr__nfet_01v8 ad=0.126 pd=1.44 as=0.126 ps=1.44 w=0.42 l=0.15 sa=0.3 sb=0.3
X60 a_n48_382# a_n48_382# VB GND sky130_fd_pr__nfet_01v8 ad=0.3 pd=2.6 as=0.3 ps=2.6 w=1 l=1 sa=0.3 sb=0.3
X61 a_7130_n1632# VB a_7040_n2004# GND sky130_fd_pr__nfet_01v8 ad=0.126 pd=1.44 as=0.126 ps=1.44 w=0.42 l=0.15 sa=0.3 sb=0.3
X65 VB VB GND GND sky130_fd_pr__nfet_01v8 ad=0.126 pd=1.44 as=0.126 ps=1.44 w=0.42 l=0.15 sa=0.3 sb=0.3
X66 a_n2000_n1632# VB a_n2090_n1632# GND sky130_fd_pr__nfet_01v8 ad=0.126 pd=1.44 as=0.126 ps=1.44 w=0.42 l=0.15 sa=0.3 sb=0.3
X67 a_n2000_n1632# VB a_n2090_n1632# GND sky130_fd_pr__nfet_01v8 ad=0.126 pd=1.44 as=0.126 ps=1.44 w=0.42 l=0.15 sa=0.3 sb=0.3
X69 GND DUTB a_4500_n392# GND sky130_fd_pr__nfet_01v8 ad=0.252 pd=2.28 as=0.252 ps=2.28 w=0.84 l=0.15 sa=0.3 sb=0.3
X70 a_7130_n1632# VB XB GND sky130_fd_pr__nfet_01v8 ad=0.126 pd=1.44 as=0.126 ps=1.44 w=0.42 l=0.15 sa=0.3 sb=0.3
X71 a_7130_n1632# VB a_7040_n2004# GND sky130_fd_pr__nfet_01v8 ad=0.126 pd=1.44 as=0.126 ps=1.44 w=0.42 l=0.15 sa=0.3 sb=0.3
X75 a_7130_n1632# VB a_7040_n2004# GND sky130_fd_pr__nfet_01v8 ad=0.126 pd=1.44 as=0.126 ps=1.44 w=0.42 l=0.15 sa=0.3 sb=0.3
X76 VB VB GND GND sky130_fd_pr__nfet_01v8 ad=0.126 pd=1.44 as=0.126 ps=1.44 w=0.42 l=0.15 sa=0.3 sb=0.3
X77 VB VB GND GND sky130_fd_pr__nfet_01v8 ad=0.126 pd=1.44 as=0.126 ps=1.44 w=0.42 l=0.15 sa=0.3 sb=0.3
X78 XA VB a_n2090_n1632# GND sky130_fd_pr__nfet_01v8 ad=0.126 pd=1.44 as=0.126 ps=1.44 w=0.42 l=0.15 sa=0.3 sb=0.3
X79 XA VB a_n2090_n1632# GND sky130_fd_pr__nfet_01v8 ad=0.126 pd=1.44 as=0.126 ps=1.44 w=0.42 l=0.15 sa=0.3 sb=0.3
X82 GND DUTA a_3900_n392# GND sky130_fd_pr__nfet_01v8 ad=0.252 pd=2.28 as=0.252 ps=2.28 w=0.84 l=0.15 sa=0.3 sb=0.3
X83 a_7130_n1632# VB XB GND sky130_fd_pr__nfet_01v8 ad=0.126 pd=1.44 as=0.126 ps=1.44 w=0.42 l=0.15 sa=0.3 sb=0.3
X84 a_7130_n1632# VB XB GND sky130_fd_pr__nfet_01v8 ad=0.126 pd=1.44 as=0.126 ps=1.44 w=0.42 l=0.15 sa=0.3 sb=0.3
X86 C1 C1 a_n48_382# GND sky130_fd_pr__nfet_01v8 ad=0.3 pd=2.6 as=0.3 ps=2.6 w=1 l=1 sa=0.3 sb=0.3
X87 VB VB GND GND sky130_fd_pr__nfet_01v8 ad=0.126 pd=1.44 as=0.126 ps=1.44 w=0.42 l=0.15 sa=0.3 sb=0.3
X88 VBIAS VBIAS C1 GND sky130_fd_pr__nfet_01v8 ad=0.3 pd=2.6 as=0.3 ps=2.6 w=1 l=1 sa=0.3 sb=0.3
X89 a_n2000_n1632# VB a_n2090_n1632# GND sky130_fd_pr__nfet_01v8 ad=0.126 pd=1.44 as=0.126 ps=1.44 w=0.42 l=0.15 sa=0.3 sb=0.3
X91 VB VB GND GND sky130_fd_pr__nfet_01v8 ad=0.126 pd=1.44 as=0.126 ps=1.44 w=0.42 l=0.15 sa=0.3 sb=0.3
X93 XA VB a_n2090_n1632# GND sky130_fd_pr__nfet_01v8 ad=0.126 pd=1.44 as=0.126 ps=1.44 w=0.42 l=0.15 sa=0.3 sb=0.3
X94 a_n2000_n1632# VB a_n2090_n1632# GND sky130_fd_pr__nfet_01v8 ad=0.126 pd=1.44 as=0.126 ps=1.44 w=0.42 l=0.15 sa=0.3 sb=0.3
C0 a_n950_n924# SA0B 0.00164f
C1 a_n950_n924# a_n1230_n924# 0.00251f
C2 VB PREA 0.00674f
C3 SA1B VDD 0.05165f
C4 VB SA2B 0
C5 a_n950_n924# XA 0.05363f
C6 CALA XA 0.59636f
C7 XB DUTA 0
C8 VDD SA0B 0.04538f
C9 SA1B SA0B 0.01827f
C10 VDD a_n1230_n924# 0.02524f
C11 VB DUTA 0.01701f
C12 XB CALB 0.60923f
C13 VDD PREB 0.17673f
C14 SA1B a_n1230_n924# 0.00999f
C15 a_n2000_n1632# REFA 0.00982f
C16 a_3900_n392# DUTA 0.00298f
C17 VDD XA 0.42588f
C18 SA1B XA 0.01535f
C19 CALB VB 0.01176f
C20 DUTB DUTA 0.00465f
C21 XB SB0B 0.01894f
C22 SA0B a_n1230_n924# 0.00126f
C23 SB0B a_7090_n924# 0.00164f
C24 VB REFA 0.00473f
C25 VDD PREA 0.17043f
C26 SA0B XA 0.01894f
C27 VB SB0B 0.00204f
C28 CALB DUTB 0
C29 VDD SA2B 0.05775f
C30 XA a_n1230_n924# 0.14938f
C31 SB0B a_7370_n924# 0.00126f
C32 SA1B SA2B 0.01827f
C33 PREB XA 0
C34 CALB CALA 0.00657f
C35 a_7040_n2004# SB0B 0
C36 VDD DUTA 0
C37 PREB PREA 0.00413f
C38 a_n1230_n924# SA2B 0.00165f
C39 XA PREA 0.02146f
C40 VDD CALB 0
C41 XA SA2B 0.01399f
C42 XB SB1B 0.01535f
C43 SB1B a_7090_n924# 0
C44 SB1B VB 0.00327f
C45 C1 a_n48_382# 0.05143f
C46 VDD SB0B 0.04538f
C47 SB1B a_7370_n924# 0.00999f
C48 XA DUTA 0.00921f
C49 a_n48_382# VB 0.06216f
C50 PREB CALB 0
C51 SB1B a_7130_n1632# 0
C52 CALB XA 0
C53 XA_OUT VB 0
C54 a_n1510_n924# a_n2090_n1632# 0.04223f
C55 VB REFB 0.00642f
C56 a_7130_n1632# REFB 0
C57 a_7040_n2004# REFB 0.00982f
C58 VDD SB1B 0.06992f
C59 VDD a_n48_382# 0.04849f
C60 XB a_7650_n924# 0.08426f
C61 XB a_4500_n392# 0.05778f
C62 VDD XA_OUT 0.11304f
C63 a_7650_n924# VB 0.02473f
C64 XB_OUT XB 0.02746f
C65 VB a_4500_n392# 0.0654f
C66 a_7650_n924# a_7370_n924# 0.11048f
C67 a_n2090_n1632# a_n2000_n1632# 0.44072f
C68 XB_OUT VB 0
C69 a_7650_n924# a_7130_n1632# 0.04223f
C70 a_4500_n392# DUTB 0.00298f
C71 a_n48_382# XA 0.0082f
C72 a_7040_n2004# a_7650_n924# 0.00146f
C73 a_n1510_n924# a_n2000_n1632# 0.00146f
C74 a_n2090_n1632# VB 0.41781f
C75 XA_OUT XA 0.02816f
C76 a_n1510_n924# VB 0.0246f
C77 VDD a_7650_n924# 0.07321f
C78 a_n2090_n1632# a_n950_n924# 0
C79 VDD a_4500_n392# 0.00496f
C80 XB_OUT VDD 0.1139f
C81 a_n2090_n1632# VDD 0.02312f
C82 SB1B SB0B 0.01827f
C83 SA1B a_n2090_n1632# 0
C84 C1 VBIAS 0.05143f
C85 a_n1510_n924# VDD 0.04424f
C86 VB VBIAS 0.00565f
C87 VB a_n2000_n1632# 0.14597f
C88 XB a_7090_n924# 0.05363f
C89 a_n2090_n1632# a_n1230_n924# 0.04617f
C90 XB VB 0.97066f
C91 C1 VB 0.00902f
C92 a_n2090_n1632# XA 0.42116f
C93 VB a_7090_n924# 0
C94 XB a_7370_n924# 0.14938f
C95 a_n1510_n924# a_n1230_n924# 0.11048f
C96 a_7370_n924# a_7090_n924# 0.00251f
C97 XB a_7130_n1632# 0.42116f
C98 VB a_7370_n924# 0.01419f
C99 a_n1510_n924# XA 0.08427f
C100 VB a_3900_n392# 0.07228f
C101 XB DUTB 0.01922f
C102 a_7130_n1632# a_7090_n924# 0
C103 a_4500_n392# DUTA 0
C104 a_7040_n2004# XB 0.00524f
C105 VB a_7130_n1632# 0.42696f
C106 a_n2090_n1632# SA2B 0
C107 XB CALA 0
C108 VB DUTB 0.01701f
C109 a_7130_n1632# a_7370_n924# 0.04617f
C110 a_7040_n2004# VB 0.14965f
C111 a_n950_n924# VB 0
C112 a_7040_n2004# a_7370_n924# 0.00104f
C113 VB CALA 0.01075f
C114 a_n1510_n924# SA2B 0.00999f
C115 VDD VBIAS 0.03241f
C116 a_3900_n392# CALA 0
C117 VDD a_n2000_n1632# 0
C118 a_7040_n2004# a_7130_n1632# 0.44072f
C119 VDD XB 0.47837f
C120 C1 VDD 0.04849f
C121 VDD a_7090_n924# 0.00372f
C122 VDD VB 0.37803f
C123 SA0B a_n2000_n1632# 0
C124 SA1B VB 0.00283f
C125 VDD a_7370_n924# 0.0269f
C126 a_n2000_n1632# a_n1230_n924# 0.00104f
C127 VDD a_3900_n392# 0.00496f
C128 a_n2090_n1632# REFA 0
C129 XA VBIAS 0.00599f
C130 VDD a_7130_n1632# 0.02379f
C131 XA a_n2000_n1632# 0.00524f
C132 XB PREB 0.0233f
C133 VDD DUTB 0
C134 VB SA0B 0
C135 VDD a_7040_n2004# 0
C136 XB XA 0.02337f
C137 C1 XA 0.00739f
C138 VB a_n1230_n924# 0.00964f
C139 VDD a_n950_n924# 0.00372f
C140 PREB VB 0.00674f
C141 SA1B a_n950_n924# 0
C142 VB XA 0.8449f
C143 a_n2000_n1632# SA2B 0
C144 a_3900_n392# XA 0.05981f
C145 CALB GND 0.28251f
C146 CALA GND 0.29501f
C147 REFB GND 0.20655f
C148 REFA GND 0.20801f
C149 SB1B GND 0.12644f
C150 SB0B GND 0.15202f
C151 SA0B GND 0.15406f
C152 SA1B GND 0.12684f
C153 SA2B GND 0.14679f
C154 DUTB GND 0.21831f
C155 DUTA GND 0.21794f
C156 XB_OUT GND 0.13753f
C157 PREB GND 0.10876f
C158 PREA GND 0.11529f
C159 VB GND 0.15539p
C160 XA_OUT GND 0.13768f
C161 XB GND 6.78211f
C162 VBIAS GND 0.5422f
C163 C1 GND 0.59586f
C164 XA GND 6.96986f
C165 VDD GND 10.8423f
C166 a_7040_n2004# GND 0.72315f
C167 a_7130_n1632# GND 1.04447f
C168 a_7650_n924# GND 0.28817f
C169 a_7370_n924# GND 0.23703f
C170 a_7090_n924# GND 0.01563f
C171 a_n2000_n1632# GND 0.72677f
C172 a_n2090_n1632# GND 1.05417f
C173 a_n950_n924# GND 0.01598f
C174 a_n1230_n924# GND 0.24157f
C175 a_n1510_n924# GND 0.297f
C176 a_4500_n392# GND 0.20468f
C177 a_3900_n392# GND 0.19922f
C178 a_n48_382# GND 0.59697f
.ends
Vd vdd 0 1.8
Vh hi 0 1.8
Vpre pre 0 pwl(0 1.8 1e-06 1.8 1.001e-06 0)
Vs1 s1 0 0
Vs0 s0 0 1.8
Vk k 0 0
* --- m0: trap
Xm0_ienn hi 0 0 vdd vdd m0_enn sky130_fd_sc_hd__inv_1
Xm0_is1n s1 0 0 vdd vdd m0_s1n sky130_fd_sc_hd__inv_1
Xm0_is0n s0 0 0 vdd vdd m0_s0n sky130_fd_sc_hd__inv_1
Xm0_PREA pre m0_enn 0 0 vdd vdd m0_PREA sky130_fd_sc_hd__nor2_1
Xm0_PREB pre m0_enn 0 0 vdd vdd m0_PREB sky130_fd_sc_hd__nor2_1
Xm0_VBIAS hi 0 0 vdd vdd m0_VBIAS sky130_fd_sc_hd__buf_2
Xm0_C1 hi 0 0 vdd vdd m0_C1 sky130_fd_sc_hd__buf_2
Xm0_DUTA hi m0_s1n s0 0 0 vdd vdd m0_DUTA sky130_fd_sc_hd__and3_1
Xm0_DUTB hi m0_s1n s0 0 0 vdd vdd m0_DUTB sky130_fd_sc_hd__and3_1
Xm0_REFA hi s1 0 0 vdd vdd m0_REFA sky130_fd_sc_hd__and2_1
Xm0_REFB hi s1 0 0 vdd vdd m0_REFB sky130_fd_sc_hd__and2_1
Xm0_SA0B hi s1 s0 0 0 vdd vdd m0_SA0B sky130_fd_sc_hd__nand3_1
Xm0_SA1B hi s1 0 0 vdd vdd m0_SA1B sky130_fd_sc_hd__nand2_1
Xm0_SA2B hi s1 m0_s0n 0 0 vdd vdd m0_SA2B sky130_fd_sc_hd__nand3_1
Xm0_SB0B hi s1 0 0 vdd vdd m0_SB0B sky130_fd_sc_hd__nand2_1
Xm0_SB1B hi s1 0 0 vdd vdd m0_SB1B sky130_fd_sc_hd__nand2_1
Xm0_M m0_ob m0_SB0B m0_SB1B m0_REFB m0_oa m0_SA0B m0_SA1B m0_SA2B m0_REFA vdd 0 m0_VBIAS m0_C1 m0_PREA m0_XA m0_DUTA m0_PREB m0_XB m0_DUTB m0_VB 0 0 m0_GT trap
Bm0_gt m0_GT 0 V=v(m0_VB)+0.000305*v(k)

* --- m1: trap
Xm1_ienn hi 0 0 vdd vdd m1_enn sky130_fd_sc_hd__inv_1
Xm1_is1n s1 0 0 vdd vdd m1_s1n sky130_fd_sc_hd__inv_1
Xm1_is0n s0 0 0 vdd vdd m1_s0n sky130_fd_sc_hd__inv_1
Xm1_PREA pre m1_enn 0 0 vdd vdd m1_PREA sky130_fd_sc_hd__nor2_1
Xm1_PREB pre m1_enn 0 0 vdd vdd m1_PREB sky130_fd_sc_hd__nor2_1
Xm1_VBIAS hi 0 0 vdd vdd m1_VBIAS sky130_fd_sc_hd__buf_2
Xm1_C1 hi 0 0 vdd vdd m1_C1 sky130_fd_sc_hd__buf_2
Xm1_DUTA hi m1_s1n s0 0 0 vdd vdd m1_DUTA sky130_fd_sc_hd__and3_1
Xm1_DUTB hi m1_s1n s0 0 0 vdd vdd m1_DUTB sky130_fd_sc_hd__and3_1
Xm1_REFA hi s1 0 0 vdd vdd m1_REFA sky130_fd_sc_hd__and2_1
Xm1_REFB hi s1 0 0 vdd vdd m1_REFB sky130_fd_sc_hd__and2_1
Xm1_SA0B hi s1 s0 0 0 vdd vdd m1_SA0B sky130_fd_sc_hd__nand3_1
Xm1_SA1B hi s1 0 0 vdd vdd m1_SA1B sky130_fd_sc_hd__nand2_1
Xm1_SA2B hi s1 m1_s0n 0 0 vdd vdd m1_SA2B sky130_fd_sc_hd__nand3_1
Xm1_SB0B hi s1 0 0 vdd vdd m1_SB0B sky130_fd_sc_hd__nand2_1
Xm1_SB1B hi s1 0 0 vdd vdd m1_SB1B sky130_fd_sc_hd__nand2_1
Xm1_M m1_ob m1_SB0B m1_SB1B m1_REFB m1_oa m1_SA0B m1_SA1B m1_SA2B m1_REFA vdd 0 m1_VBIAS m1_C1 m1_PREA m1_XA m1_DUTA m1_PREB m1_XB m1_DUTB m1_VB 0 0 m1_GT trap
Bm1_gt m1_GT 0 V=v(m1_VB)+0.000305*v(k)

* --- m2: trap
Xm2_ienn hi 0 0 vdd vdd m2_enn sky130_fd_sc_hd__inv_1
Xm2_is1n s1 0 0 vdd vdd m2_s1n sky130_fd_sc_hd__inv_1
Xm2_is0n s0 0 0 vdd vdd m2_s0n sky130_fd_sc_hd__inv_1
Xm2_PREA pre m2_enn 0 0 vdd vdd m2_PREA sky130_fd_sc_hd__nor2_1
Xm2_PREB pre m2_enn 0 0 vdd vdd m2_PREB sky130_fd_sc_hd__nor2_1
Xm2_VBIAS hi 0 0 vdd vdd m2_VBIAS sky130_fd_sc_hd__buf_2
Xm2_C1 hi 0 0 vdd vdd m2_C1 sky130_fd_sc_hd__buf_2
Xm2_DUTA hi m2_s1n s0 0 0 vdd vdd m2_DUTA sky130_fd_sc_hd__and3_1
Xm2_DUTB hi m2_s1n s0 0 0 vdd vdd m2_DUTB sky130_fd_sc_hd__and3_1
Xm2_REFA hi s1 0 0 vdd vdd m2_REFA sky130_fd_sc_hd__and2_1
Xm2_REFB hi s1 0 0 vdd vdd m2_REFB sky130_fd_sc_hd__and2_1
Xm2_SA0B hi s1 s0 0 0 vdd vdd m2_SA0B sky130_fd_sc_hd__nand3_1
Xm2_SA1B hi s1 0 0 vdd vdd m2_SA1B sky130_fd_sc_hd__nand2_1
Xm2_SA2B hi s1 m2_s0n 0 0 vdd vdd m2_SA2B sky130_fd_sc_hd__nand3_1
Xm2_SB0B hi s1 0 0 vdd vdd m2_SB0B sky130_fd_sc_hd__nand2_1
Xm2_SB1B hi s1 0 0 vdd vdd m2_SB1B sky130_fd_sc_hd__nand2_1
Xm2_M m2_ob m2_SB0B m2_SB1B m2_REFB m2_oa m2_SA0B m2_SA1B m2_SA2B m2_REFA vdd 0 m2_VBIAS m2_C1 m2_PREA m2_XA m2_DUTA m2_PREB m2_XB m2_DUTB m2_VB 0 0 m2_GT trap
Bm2_gt m2_GT 0 V=v(m2_VB)+0.000305*v(k)

* --- m3: trap
Xm3_ienn hi 0 0 vdd vdd m3_enn sky130_fd_sc_hd__inv_1
Xm3_is1n s1 0 0 vdd vdd m3_s1n sky130_fd_sc_hd__inv_1
Xm3_is0n s0 0 0 vdd vdd m3_s0n sky130_fd_sc_hd__inv_1
Xm3_PREA pre m3_enn 0 0 vdd vdd m3_PREA sky130_fd_sc_hd__nor2_1
Xm3_PREB pre m3_enn 0 0 vdd vdd m3_PREB sky130_fd_sc_hd__nor2_1
Xm3_VBIAS hi 0 0 vdd vdd m3_VBIAS sky130_fd_sc_hd__buf_2
Xm3_C1 hi 0 0 vdd vdd m3_C1 sky130_fd_sc_hd__buf_2
Xm3_DUTA hi m3_s1n s0 0 0 vdd vdd m3_DUTA sky130_fd_sc_hd__and3_1
Xm3_DUTB hi m3_s1n s0 0 0 vdd vdd m3_DUTB sky130_fd_sc_hd__and3_1
Xm3_REFA hi s1 0 0 vdd vdd m3_REFA sky130_fd_sc_hd__and2_1
Xm3_REFB hi s1 0 0 vdd vdd m3_REFB sky130_fd_sc_hd__and2_1
Xm3_SA0B hi s1 s0 0 0 vdd vdd m3_SA0B sky130_fd_sc_hd__nand3_1
Xm3_SA1B hi s1 0 0 vdd vdd m3_SA1B sky130_fd_sc_hd__nand2_1
Xm3_SA2B hi s1 m3_s0n 0 0 vdd vdd m3_SA2B sky130_fd_sc_hd__nand3_1
Xm3_SB0B hi s1 0 0 vdd vdd m3_SB0B sky130_fd_sc_hd__nand2_1
Xm3_SB1B hi s1 0 0 vdd vdd m3_SB1B sky130_fd_sc_hd__nand2_1
Xm3_M m3_ob m3_SB0B m3_SB1B m3_REFB m3_oa m3_SA0B m3_SA1B m3_SA2B m3_REFA vdd 0 m3_VBIAS m3_C1 m3_PREA m3_XA m3_DUTA m3_PREB m3_XB m3_DUTB m3_VB 0 0 m3_GT trap
Bm3_gt m3_GT 0 V=v(m3_VB)+0.000305*v(k)

* --- m4: trap
Xm4_ienn hi 0 0 vdd vdd m4_enn sky130_fd_sc_hd__inv_1
Xm4_is1n s1 0 0 vdd vdd m4_s1n sky130_fd_sc_hd__inv_1
Xm4_is0n s0 0 0 vdd vdd m4_s0n sky130_fd_sc_hd__inv_1
Xm4_PREA pre m4_enn 0 0 vdd vdd m4_PREA sky130_fd_sc_hd__nor2_1
Xm4_PREB pre m4_enn 0 0 vdd vdd m4_PREB sky130_fd_sc_hd__nor2_1
Xm4_VBIAS hi 0 0 vdd vdd m4_VBIAS sky130_fd_sc_hd__buf_2
Xm4_C1 hi 0 0 vdd vdd m4_C1 sky130_fd_sc_hd__buf_2
Xm4_DUTA hi m4_s1n s0 0 0 vdd vdd m4_DUTA sky130_fd_sc_hd__and3_1
Xm4_DUTB hi m4_s1n s0 0 0 vdd vdd m4_DUTB sky130_fd_sc_hd__and3_1
Xm4_REFA hi s1 0 0 vdd vdd m4_REFA sky130_fd_sc_hd__and2_1
Xm4_REFB hi s1 0 0 vdd vdd m4_REFB sky130_fd_sc_hd__and2_1
Xm4_SA0B hi s1 s0 0 0 vdd vdd m4_SA0B sky130_fd_sc_hd__nand3_1
Xm4_SA1B hi s1 0 0 vdd vdd m4_SA1B sky130_fd_sc_hd__nand2_1
Xm4_SA2B hi s1 m4_s0n 0 0 vdd vdd m4_SA2B sky130_fd_sc_hd__nand3_1
Xm4_SB0B hi s1 0 0 vdd vdd m4_SB0B sky130_fd_sc_hd__nand2_1
Xm4_SB1B hi s1 0 0 vdd vdd m4_SB1B sky130_fd_sc_hd__nand2_1
Xm4_M m4_ob m4_SB0B m4_SB1B m4_REFB m4_oa m4_SA0B m4_SA1B m4_SA2B m4_REFA vdd 0 m4_VBIAS m4_C1 m4_PREA m4_XA m4_DUTA m4_PREB m4_XB m4_DUTB m4_VB 0 0 m4_GT trap
Bm4_gt m4_GT 0 V=v(m4_VB)+0.000305*v(k)

* --- m5: trap
Xm5_ienn hi 0 0 vdd vdd m5_enn sky130_fd_sc_hd__inv_1
Xm5_is1n s1 0 0 vdd vdd m5_s1n sky130_fd_sc_hd__inv_1
Xm5_is0n s0 0 0 vdd vdd m5_s0n sky130_fd_sc_hd__inv_1
Xm5_PREA pre m5_enn 0 0 vdd vdd m5_PREA sky130_fd_sc_hd__nor2_1
Xm5_PREB pre m5_enn 0 0 vdd vdd m5_PREB sky130_fd_sc_hd__nor2_1
Xm5_VBIAS hi 0 0 vdd vdd m5_VBIAS sky130_fd_sc_hd__buf_2
Xm5_C1 hi 0 0 vdd vdd m5_C1 sky130_fd_sc_hd__buf_2
Xm5_DUTA hi m5_s1n s0 0 0 vdd vdd m5_DUTA sky130_fd_sc_hd__and3_1
Xm5_DUTB hi m5_s1n s0 0 0 vdd vdd m5_DUTB sky130_fd_sc_hd__and3_1
Xm5_REFA hi s1 0 0 vdd vdd m5_REFA sky130_fd_sc_hd__and2_1
Xm5_REFB hi s1 0 0 vdd vdd m5_REFB sky130_fd_sc_hd__and2_1
Xm5_SA0B hi s1 s0 0 0 vdd vdd m5_SA0B sky130_fd_sc_hd__nand3_1
Xm5_SA1B hi s1 0 0 vdd vdd m5_SA1B sky130_fd_sc_hd__nand2_1
Xm5_SA2B hi s1 m5_s0n 0 0 vdd vdd m5_SA2B sky130_fd_sc_hd__nand3_1
Xm5_SB0B hi s1 0 0 vdd vdd m5_SB0B sky130_fd_sc_hd__nand2_1
Xm5_SB1B hi s1 0 0 vdd vdd m5_SB1B sky130_fd_sc_hd__nand2_1
Xm5_M m5_ob m5_SB0B m5_SB1B m5_REFB m5_oa m5_SA0B m5_SA1B m5_SA2B m5_REFA vdd 0 m5_VBIAS m5_C1 m5_PREA m5_XA m5_DUTA m5_PREB m5_XB m5_DUTB m5_VB 0 0 m5_GT trap
Bm5_gt m5_GT 0 V=v(m5_VB)+0.000305*v(k)

.control
set noaskquit
setseed 2102
save v(m0_oa) v(m0_ob) v(m1_oa) v(m1_ob) v(m2_oa) v(m2_ob) v(m3_oa) v(m3_ob) v(m4_oa) v(m4_ob) v(m5_oa) v(m5_ob)
let i = 0
while i < 2
  reset
  alter Vs1 dc = 0
  alter Vs0 dc = 1.8
  alter Vk dc = 0
  tran 10n 200u 0 50n
  meas tran ta0 when v(m0_oa)=0.9 rise=1
  meas tran tb0 when v(m0_ob)=0.9 rise=1
  echo MC $&i e01 0 $&ta0 $&tb0
  meas tran ta1 when v(m1_oa)=0.9 rise=1
  meas tran tb1 when v(m1_ob)=0.9 rise=1
  echo MC $&i e01 1 $&ta1 $&tb1
  meas tran ta2 when v(m2_oa)=0.9 rise=1
  meas tran tb2 when v(m2_ob)=0.9 rise=1
  echo MC $&i e01 2 $&ta2 $&tb2
  meas tran ta3 when v(m3_oa)=0.9 rise=1
  meas tran tb3 when v(m3_ob)=0.9 rise=1
  echo MC $&i e01 3 $&ta3 $&tb3
  meas tran ta4 when v(m4_oa)=0.9 rise=1
  meas tran tb4 when v(m4_ob)=0.9 rise=1
  echo MC $&i e01 4 $&ta4 $&tb4
  meas tran ta5 when v(m5_oa)=0.9 rise=1
  meas tran tb5 when v(m5_ob)=0.9 rise=1
  echo MC $&i e01 5 $&ta5 $&tb5
  alter Vs1 dc = 0
  alter Vs0 dc = 1.8
  alter Vk dc = 1
  tran 10n 200u 0 50n
  meas tran ta0 when v(m0_oa)=0.9 rise=1
  meas tran tb0 when v(m0_ob)=0.9 rise=1
  echo MC $&i e01t 0 $&ta0 $&tb0
  meas tran ta1 when v(m1_oa)=0.9 rise=1
  meas tran tb1 when v(m1_ob)=0.9 rise=1
  echo MC $&i e01t 1 $&ta1 $&tb1
  meas tran ta2 when v(m2_oa)=0.9 rise=1
  meas tran tb2 when v(m2_ob)=0.9 rise=1
  echo MC $&i e01t 2 $&ta2 $&tb2
  meas tran ta3 when v(m3_oa)=0.9 rise=1
  meas tran tb3 when v(m3_ob)=0.9 rise=1
  echo MC $&i e01t 3 $&ta3 $&tb3
  meas tran ta4 when v(m4_oa)=0.9 rise=1
  meas tran tb4 when v(m4_ob)=0.9 rise=1
  echo MC $&i e01t 4 $&ta4 $&tb4
  meas tran ta5 when v(m5_oa)=0.9 rise=1
  meas tran tb5 when v(m5_ob)=0.9 rise=1
  echo MC $&i e01t 5 $&ta5 $&tb5
  alter Vs1 dc = 1.8
  alter Vs0 dc = 1.8
  alter Vk dc = 0
  tran 10n 200u 0 50n
  meas tran ta0 when v(m0_oa)=0.9 rise=1
  meas tran tb0 when v(m0_ob)=0.9 rise=1
  echo MC $&i e11 0 $&ta0 $&tb0
  meas tran ta1 when v(m1_oa)=0.9 rise=1
  meas tran tb1 when v(m1_ob)=0.9 rise=1
  echo MC $&i e11 1 $&ta1 $&tb1
  meas tran ta2 when v(m2_oa)=0.9 rise=1
  meas tran tb2 when v(m2_ob)=0.9 rise=1
  echo MC $&i e11 2 $&ta2 $&tb2
  meas tran ta3 when v(m3_oa)=0.9 rise=1
  meas tran tb3 when v(m3_ob)=0.9 rise=1
  echo MC $&i e11 3 $&ta3 $&tb3
  meas tran ta4 when v(m4_oa)=0.9 rise=1
  meas tran tb4 when v(m4_ob)=0.9 rise=1
  echo MC $&i e11 4 $&ta4 $&tb4
  meas tran ta5 when v(m5_oa)=0.9 rise=1
  meas tran tb5 when v(m5_ob)=0.9 rise=1
  echo MC $&i e11 5 $&ta5 $&tb5
  alter Vs1 dc = 1.8
  alter Vs0 dc = 0
  alter Vk dc = 0
  tran 10n 200u 0 50n
  meas tran ta0 when v(m0_oa)=0.9 rise=1
  meas tran tb0 when v(m0_ob)=0.9 rise=1
  echo MC $&i e10 0 $&ta0 $&tb0
  meas tran ta1 when v(m1_oa)=0.9 rise=1
  meas tran tb1 when v(m1_ob)=0.9 rise=1
  echo MC $&i e10 1 $&ta1 $&tb1
  meas tran ta2 when v(m2_oa)=0.9 rise=1
  meas tran tb2 when v(m2_ob)=0.9 rise=1
  echo MC $&i e10 2 $&ta2 $&tb2
  meas tran ta3 when v(m3_oa)=0.9 rise=1
  meas tran tb3 when v(m3_ob)=0.9 rise=1
  echo MC $&i e10 3 $&ta3 $&tb3
  meas tran ta4 when v(m4_oa)=0.9 rise=1
  meas tran tb4 when v(m4_ob)=0.9 rise=1
  echo MC $&i e10 4 $&ta4 $&tb4
  meas tran ta5 when v(m5_oa)=0.9 rise=1
  meas tran tb5 when v(m5_ob)=0.9 rise=1
  echo MC $&i e10 5 $&ta5 $&tb5
  let i = i + 1
end
quit
.endc
.end
