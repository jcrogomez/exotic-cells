* cadena ff -40
.lib /pdk/libs.tech/ngspice/sky130.lib.spice ff
.temp -40
.options gmin=1e-15
Vd vdd 0 1.8
Xk0a vdd vdd k0_c2 0 sky130_fd_pr__nfet_01v8 w=1 l=1
Xk0b k0_c2 k0_c2 k0_vb 0 sky130_fd_pr__nfet_01v8 w=1 l=1
Xk0m0 k0_vb k0_vb 0 0 sky130_fd_pr__nfet_01v8 w=0.42 l=0.15
Xk0m1 k0_vb k0_vb 0 0 sky130_fd_pr__nfet_01v8 w=0.42 l=0.15
Xk0m2 k0_vb k0_vb 0 0 sky130_fd_pr__nfet_01v8 w=0.42 l=0.15
Xk0m3 k0_vb k0_vb 0 0 sky130_fd_pr__nfet_01v8 w=0.42 l=0.15
Xk0m4 k0_vb k0_vb 0 0 sky130_fd_pr__nfet_01v8 w=0.42 l=0.15
Xk0m5 k0_vb k0_vb 0 0 sky130_fd_pr__nfet_01v8 w=0.42 l=0.15
Xk0m6 k0_vb k0_vb 0 0 sky130_fd_pr__nfet_01v8 w=0.42 l=0.15
Xk0m7 k0_vb k0_vb 0 0 sky130_fd_pr__nfet_01v8 w=0.42 l=0.15
Xk0m8 k0_vb k0_vb 0 0 sky130_fd_pr__nfet_01v8 w=0.42 l=0.15
Xk0m9 k0_vb k0_vb 0 0 sky130_fd_pr__nfet_01v8 w=0.42 l=0.15
Xk0m10 k0_vb k0_vb 0 0 sky130_fd_pr__nfet_01v8 w=0.42 l=0.15
Xk0m11 k0_vb k0_vb 0 0 sky130_fd_pr__nfet_01v8 w=0.42 l=0.15
Xk0m12 k0_vb k0_vb 0 0 sky130_fd_pr__nfet_01v8 w=0.42 l=0.15
Xk0m13 k0_vb k0_vb 0 0 sky130_fd_pr__nfet_01v8 w=0.42 l=0.15
Xk0m14 k0_vb k0_vb 0 0 sky130_fd_pr__nfet_01v8 w=0.42 l=0.15
Xk0m15 k0_vb k0_vb 0 0 sky130_fd_pr__nfet_01v8 w=0.42 l=0.15
Xk1t vdd vdd k1_t 0 sky130_fd_pr__nfet_01v8 w=1 l=1
Xk1a k1_t k1_t k1_c2 0 sky130_fd_pr__nfet_01v8 w=1 l=1
Xk1b k1_c2 k1_c2 k1_vb 0 sky130_fd_pr__nfet_01v8 w=1 l=1
Xk1m0 k1_vb k1_vb 0 0 sky130_fd_pr__nfet_01v8 w=0.42 l=0.15
Xk1m1 k1_vb k1_vb 0 0 sky130_fd_pr__nfet_01v8 w=0.42 l=0.15
Xk1m2 k1_vb k1_vb 0 0 sky130_fd_pr__nfet_01v8 w=0.42 l=0.15
Xk1m3 k1_vb k1_vb 0 0 sky130_fd_pr__nfet_01v8 w=0.42 l=0.15
Xk1m4 k1_vb k1_vb 0 0 sky130_fd_pr__nfet_01v8 w=0.42 l=0.15
Xk1m5 k1_vb k1_vb 0 0 sky130_fd_pr__nfet_01v8 w=0.42 l=0.15
Xk1m6 k1_vb k1_vb 0 0 sky130_fd_pr__nfet_01v8 w=0.42 l=0.15
Xk1m7 k1_vb k1_vb 0 0 sky130_fd_pr__nfet_01v8 w=0.42 l=0.15
Xk1m8 k1_vb k1_vb 0 0 sky130_fd_pr__nfet_01v8 w=0.42 l=0.15
Xk1m9 k1_vb k1_vb 0 0 sky130_fd_pr__nfet_01v8 w=0.42 l=0.15
Xk1m10 k1_vb k1_vb 0 0 sky130_fd_pr__nfet_01v8 w=0.42 l=0.15
Xk1m11 k1_vb k1_vb 0 0 sky130_fd_pr__nfet_01v8 w=0.42 l=0.15
Xk1m12 k1_vb k1_vb 0 0 sky130_fd_pr__nfet_01v8 w=0.42 l=0.15
Xk1m13 k1_vb k1_vb 0 0 sky130_fd_pr__nfet_01v8 w=0.42 l=0.15
Xk1m14 k1_vb k1_vb 0 0 sky130_fd_pr__nfet_01v8 w=0.42 l=0.15
Xk1m15 k1_vb k1_vb 0 0 sky130_fd_pr__nfet_01v8 w=0.42 l=0.15
Xk2t vdd vdd k2_t 0 sky130_fd_pr__nfet_01v8 w=2 l=1
Xk2a k2_t k2_t k2_c2 0 sky130_fd_pr__nfet_01v8 w=1 l=1
Xk2b k2_c2 k2_c2 k2_vb 0 sky130_fd_pr__nfet_01v8 w=1 l=1
Xk2m0 k2_vb k2_vb 0 0 sky130_fd_pr__nfet_01v8 w=0.42 l=0.15
Xk2m1 k2_vb k2_vb 0 0 sky130_fd_pr__nfet_01v8 w=0.42 l=0.15
Xk2m2 k2_vb k2_vb 0 0 sky130_fd_pr__nfet_01v8 w=0.42 l=0.15
Xk2m3 k2_vb k2_vb 0 0 sky130_fd_pr__nfet_01v8 w=0.42 l=0.15
Xk2m4 k2_vb k2_vb 0 0 sky130_fd_pr__nfet_01v8 w=0.42 l=0.15
Xk2m5 k2_vb k2_vb 0 0 sky130_fd_pr__nfet_01v8 w=0.42 l=0.15
Xk2m6 k2_vb k2_vb 0 0 sky130_fd_pr__nfet_01v8 w=0.42 l=0.15
Xk2m7 k2_vb k2_vb 0 0 sky130_fd_pr__nfet_01v8 w=0.42 l=0.15
Xk2m8 k2_vb k2_vb 0 0 sky130_fd_pr__nfet_01v8 w=0.42 l=0.15
Xk2m9 k2_vb k2_vb 0 0 sky130_fd_pr__nfet_01v8 w=0.42 l=0.15
Xk2m10 k2_vb k2_vb 0 0 sky130_fd_pr__nfet_01v8 w=0.42 l=0.15
Xk2m11 k2_vb k2_vb 0 0 sky130_fd_pr__nfet_01v8 w=0.42 l=0.15
Xk2m12 k2_vb k2_vb 0 0 sky130_fd_pr__nfet_01v8 w=0.42 l=0.15
Xk2m13 k2_vb k2_vb 0 0 sky130_fd_pr__nfet_01v8 w=0.42 l=0.15
Xk2m14 k2_vb k2_vb 0 0 sky130_fd_pr__nfet_01v8 w=0.42 l=0.15
Xk2m15 k2_vb k2_vb 0 0 sky130_fd_pr__nfet_01v8 w=0.42 l=0.15
Xk3t vdd vdd k3_t 0 sky130_fd_pr__nfet_01v8 w=4 l=1
Xk3a k3_t k3_t k3_c2 0 sky130_fd_pr__nfet_01v8 w=1 l=1
Xk3b k3_c2 k3_c2 k3_vb 0 sky130_fd_pr__nfet_01v8 w=1 l=1
Xk3m0 k3_vb k3_vb 0 0 sky130_fd_pr__nfet_01v8 w=0.42 l=0.15
Xk3m1 k3_vb k3_vb 0 0 sky130_fd_pr__nfet_01v8 w=0.42 l=0.15
Xk3m2 k3_vb k3_vb 0 0 sky130_fd_pr__nfet_01v8 w=0.42 l=0.15
Xk3m3 k3_vb k3_vb 0 0 sky130_fd_pr__nfet_01v8 w=0.42 l=0.15
Xk3m4 k3_vb k3_vb 0 0 sky130_fd_pr__nfet_01v8 w=0.42 l=0.15
Xk3m5 k3_vb k3_vb 0 0 sky130_fd_pr__nfet_01v8 w=0.42 l=0.15
Xk3m6 k3_vb k3_vb 0 0 sky130_fd_pr__nfet_01v8 w=0.42 l=0.15
Xk3m7 k3_vb k3_vb 0 0 sky130_fd_pr__nfet_01v8 w=0.42 l=0.15
Xk3m8 k3_vb k3_vb 0 0 sky130_fd_pr__nfet_01v8 w=0.42 l=0.15
Xk3m9 k3_vb k3_vb 0 0 sky130_fd_pr__nfet_01v8 w=0.42 l=0.15
Xk3m10 k3_vb k3_vb 0 0 sky130_fd_pr__nfet_01v8 w=0.42 l=0.15
Xk3m11 k3_vb k3_vb 0 0 sky130_fd_pr__nfet_01v8 w=0.42 l=0.15
Xk3m12 k3_vb k3_vb 0 0 sky130_fd_pr__nfet_01v8 w=0.42 l=0.15
Xk3m13 k3_vb k3_vb 0 0 sky130_fd_pr__nfet_01v8 w=0.42 l=0.15
Xk3m14 k3_vb k3_vb 0 0 sky130_fd_pr__nfet_01v8 w=0.42 l=0.15
Xk3m15 k3_vb k3_vb 0 0 sky130_fd_pr__nfet_01v8 w=0.42 l=0.15
Xk4t vdd vdd k4_t 0 sky130_fd_pr__nfet_01v8 w=8 l=1
Xk4a k4_t k4_t k4_c2 0 sky130_fd_pr__nfet_01v8 w=1 l=1
Xk4b k4_c2 k4_c2 k4_vb 0 sky130_fd_pr__nfet_01v8 w=1 l=1
Xk4m0 k4_vb k4_vb 0 0 sky130_fd_pr__nfet_01v8 w=0.42 l=0.15
Xk4m1 k4_vb k4_vb 0 0 sky130_fd_pr__nfet_01v8 w=0.42 l=0.15
Xk4m2 k4_vb k4_vb 0 0 sky130_fd_pr__nfet_01v8 w=0.42 l=0.15
Xk4m3 k4_vb k4_vb 0 0 sky130_fd_pr__nfet_01v8 w=0.42 l=0.15
Xk4m4 k4_vb k4_vb 0 0 sky130_fd_pr__nfet_01v8 w=0.42 l=0.15
Xk4m5 k4_vb k4_vb 0 0 sky130_fd_pr__nfet_01v8 w=0.42 l=0.15
Xk4m6 k4_vb k4_vb 0 0 sky130_fd_pr__nfet_01v8 w=0.42 l=0.15
Xk4m7 k4_vb k4_vb 0 0 sky130_fd_pr__nfet_01v8 w=0.42 l=0.15
Xk4m8 k4_vb k4_vb 0 0 sky130_fd_pr__nfet_01v8 w=0.42 l=0.15
Xk4m9 k4_vb k4_vb 0 0 sky130_fd_pr__nfet_01v8 w=0.42 l=0.15
Xk4m10 k4_vb k4_vb 0 0 sky130_fd_pr__nfet_01v8 w=0.42 l=0.15
Xk4m11 k4_vb k4_vb 0 0 sky130_fd_pr__nfet_01v8 w=0.42 l=0.15
Xk4m12 k4_vb k4_vb 0 0 sky130_fd_pr__nfet_01v8 w=0.42 l=0.15
Xk4m13 k4_vb k4_vb 0 0 sky130_fd_pr__nfet_01v8 w=0.42 l=0.15
Xk4m14 k4_vb k4_vb 0 0 sky130_fd_pr__nfet_01v8 w=0.42 l=0.15
Xk4m15 k4_vb k4_vb 0 0 sky130_fd_pr__nfet_01v8 w=0.42 l=0.15
Xk5t vdd vdd k5_t 0 sky130_fd_pr__nfet_01v8 w=16 l=1
Xk5a k5_t k5_t k5_c2 0 sky130_fd_pr__nfet_01v8 w=1 l=1
Xk5b k5_c2 k5_c2 k5_vb 0 sky130_fd_pr__nfet_01v8 w=1 l=1
Xk5m0 k5_vb k5_vb 0 0 sky130_fd_pr__nfet_01v8 w=0.42 l=0.15
Xk5m1 k5_vb k5_vb 0 0 sky130_fd_pr__nfet_01v8 w=0.42 l=0.15
Xk5m2 k5_vb k5_vb 0 0 sky130_fd_pr__nfet_01v8 w=0.42 l=0.15
Xk5m3 k5_vb k5_vb 0 0 sky130_fd_pr__nfet_01v8 w=0.42 l=0.15
Xk5m4 k5_vb k5_vb 0 0 sky130_fd_pr__nfet_01v8 w=0.42 l=0.15
Xk5m5 k5_vb k5_vb 0 0 sky130_fd_pr__nfet_01v8 w=0.42 l=0.15
Xk5m6 k5_vb k5_vb 0 0 sky130_fd_pr__nfet_01v8 w=0.42 l=0.15
Xk5m7 k5_vb k5_vb 0 0 sky130_fd_pr__nfet_01v8 w=0.42 l=0.15
Xk5m8 k5_vb k5_vb 0 0 sky130_fd_pr__nfet_01v8 w=0.42 l=0.15
Xk5m9 k5_vb k5_vb 0 0 sky130_fd_pr__nfet_01v8 w=0.42 l=0.15
Xk5m10 k5_vb k5_vb 0 0 sky130_fd_pr__nfet_01v8 w=0.42 l=0.15
Xk5m11 k5_vb k5_vb 0 0 sky130_fd_pr__nfet_01v8 w=0.42 l=0.15
Xk5m12 k5_vb k5_vb 0 0 sky130_fd_pr__nfet_01v8 w=0.42 l=0.15
Xk5m13 k5_vb k5_vb 0 0 sky130_fd_pr__nfet_01v8 w=0.42 l=0.15
Xk5m14 k5_vb k5_vb 0 0 sky130_fd_pr__nfet_01v8 w=0.42 l=0.15
Xk5m15 k5_vb k5_vb 0 0 sky130_fd_pr__nfet_01v8 w=0.42 l=0.15
Xk6t vdd vdd k6_t 0 sky130_fd_pr__nfet_01v8 w=32 l=1
Xk6a k6_t k6_t k6_c2 0 sky130_fd_pr__nfet_01v8 w=1 l=1
Xk6b k6_c2 k6_c2 k6_vb 0 sky130_fd_pr__nfet_01v8 w=1 l=1
Xk6m0 k6_vb k6_vb 0 0 sky130_fd_pr__nfet_01v8 w=0.42 l=0.15
Xk6m1 k6_vb k6_vb 0 0 sky130_fd_pr__nfet_01v8 w=0.42 l=0.15
Xk6m2 k6_vb k6_vb 0 0 sky130_fd_pr__nfet_01v8 w=0.42 l=0.15
Xk6m3 k6_vb k6_vb 0 0 sky130_fd_pr__nfet_01v8 w=0.42 l=0.15
Xk6m4 k6_vb k6_vb 0 0 sky130_fd_pr__nfet_01v8 w=0.42 l=0.15
Xk6m5 k6_vb k6_vb 0 0 sky130_fd_pr__nfet_01v8 w=0.42 l=0.15
Xk6m6 k6_vb k6_vb 0 0 sky130_fd_pr__nfet_01v8 w=0.42 l=0.15
Xk6m7 k6_vb k6_vb 0 0 sky130_fd_pr__nfet_01v8 w=0.42 l=0.15
Xk6m8 k6_vb k6_vb 0 0 sky130_fd_pr__nfet_01v8 w=0.42 l=0.15
Xk6m9 k6_vb k6_vb 0 0 sky130_fd_pr__nfet_01v8 w=0.42 l=0.15
Xk6m10 k6_vb k6_vb 0 0 sky130_fd_pr__nfet_01v8 w=0.42 l=0.15
Xk6m11 k6_vb k6_vb 0 0 sky130_fd_pr__nfet_01v8 w=0.42 l=0.15
Xk6m12 k6_vb k6_vb 0 0 sky130_fd_pr__nfet_01v8 w=0.42 l=0.15
Xk6m13 k6_vb k6_vb 0 0 sky130_fd_pr__nfet_01v8 w=0.42 l=0.15
Xk6m14 k6_vb k6_vb 0 0 sky130_fd_pr__nfet_01v8 w=0.42 l=0.15
Xk6m15 k6_vb k6_vb 0 0 sky130_fd_pr__nfet_01v8 w=0.42 l=0.15
Xk7t vdd vdd k7_t 0 sky130_fd_pr__nfet_01v8 w=64 l=1
Xk7a k7_t k7_t k7_c2 0 sky130_fd_pr__nfet_01v8 w=1 l=1
Xk7b k7_c2 k7_c2 k7_vb 0 sky130_fd_pr__nfet_01v8 w=1 l=1
Xk7m0 k7_vb k7_vb 0 0 sky130_fd_pr__nfet_01v8 w=0.42 l=0.15
Xk7m1 k7_vb k7_vb 0 0 sky130_fd_pr__nfet_01v8 w=0.42 l=0.15
Xk7m2 k7_vb k7_vb 0 0 sky130_fd_pr__nfet_01v8 w=0.42 l=0.15
Xk7m3 k7_vb k7_vb 0 0 sky130_fd_pr__nfet_01v8 w=0.42 l=0.15
Xk7m4 k7_vb k7_vb 0 0 sky130_fd_pr__nfet_01v8 w=0.42 l=0.15
Xk7m5 k7_vb k7_vb 0 0 sky130_fd_pr__nfet_01v8 w=0.42 l=0.15
Xk7m6 k7_vb k7_vb 0 0 sky130_fd_pr__nfet_01v8 w=0.42 l=0.15
Xk7m7 k7_vb k7_vb 0 0 sky130_fd_pr__nfet_01v8 w=0.42 l=0.15
Xk7m8 k7_vb k7_vb 0 0 sky130_fd_pr__nfet_01v8 w=0.42 l=0.15
Xk7m9 k7_vb k7_vb 0 0 sky130_fd_pr__nfet_01v8 w=0.42 l=0.15
Xk7m10 k7_vb k7_vb 0 0 sky130_fd_pr__nfet_01v8 w=0.42 l=0.15
Xk7m11 k7_vb k7_vb 0 0 sky130_fd_pr__nfet_01v8 w=0.42 l=0.15
Xk7m12 k7_vb k7_vb 0 0 sky130_fd_pr__nfet_01v8 w=0.42 l=0.15
Xk7m13 k7_vb k7_vb 0 0 sky130_fd_pr__nfet_01v8 w=0.42 l=0.15
Xk7m14 k7_vb k7_vb 0 0 sky130_fd_pr__nfet_01v8 w=0.42 l=0.15
Xk7m15 k7_vb k7_vb 0 0 sky130_fd_pr__nfet_01v8 w=0.42 l=0.15
.control
op
print v(k0_vb) v(k1_vb) v(k2_vb) v(k3_vb) v(k4_vb) v(k5_vb) v(k6_vb) v(k7_vb)
quit
.endc
.end
