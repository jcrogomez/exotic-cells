* MISFIT-03 etapa a · MISFIT-04 I4 pasada 5 · esquina tt 27 C. Generado por gen_contrato.py (no editar a mano).
* Macro: cells/xc19_slot_core/xc19_slot_core_lod.inc (Magic, extraccion con capacidades, LOD anotado por Residual).
* Decodificador: celdas sky130_fd_sc_hd en SPICE (E7). El contador es aritmetico: cuentas = (t_xa - t_pre) * 50 MHz.
.lib /pdk/libs.tech/ngspice/sky130.lib.spice tt
.include /pdk/libs.ref/sky130_fd_sc_hd/spice/sky130_fd_sc_hd.spice
.options gmin=1e-18 abstol=1e-15 reltol=1e-5 method=gear
.temp 27
.subckt core XB_OUT SB0B SB1B REFB XA_OUT SA0B SA1B SA2B REFA VDD GND VBIAS C1 PREA XA DUTA PREB XB DUTB VB CALA CALB
X5 GND VB GND GND sky130_fd_pr__nfet_01v8 ad=1.65 pd=6.1 as=117.474 ps=596.35999 w=5.5 l=10
X6 GND VB GND GND sky130_fd_pr__nfet_01v8 ad=1.65 pd=6.1 as=0 ps=0 w=5.5 l=10
X7 GND XB GND GND sky130_fd_pr__nfet_01v8 ad=1.29 pd=9.2 as=0 ps=0 w=4.3 l=4
X12 GND VB GND GND sky130_fd_pr__nfet_01v8 ad=1.65 pd=6.1 as=0 ps=0 w=5.5 l=10
X13 GND VB GND GND sky130_fd_pr__nfet_01v8 ad=1.65 pd=11.6 as=0 ps=0 w=5.5 l=10
X16 GND VB GND GND sky130_fd_pr__nfet_01v8 ad=1.65 pd=11.6 as=0 ps=0 w=5.5 l=10
X17 GND VB GND GND sky130_fd_pr__nfet_01v8 ad=1.65 pd=6.1 as=0 ps=0 w=5.5 l=10
X19 GND XA GND GND sky130_fd_pr__nfet_01v8 ad=1.29 pd=9.2 as=0 ps=0 w=4.3 l=4
X23 GND VB GND GND sky130_fd_pr__nfet_01v8 ad=1.65 pd=6.1 as=0 ps=0 w=5.5 l=10
X24 GND VB GND GND sky130_fd_pr__nfet_01v8 ad=1.65 pd=6.1 as=0 ps=0 w=5.5 l=10
X25 GND VB GND GND sky130_fd_pr__nfet_01v8 ad=1.65 pd=11.6 as=0 ps=0 w=5.5 l=10
X27 GND VB GND GND sky130_fd_pr__nfet_01v8 ad=1.65 pd=6.1 as=0 ps=0 w=5.5 l=10
X32 GND VB GND GND sky130_fd_pr__nfet_01v8 ad=1.65 pd=6.1 as=0 ps=0 w=5.5 l=10
X34 GND VB GND GND sky130_fd_pr__nfet_01v8 ad=1.65 pd=11.6 as=0 ps=0 w=5.5 l=10
X42 GND VB GND GND sky130_fd_pr__nfet_01v8 ad=1.65 pd=6.1 as=0 ps=0 w=5.5 l=10
X43 GND VB GND GND sky130_fd_pr__nfet_01v8 ad=1.65 pd=6.1 as=0 ps=0 w=5.5 l=10
X50 GND VB GND GND sky130_fd_pr__nfet_01v8 ad=1.65 pd=11.6 as=0 ps=0 w=5.5 l=10
X53 GND VB GND GND sky130_fd_pr__nfet_01v8 ad=1.65 pd=6.1 as=0 ps=0 w=5.5 l=10
X54 GND VB GND GND sky130_fd_pr__nfet_01v8 ad=1.65 pd=6.1 as=0 ps=0 w=5.5 l=10
X55 GND VB GND GND sky130_fd_pr__nfet_01v8 ad=1.65 pd=6.1 as=0 ps=0 w=5.5 l=10
X58 GND VB GND GND sky130_fd_pr__nfet_01v8 ad=1.65 pd=6.1 as=0 ps=0 w=5.5 l=10
X59 GND VB GND GND sky130_fd_pr__nfet_01v8 ad=1.65 pd=11.6 as=0 ps=0 w=5.5 l=10
X62 GND VB GND GND sky130_fd_pr__nfet_01v8 ad=1.65 pd=11.6 as=0 ps=0 w=5.5 l=10
X63 GND VB GND GND sky130_fd_pr__nfet_01v8 ad=1.65 pd=6.1 as=0 ps=0 w=5.5 l=10
X64 GND VB GND GND sky130_fd_pr__nfet_01v8 ad=1.65 pd=6.1 as=0 ps=0 w=5.5 l=10
X68 GND VB GND GND sky130_fd_pr__nfet_01v8 ad=1.65 pd=11.6 as=0 ps=0 w=5.5 l=10
X72 GND VB GND GND sky130_fd_pr__nfet_01v8 ad=1.65 pd=11.6 as=0 ps=0 w=5.5 l=10
X73 GND VB GND GND sky130_fd_pr__nfet_01v8 ad=1.65 pd=6.1 as=0 ps=0 w=5.5 l=10
X74 GND VB GND GND sky130_fd_pr__nfet_01v8 ad=1.65 pd=6.1 as=0 ps=0 w=5.5 l=10
X80 GND VB GND GND sky130_fd_pr__nfet_01v8 ad=1.65 pd=6.1 as=0 ps=0 w=5.5 l=10
X81 GND VB GND GND sky130_fd_pr__nfet_01v8 ad=1.65 pd=11.6 as=0 ps=0 w=5.5 l=10
X85 GND VB GND GND sky130_fd_pr__nfet_01v8 ad=1.65 pd=6.1 as=0 ps=0 w=5.5 l=10
X90 GND VB GND GND sky130_fd_pr__nfet_01v8 ad=1.65 pd=6.1 as=0 ps=0 w=5.5 l=10
X92 GND VB GND GND sky130_fd_pr__nfet_01v8 ad=1.65 pd=6.1 as=0 ps=0 w=5.5 l=10
X95 GND VB GND GND sky130_fd_pr__nfet_01v8 ad=1.65 pd=11.6 as=0 ps=0 w=5.5 l=10
X0 XB PREB VDD VDD sky130_fd_pr__pfet_01v8_hvt ad=0.126 pd=1.44 as=0.126 ps=1.44 w=0.42 l=0.5 sa=0.3 sb=0.3
X1 VB VB GND GND sky130_fd_pr__nfet_01v8 ad=0.126 pd=1.44 as=0.126 ps=1.44 w=0.42 l=0.15 sa=0.3 sb=0.3
X2 a_n2000_n1632# VB a_n2090_n1632# GND sky130_fd_pr__nfet_01v8 ad=0.126 pd=1.44 as=0.126 ps=1.44 w=0.42 l=0.15 sa=0.3 sb=0.3
X3 a_7130_n1632# VB a_7040_n2004# GND sky130_fd_pr__nfet_01v8 ad=0.126 pd=1.44 as=0.126 ps=1.44 w=0.42 l=0.15 sa=0.3 sb=0.3
X4 a_7130_n1632# VB a_7040_n2004# GND sky130_fd_pr__nfet_01v8 ad=0.126 pd=1.44 as=0.126 ps=1.44 w=0.42 l=0.15 sa=0.3 sb=0.3
X8 XA PREA VDD VDD sky130_fd_pr__pfet_01v8_hvt ad=0.126 pd=1.44 as=0.126 ps=1.44 w=0.42 l=0.5 sa=0.3 sb=0.3
X9 VB VB GND GND sky130_fd_pr__nfet_01v8 ad=0.126 pd=1.44 as=0.126 ps=1.44 w=0.42 l=0.15 sa=0.3 sb=0.3
X10 VB VB GND GND sky130_fd_pr__nfet_01v8 ad=0.126 pd=1.44 as=0.126 ps=1.44 w=0.42 l=0.15 sa=0.3 sb=0.3
X11 XA VB a_n2090_n1632# GND sky130_fd_pr__nfet_01v8 ad=0.126 pd=1.44 as=0.126 ps=1.44 w=0.42 l=0.15 sa=0.3 sb=0.3
X14 XA VB a_n2090_n1632# GND sky130_fd_pr__nfet_01v8 ad=0.126 pd=1.44 as=0.126 ps=1.44 w=0.42 l=0.15 sa=0.3 sb=0.3
X15 GND REFB a_7040_n2004# GND sky130_fd_pr__nfet_01v8 ad=0.252 pd=2.28 as=0.252 ps=2.28 w=0.84 l=0.15 sa=0.3 sb=0.3
X18 XB_OUT XB VDD VDD sky130_fd_pr__pfet_01v8 ad=0.3 pd=2.6 as=0.3 ps=2.6 w=1 l=0.15 sa=0.3 sb=0.3
X20 a_7650_n924# VDD XB VDD sky130_fd_pr__pfet_01v8 ad=0.126 pd=1.44 as=0.126 ps=1.44 w=0.42 l=0.15 sa=0.3 sb=0.3
X21 a_7130_n1632# VB XB GND sky130_fd_pr__nfet_01v8 ad=0.126 pd=1.44 as=0.126 ps=1.44 w=0.42 l=0.15 sa=0.3 sb=0.3
X22 a_7130_n1632# VB XB GND sky130_fd_pr__nfet_01v8 ad=0.126 pd=1.44 as=0.126 ps=1.44 w=0.42 l=0.15 sa=0.3 sb=0.3
X26 VB VB GND GND sky130_fd_pr__nfet_01v8 ad=0.126 pd=1.44 as=0.126 ps=1.44 w=0.42 l=0.15 sa=0.3 sb=0.3
X28 XB_OUT XB GND GND sky130_fd_pr__nfet_01v8 ad=0.195 pd=1.9 as=0.195 ps=1.9 w=0.65 l=0.15 sa=0.3 sb=0.3
X29 VB VB GND GND sky130_fd_pr__nfet_01v8 ad=0.126 pd=1.44 as=0.126 ps=1.44 w=0.42 l=0.15 sa=0.3 sb=0.3
X30 XA SA2B a_n1510_n924# VDD sky130_fd_pr__pfet_01v8 ad=0.126 pd=1.44 as=0.126 ps=1.44 w=0.42 l=0.15 sa=0.3 sb=0.3
X31 a_7370_n924# SB1B XB VDD sky130_fd_pr__pfet_01v8 ad=0.126 pd=1.44 as=0.126 ps=1.44 w=0.42 l=0.15 sa=0.3 sb=0.3
X33 VB VB GND GND sky130_fd_pr__nfet_01v8 ad=0.126 pd=1.44 as=0.126 ps=1.44 w=0.42 l=0.15 sa=0.3 sb=0.3
X35 a_n2000_n1632# VB a_n2090_n1632# GND sky130_fd_pr__nfet_01v8 ad=0.126 pd=1.44 as=0.126 ps=1.44 w=0.42 l=0.15 sa=0.3 sb=0.3
X36 VB VB GND GND sky130_fd_pr__nfet_01v8 ad=0.126 pd=1.44 as=0.126 ps=1.44 w=0.42 l=0.15 sa=0.3 sb=0.3
X37 XA VB a_3900_n392# GND sky130_fd_pr__nfet_01v8 ad=0.126 pd=1.44 as=0.126 ps=1.44 w=0.42 l=0.15 sa=0.3 sb=0.3
X38 a_7130_n1632# VB a_7040_n2004# GND sky130_fd_pr__nfet_01v8 ad=0.126 pd=1.44 as=0.126 ps=1.44 w=0.42 l=0.15 sa=0.3 sb=0.3
X39 XB VB a_4500_n392# GND sky130_fd_pr__nfet_01v8 ad=0.126 pd=1.44 as=0.126 ps=1.44 w=0.42 l=0.15 sa=0.3 sb=0.3
X40 XA SA1B a_n1230_n924# VDD sky130_fd_pr__pfet_01v8 ad=0.126 pd=1.44 as=0.126 ps=1.44 w=0.42 l=0.15 sa=0.3 sb=0.3
X41 a_7090_n924# SB0B XB VDD sky130_fd_pr__pfet_01v8 ad=0.126 pd=1.44 as=0.126 ps=1.44 w=0.42 l=0.15 sa=0.3 sb=0.3
X44 XA VB a_n2090_n1632# GND sky130_fd_pr__nfet_01v8 ad=0.126 pd=1.44 as=0.126 ps=1.44 w=0.42 l=0.15 sa=0.3 sb=0.3
X45 a_n2000_n1632# REFA GND GND sky130_fd_pr__nfet_01v8 ad=0.252 pd=2.28 as=0.252 ps=2.28 w=0.84 l=0.15 sa=0.3 sb=0.3
X46 VDD XA XA_OUT VDD sky130_fd_pr__pfet_01v8 ad=0.3 pd=2.6 as=0.3 ps=2.6 w=1 l=0.15 sa=0.3 sb=0.3
X47 VB VB GND GND sky130_fd_pr__nfet_01v8 ad=0.126 pd=1.44 as=0.126 ps=1.44 w=0.42 l=0.15 sa=0.3 sb=0.3
X48 XA SA0B a_n950_n924# VDD sky130_fd_pr__pfet_01v8 ad=0.126 pd=1.44 as=0.126 ps=1.44 w=0.42 l=0.15 sa=0.3 sb=0.3
X49 a_7130_n1632# VB XB GND sky130_fd_pr__nfet_01v8 ad=0.126 pd=1.44 as=0.126 ps=1.44 w=0.42 l=0.15 sa=0.3 sb=0.3
X51 VB VB GND GND sky130_fd_pr__nfet_01v8 ad=0.126 pd=1.44 as=0.126 ps=1.44 w=0.42 l=0.15 sa=0.3 sb=0.3
X52 VB VB GND GND sky130_fd_pr__nfet_01v8 ad=0.126 pd=1.44 as=0.126 ps=1.44 w=0.42 l=0.15 sa=0.3 sb=0.3
X56 GND XA XA_OUT GND sky130_fd_pr__nfet_01v8 ad=0.195 pd=1.9 as=0.195 ps=1.9 w=0.65 l=0.15 sa=0.3 sb=0.3
X57 VB VB GND GND sky130_fd_pr__nfet_01v8 ad=0.126 pd=1.44 as=0.126 ps=1.44 w=0.42 l=0.15 sa=0.3 sb=0.3
X60 a_n48_382# a_n48_382# VB GND sky130_fd_pr__nfet_01v8 ad=0.3 pd=2.6 as=0.3 ps=2.6 w=1 l=1 sa=0.3 sb=0.3
X61 a_7130_n1632# VB a_7040_n2004# GND sky130_fd_pr__nfet_01v8 ad=0.126 pd=1.44 as=0.126 ps=1.44 w=0.42 l=0.15 sa=0.3 sb=0.3
X65 VB VB GND GND sky130_fd_pr__nfet_01v8 ad=0.126 pd=1.44 as=0.126 ps=1.44 w=0.42 l=0.15 sa=0.3 sb=0.3
X66 a_n2000_n1632# VB a_n2090_n1632# GND sky130_fd_pr__nfet_01v8 ad=0.126 pd=1.44 as=0.126 ps=1.44 w=0.42 l=0.15 sa=0.3 sb=0.3
X67 a_n2000_n1632# VB a_n2090_n1632# GND sky130_fd_pr__nfet_01v8 ad=0.126 pd=1.44 as=0.126 ps=1.44 w=0.42 l=0.15 sa=0.3 sb=0.3
X69 GND DUTB a_4500_n392# GND sky130_fd_pr__nfet_01v8 ad=0.252 pd=2.28 as=0.252 ps=2.28 w=0.84 l=0.15 sa=0.3 sb=0.3
X70 a_7130_n1632# VB XB GND sky130_fd_pr__nfet_01v8 ad=0.126 pd=1.44 as=0.126 ps=1.44 w=0.42 l=0.15 sa=0.3 sb=0.3
X71 a_7130_n1632# VB a_7040_n2004# GND sky130_fd_pr__nfet_01v8 ad=0.126 pd=1.44 as=0.126 ps=1.44 w=0.42 l=0.15 sa=0.3 sb=0.3
X75 a_7130_n1632# VB a_7040_n2004# GND sky130_fd_pr__nfet_01v8 ad=0.126 pd=1.44 as=0.126 ps=1.44 w=0.42 l=0.15 sa=0.3 sb=0.3
X76 VB VB GND GND sky130_fd_pr__nfet_01v8 ad=0.126 pd=1.44 as=0.126 ps=1.44 w=0.42 l=0.15 sa=0.3 sb=0.3
X77 VB VB GND GND sky130_fd_pr__nfet_01v8 ad=0.126 pd=1.44 as=0.126 ps=1.44 w=0.42 l=0.15 sa=0.3 sb=0.3
X78 XA VB a_n2090_n1632# GND sky130_fd_pr__nfet_01v8 ad=0.126 pd=1.44 as=0.126 ps=1.44 w=0.42 l=0.15 sa=0.3 sb=0.3
X79 XA VB a_n2090_n1632# GND sky130_fd_pr__nfet_01v8 ad=0.126 pd=1.44 as=0.126 ps=1.44 w=0.42 l=0.15 sa=0.3 sb=0.3
X82 GND DUTA a_3900_n392# GND sky130_fd_pr__nfet_01v8 ad=0.252 pd=2.28 as=0.252 ps=2.28 w=0.84 l=0.15 sa=0.3 sb=0.3
X83 a_7130_n1632# VB XB GND sky130_fd_pr__nfet_01v8 ad=0.126 pd=1.44 as=0.126 ps=1.44 w=0.42 l=0.15 sa=0.3 sb=0.3
X84 a_7130_n1632# VB XB GND sky130_fd_pr__nfet_01v8 ad=0.126 pd=1.44 as=0.126 ps=1.44 w=0.42 l=0.15 sa=0.3 sb=0.3
X86 C1 C1 a_n48_382# GND sky130_fd_pr__nfet_01v8 ad=0.3 pd=2.6 as=0.3 ps=2.6 w=1 l=1 sa=0.3 sb=0.3
X87 VB VB GND GND sky130_fd_pr__nfet_01v8 ad=0.126 pd=1.44 as=0.126 ps=1.44 w=0.42 l=0.15 sa=0.3 sb=0.3
X88 VBIAS VBIAS C1 GND sky130_fd_pr__nfet_01v8 ad=0.3 pd=2.6 as=0.3 ps=2.6 w=1 l=1 sa=0.3 sb=0.3
X89 a_n2000_n1632# VB a_n2090_n1632# GND sky130_fd_pr__nfet_01v8 ad=0.126 pd=1.44 as=0.126 ps=1.44 w=0.42 l=0.15 sa=0.3 sb=0.3
X91 VB VB GND GND sky130_fd_pr__nfet_01v8 ad=0.126 pd=1.44 as=0.126 ps=1.44 w=0.42 l=0.15 sa=0.3 sb=0.3
X93 XA VB a_n2090_n1632# GND sky130_fd_pr__nfet_01v8 ad=0.126 pd=1.44 as=0.126 ps=1.44 w=0.42 l=0.15 sa=0.3 sb=0.3
X94 a_n2000_n1632# VB a_n2090_n1632# GND sky130_fd_pr__nfet_01v8 ad=0.126 pd=1.44 as=0.126 ps=1.44 w=0.42 l=0.15 sa=0.3 sb=0.3
C0 a_n950_n924# SA0B 0.00164f
C1 a_n950_n924# a_n1230_n924# 0.00251f
C2 VB PREA 0.00674f
C3 SA1B VDD 0.05165f
C4 VB SA2B 0
C5 a_n950_n924# XA 0.05363f
C6 CALA XA 0.59636f
C7 XB DUTA 0
C8 VDD SA0B 0.04538f
C9 SA1B SA0B 0.01827f
C10 VDD a_n1230_n924# 0.02524f
C11 VB DUTA 0.01701f
C12 XB CALB 0.60923f
C13 VDD PREB 0.17673f
C14 SA1B a_n1230_n924# 0.00999f
C15 a_n2000_n1632# REFA 0.00982f
C16 a_3900_n392# DUTA 0.00298f
C17 VDD XA 0.42588f
C18 SA1B XA 0.01535f
C19 CALB VB 0.01176f
C20 DUTB DUTA 0.00465f
C21 XB SB0B 0.01894f
C22 SA0B a_n1230_n924# 0.00126f
C23 SB0B a_7090_n924# 0.00164f
C24 VB REFA 0.00473f
C25 VDD PREA 0.17043f
C26 SA0B XA 0.01894f
C27 VB SB0B 0.00204f
C28 CALB DUTB 0
C29 VDD SA2B 0.05775f
C30 XA a_n1230_n924# 0.14938f
C31 SB0B a_7370_n924# 0.00126f
C32 SA1B SA2B 0.01827f
C33 PREB XA 0
C34 CALB CALA 0.00657f
C35 a_7040_n2004# SB0B 0
C36 VDD DUTA 0
C37 PREB PREA 0.00413f
C38 a_n1230_n924# SA2B 0.00165f
C39 XA PREA 0.02146f
C40 VDD CALB 0
C41 XA SA2B 0.01399f
C42 XB SB1B 0.01535f
C43 SB1B a_7090_n924# 0
C44 SB1B VB 0.00327f
C45 C1 a_n48_382# 0.05143f
C46 VDD SB0B 0.04538f
C47 SB1B a_7370_n924# 0.00999f
C48 XA DUTA 0.00921f
C49 a_n48_382# VB 0.06216f
C50 PREB CALB 0
C51 SB1B a_7130_n1632# 0
C52 CALB XA 0
C53 XA_OUT VB 0
C54 a_n1510_n924# a_n2090_n1632# 0.04223f
C55 VB REFB 0.00642f
C56 a_7130_n1632# REFB 0
C57 a_7040_n2004# REFB 0.00982f
C58 VDD SB1B 0.06992f
C59 VDD a_n48_382# 0.04849f
C60 XB a_7650_n924# 0.08426f
C61 XB a_4500_n392# 0.05778f
C62 VDD XA_OUT 0.11304f
C63 a_7650_n924# VB 0.02473f
C64 XB_OUT XB 0.02746f
C65 VB a_4500_n392# 0.0654f
C66 a_7650_n924# a_7370_n924# 0.11048f
C67 a_n2090_n1632# a_n2000_n1632# 0.44072f
C68 XB_OUT VB 0
C69 a_7650_n924# a_7130_n1632# 0.04223f
C70 a_4500_n392# DUTB 0.00298f
C71 a_n48_382# XA 0.0082f
C72 a_7040_n2004# a_7650_n924# 0.00146f
C73 a_n1510_n924# a_n2000_n1632# 0.00146f
C74 a_n2090_n1632# VB 0.41781f
C75 XA_OUT XA 0.02816f
C76 a_n1510_n924# VB 0.0246f
C77 VDD a_7650_n924# 0.07321f
C78 a_n2090_n1632# a_n950_n924# 0
C79 VDD a_4500_n392# 0.00496f
C80 XB_OUT VDD 0.1139f
C81 a_n2090_n1632# VDD 0.02312f
C82 SB1B SB0B 0.01827f
C83 SA1B a_n2090_n1632# 0
C84 C1 VBIAS 0.05143f
C85 a_n1510_n924# VDD 0.04424f
C86 VB VBIAS 0.00565f
C87 VB a_n2000_n1632# 0.14597f
C88 XB a_7090_n924# 0.05363f
C89 a_n2090_n1632# a_n1230_n924# 0.04617f
C90 XB VB 0.97066f
C91 C1 VB 0.00902f
C92 a_n2090_n1632# XA 0.42116f
C93 VB a_7090_n924# 0
C94 XB a_7370_n924# 0.14938f
C95 a_n1510_n924# a_n1230_n924# 0.11048f
C96 a_7370_n924# a_7090_n924# 0.00251f
C97 XB a_7130_n1632# 0.42116f
C98 VB a_7370_n924# 0.01419f
C99 a_n1510_n924# XA 0.08427f
C100 VB a_3900_n392# 0.07228f
C101 XB DUTB 0.01922f
C102 a_7130_n1632# a_7090_n924# 0
C103 a_4500_n392# DUTA 0
C104 a_7040_n2004# XB 0.00524f
C105 VB a_7130_n1632# 0.42696f
C106 a_n2090_n1632# SA2B 0
C107 XB CALA 0
C108 VB DUTB 0.01701f
C109 a_7130_n1632# a_7370_n924# 0.04617f
C110 a_7040_n2004# VB 0.14965f
C111 a_n950_n924# VB 0
C112 a_7040_n2004# a_7370_n924# 0.00104f
C113 VB CALA 0.01075f
C114 a_n1510_n924# SA2B 0.00999f
C115 VDD VBIAS 0.03241f
C116 a_3900_n392# CALA 0
C117 VDD a_n2000_n1632# 0
C118 a_7040_n2004# a_7130_n1632# 0.44072f
C119 VDD XB 0.47837f
C120 C1 VDD 0.04849f
C121 VDD a_7090_n924# 0.00372f
C122 VDD VB 0.37803f
C123 SA0B a_n2000_n1632# 0
C124 SA1B VB 0.00283f
C125 VDD a_7370_n924# 0.0269f
C126 a_n2000_n1632# a_n1230_n924# 0.00104f
C127 VDD a_3900_n392# 0.00496f
C128 a_n2090_n1632# REFA 0
C129 XA VBIAS 0.00599f
C130 VDD a_7130_n1632# 0.02379f
C131 XA a_n2000_n1632# 0.00524f
C132 XB PREB 0.0233f
C133 VDD DUTB 0
C134 VB SA0B 0
C135 VDD a_7040_n2004# 0
C136 XB XA 0.02337f
C137 C1 XA 0.00739f
C138 VB a_n1230_n924# 0.00964f
C139 VDD a_n950_n924# 0.00372f
C140 PREB VB 0.00674f
C141 SA1B a_n950_n924# 0
C142 VB XA 0.8449f
C143 a_n2000_n1632# SA2B 0
C144 a_3900_n392# XA 0.05981f
C145 CALB GND 0.28251f
C146 CALA GND 0.29501f
C147 REFB GND 0.20655f
C148 REFA GND 0.20801f
C149 SB1B GND 0.12644f
C150 SB0B GND 0.15202f
C151 SA0B GND 0.15406f
C152 SA1B GND 0.12684f
C153 SA2B GND 0.14679f
C154 DUTB GND 0.21831f
C155 DUTA GND 0.21794f
C156 XB_OUT GND 0.13753f
C157 PREB GND 0.10876f
C158 PREA GND 0.11529f
C159 VB GND 0.15539p
C160 XA_OUT GND 0.13768f
C161 XB GND 6.78211f
C162 VBIAS GND 0.5422f
C163 C1 GND 0.59586f
C164 XA GND 6.96986f
C165 VDD GND 10.8423f
C166 a_7040_n2004# GND 0.72315f
C167 a_7130_n1632# GND 1.04447f
C168 a_7650_n924# GND 0.28817f
C169 a_7370_n924# GND 0.23703f
C170 a_7090_n924# GND 0.01563f
C171 a_n2000_n1632# GND 0.72677f
C172 a_n2090_n1632# GND 1.05417f
C173 a_n950_n924# GND 0.01598f
C174 a_n1230_n924# GND 0.24157f
C175 a_n1510_n924# GND 0.297f
C176 a_4500_n392# GND 0.20468f
C177 a_3900_n392# GND 0.19922f
C178 a_n48_382# GND 0.59697f
.ends
Vd vdd 0 1.8
Vh hi 0 1.8
Vpre pre 0 pwl(0 1.8 1e-06 1.8 1.001e-06 0)
* --- c: core
Xc_ienn hi 0 0 vdd vdd c_enn sky130_fd_sc_hd__inv_1
Xc_is1n 0 0 0 vdd vdd c_s1n sky130_fd_sc_hd__inv_1
Xc_is0n hi 0 0 vdd vdd c_s0n sky130_fd_sc_hd__inv_1
Xc_PREA pre c_enn 0 0 vdd vdd c_PREA sky130_fd_sc_hd__nor2_1
Xc_PREB pre c_enn 0 0 vdd vdd c_PREB sky130_fd_sc_hd__nor2_1
Xc_VBIAS hi 0 0 vdd vdd c_VBIAS sky130_fd_sc_hd__buf_2
Xc_C1 hi 0 0 vdd vdd c_C1 sky130_fd_sc_hd__buf_2
Xc_DUTA hi c_s1n hi 0 0 vdd vdd c_DUTA sky130_fd_sc_hd__and3_1
Xc_DUTB hi c_s1n hi 0 0 vdd vdd c_DUTB sky130_fd_sc_hd__and3_1
Xc_REFA hi 0 0 0 vdd vdd c_REFA sky130_fd_sc_hd__and2_1
Xc_REFB hi 0 0 0 vdd vdd c_REFB sky130_fd_sc_hd__and2_1
Xc_SA0B hi 0 hi 0 0 vdd vdd c_SA0B sky130_fd_sc_hd__nand3_1
Xc_SA1B hi 0 0 0 vdd vdd c_SA1B sky130_fd_sc_hd__nand2_1
Xc_SA2B hi 0 c_s0n 0 0 vdd vdd c_SA2B sky130_fd_sc_hd__nand3_1
Xc_SB0B hi 0 0 0 vdd vdd c_SB0B sky130_fd_sc_hd__nand2_1
Xc_SB1B hi 0 0 0 vdd vdd c_SB1B sky130_fd_sc_hd__nand2_1
Xc_M c_ob c_SB0B c_SB1B c_REFB c_oa c_SA0B c_SA1B c_SA2B c_REFA vdd 0 c_VBIAS c_C1 c_PREA c_XA c_DUTA c_PREB c_XB c_DUTB c_VB 0 0 core

* --- q: core
Xq_ienn hi 0 0 vdd vdd q_enn sky130_fd_sc_hd__inv_1
Xq_is1n 0 0 0 vdd vdd q_s1n sky130_fd_sc_hd__inv_1
Xq_is0n hi 0 0 vdd vdd q_s0n sky130_fd_sc_hd__inv_1
Xq_PREA pre q_enn 0 0 vdd vdd q_PREA sky130_fd_sc_hd__nor2_1
Xq_PREB pre q_enn 0 0 vdd vdd q_PREB sky130_fd_sc_hd__nor2_1
Xq_VBIAS hi 0 0 vdd vdd q_VBIAS sky130_fd_sc_hd__buf_2
Xq_C1 hi 0 0 vdd vdd q_C1 sky130_fd_sc_hd__buf_2
Xq_DUTA hi q_s1n hi 0 0 vdd vdd q_DUTA sky130_fd_sc_hd__and3_1
Xq_DUTB hi q_s1n hi 0 0 vdd vdd q_DUTB sky130_fd_sc_hd__and3_1
Xq_REFA hi 0 0 0 vdd vdd q_REFA sky130_fd_sc_hd__and2_1
Xq_REFB hi 0 0 0 vdd vdd q_REFB sky130_fd_sc_hd__and2_1
Xq_SA0B hi 0 hi 0 0 vdd vdd q_SA0B sky130_fd_sc_hd__nand3_1
Xq_SA1B hi 0 0 0 vdd vdd q_SA1B sky130_fd_sc_hd__nand2_1
Xq_SA2B hi 0 q_s0n 0 0 vdd vdd q_SA2B sky130_fd_sc_hd__nand3_1
Xq_SB0B hi 0 0 0 vdd vdd q_SB0B sky130_fd_sc_hd__nand2_1
Xq_SB1B hi 0 0 0 vdd vdd q_SB1B sky130_fd_sc_hd__nand2_1
Xq_M q_ob q_SB0B q_SB1B q_REFB q_oa q_SA0B q_SA1B q_SA2B q_REFA vdd 0 q_VBIAS q_C1 q_PREA q_XA q_DUTA q_PREB q_XB q_DUTB q_VB 0 0 core

Cq_XAoa q_XA q_oa 3.4540e-17
Cq_XBob q_XB q_ob 3.3840e-17
Cq_XAXB q_XA q_XB 2.3370e-17
Vq_ag685 q_ag685 0 1.8
Vq_agin2 q_agin2 0 0
Vq_agin3 q_agin3 0 0
Cq_ag685ob q_ag685 q_ob 6.9200e-18
Cq_agin3oa q_agin3 q_oa 6.1390e-17
Cq_agin3ob q_agin3 q_ob 5.5900e-17
Cq_agin2oa q_agin2 q_oa 4.1100e-18
* --- l80f14: core
Xl80f14_ienn hi 0 0 vdd vdd l80f14_enn sky130_fd_sc_hd__inv_1
Xl80f14_is1n 0 0 0 vdd vdd l80f14_s1n sky130_fd_sc_hd__inv_1
Xl80f14_is0n hi 0 0 vdd vdd l80f14_s0n sky130_fd_sc_hd__inv_1
Xl80f14_PREA pre l80f14_enn 0 0 vdd vdd l80f14_PREA sky130_fd_sc_hd__nor2_1
Xl80f14_PREB pre l80f14_enn 0 0 vdd vdd l80f14_PREB sky130_fd_sc_hd__nor2_1
Xl80f14_VBIAS hi 0 0 vdd vdd l80f14_VBIAS sky130_fd_sc_hd__buf_2
Xl80f14_C1 hi 0 0 vdd vdd l80f14_C1 sky130_fd_sc_hd__buf_2
Xl80f14_DUTA hi l80f14_s1n hi 0 0 vdd vdd l80f14_DUTA sky130_fd_sc_hd__and3_1
Xl80f14_DUTB hi l80f14_s1n hi 0 0 vdd vdd l80f14_DUTB sky130_fd_sc_hd__and3_1
Xl80f14_REFA hi 0 0 0 vdd vdd l80f14_REFA sky130_fd_sc_hd__and2_1
Xl80f14_REFB hi 0 0 0 vdd vdd l80f14_REFB sky130_fd_sc_hd__and2_1
Xl80f14_SA0B hi 0 hi 0 0 vdd vdd l80f14_SA0B sky130_fd_sc_hd__nand3_1
Xl80f14_SA1B hi 0 0 0 vdd vdd l80f14_SA1B sky130_fd_sc_hd__nand2_1
Xl80f14_SA2B hi 0 l80f14_s0n 0 0 vdd vdd l80f14_SA2B sky130_fd_sc_hd__nand3_1
Xl80f14_SB0B hi 0 0 0 vdd vdd l80f14_SB0B sky130_fd_sc_hd__nand2_1
Xl80f14_SB1B hi 0 0 0 vdd vdd l80f14_SB1B sky130_fd_sc_hd__nand2_1
Xl80f14_M l80f14_ob l80f14_SB0B l80f14_SB1B l80f14_REFB l80f14_oa l80f14_SA0B l80f14_SA1B l80f14_SA2B l80f14_REFA vdd 0 l80f14_VBIAS l80f14_C1 l80f14_PREA l80f14_XA l80f14_DUTA l80f14_PREB l80f14_XB l80f14_DUTB l80f14_VB 0 0 core

Cl80f14_XAoa l80f14_XA l80f14_oa 3.4540e-17
Cl80f14_XBob l80f14_XB l80f14_ob 3.3840e-17
Cl80f14_XAXB l80f14_XA l80f14_XB 2.3370e-17
Vl80f14_ag685 l80f14_ag685 0 1.8
Vl80f14_agin2 l80f14_agin2 0 0
Vl80f14_agin3 l80f14_agin3 0 0
Cl80f14_ag685ob l80f14_ag685 l80f14_ob 6.9200e-18
Cl80f14_agin3oa l80f14_agin3 l80f14_oa 6.1390e-17
Cl80f14_agin3ob l80f14_agin3 l80f14_ob 5.5900e-17
Cl80f14_agin2oa l80f14_agin2 l80f14_oa 4.1100e-18
Vl80f14_clk l80f14_clk 0 pulse(0 1.8 14n 1e-10 1e-10 9.9000e-09 20n)
Cl80f14_s7 l80f14_clk l80f14_XA 2.3818e-16
* --- l80f16: core
Xl80f16_ienn hi 0 0 vdd vdd l80f16_enn sky130_fd_sc_hd__inv_1
Xl80f16_is1n 0 0 0 vdd vdd l80f16_s1n sky130_fd_sc_hd__inv_1
Xl80f16_is0n hi 0 0 vdd vdd l80f16_s0n sky130_fd_sc_hd__inv_1
Xl80f16_PREA pre l80f16_enn 0 0 vdd vdd l80f16_PREA sky130_fd_sc_hd__nor2_1
Xl80f16_PREB pre l80f16_enn 0 0 vdd vdd l80f16_PREB sky130_fd_sc_hd__nor2_1
Xl80f16_VBIAS hi 0 0 vdd vdd l80f16_VBIAS sky130_fd_sc_hd__buf_2
Xl80f16_C1 hi 0 0 vdd vdd l80f16_C1 sky130_fd_sc_hd__buf_2
Xl80f16_DUTA hi l80f16_s1n hi 0 0 vdd vdd l80f16_DUTA sky130_fd_sc_hd__and3_1
Xl80f16_DUTB hi l80f16_s1n hi 0 0 vdd vdd l80f16_DUTB sky130_fd_sc_hd__and3_1
Xl80f16_REFA hi 0 0 0 vdd vdd l80f16_REFA sky130_fd_sc_hd__and2_1
Xl80f16_REFB hi 0 0 0 vdd vdd l80f16_REFB sky130_fd_sc_hd__and2_1
Xl80f16_SA0B hi 0 hi 0 0 vdd vdd l80f16_SA0B sky130_fd_sc_hd__nand3_1
Xl80f16_SA1B hi 0 0 0 vdd vdd l80f16_SA1B sky130_fd_sc_hd__nand2_1
Xl80f16_SA2B hi 0 l80f16_s0n 0 0 vdd vdd l80f16_SA2B sky130_fd_sc_hd__nand3_1
Xl80f16_SB0B hi 0 0 0 vdd vdd l80f16_SB0B sky130_fd_sc_hd__nand2_1
Xl80f16_SB1B hi 0 0 0 vdd vdd l80f16_SB1B sky130_fd_sc_hd__nand2_1
Xl80f16_M l80f16_ob l80f16_SB0B l80f16_SB1B l80f16_REFB l80f16_oa l80f16_SA0B l80f16_SA1B l80f16_SA2B l80f16_REFA vdd 0 l80f16_VBIAS l80f16_C1 l80f16_PREA l80f16_XA l80f16_DUTA l80f16_PREB l80f16_XB l80f16_DUTB l80f16_VB 0 0 core

Cl80f16_XAoa l80f16_XA l80f16_oa 3.4540e-17
Cl80f16_XBob l80f16_XB l80f16_ob 3.3840e-17
Cl80f16_XAXB l80f16_XA l80f16_XB 2.3370e-17
Vl80f16_ag685 l80f16_ag685 0 1.8
Vl80f16_agin2 l80f16_agin2 0 0
Vl80f16_agin3 l80f16_agin3 0 0
Cl80f16_ag685ob l80f16_ag685 l80f16_ob 6.9200e-18
Cl80f16_agin3oa l80f16_agin3 l80f16_oa 6.1390e-17
Cl80f16_agin3ob l80f16_agin3 l80f16_ob 5.5900e-17
Cl80f16_agin2oa l80f16_agin2 l80f16_oa 4.1100e-18
Vl80f16_clk l80f16_clk 0 pulse(0 1.8 16n 1e-10 1e-10 9.9000e-09 20n)
Cl80f16_s7 l80f16_clk l80f16_XA 2.3818e-16
* --- l80f18: core
Xl80f18_ienn hi 0 0 vdd vdd l80f18_enn sky130_fd_sc_hd__inv_1
Xl80f18_is1n 0 0 0 vdd vdd l80f18_s1n sky130_fd_sc_hd__inv_1
Xl80f18_is0n hi 0 0 vdd vdd l80f18_s0n sky130_fd_sc_hd__inv_1
Xl80f18_PREA pre l80f18_enn 0 0 vdd vdd l80f18_PREA sky130_fd_sc_hd__nor2_1
Xl80f18_PREB pre l80f18_enn 0 0 vdd vdd l80f18_PREB sky130_fd_sc_hd__nor2_1
Xl80f18_VBIAS hi 0 0 vdd vdd l80f18_VBIAS sky130_fd_sc_hd__buf_2
Xl80f18_C1 hi 0 0 vdd vdd l80f18_C1 sky130_fd_sc_hd__buf_2
Xl80f18_DUTA hi l80f18_s1n hi 0 0 vdd vdd l80f18_DUTA sky130_fd_sc_hd__and3_1
Xl80f18_DUTB hi l80f18_s1n hi 0 0 vdd vdd l80f18_DUTB sky130_fd_sc_hd__and3_1
Xl80f18_REFA hi 0 0 0 vdd vdd l80f18_REFA sky130_fd_sc_hd__and2_1
Xl80f18_REFB hi 0 0 0 vdd vdd l80f18_REFB sky130_fd_sc_hd__and2_1
Xl80f18_SA0B hi 0 hi 0 0 vdd vdd l80f18_SA0B sky130_fd_sc_hd__nand3_1
Xl80f18_SA1B hi 0 0 0 vdd vdd l80f18_SA1B sky130_fd_sc_hd__nand2_1
Xl80f18_SA2B hi 0 l80f18_s0n 0 0 vdd vdd l80f18_SA2B sky130_fd_sc_hd__nand3_1
Xl80f18_SB0B hi 0 0 0 vdd vdd l80f18_SB0B sky130_fd_sc_hd__nand2_1
Xl80f18_SB1B hi 0 0 0 vdd vdd l80f18_SB1B sky130_fd_sc_hd__nand2_1
Xl80f18_M l80f18_ob l80f18_SB0B l80f18_SB1B l80f18_REFB l80f18_oa l80f18_SA0B l80f18_SA1B l80f18_SA2B l80f18_REFA vdd 0 l80f18_VBIAS l80f18_C1 l80f18_PREA l80f18_XA l80f18_DUTA l80f18_PREB l80f18_XB l80f18_DUTB l80f18_VB 0 0 core

Cl80f18_XAoa l80f18_XA l80f18_oa 3.4540e-17
Cl80f18_XBob l80f18_XB l80f18_ob 3.3840e-17
Cl80f18_XAXB l80f18_XA l80f18_XB 2.3370e-17
Vl80f18_ag685 l80f18_ag685 0 1.8
Vl80f18_agin2 l80f18_agin2 0 0
Vl80f18_agin3 l80f18_agin3 0 0
Cl80f18_ag685ob l80f18_ag685 l80f18_ob 6.9200e-18
Cl80f18_agin3oa l80f18_agin3 l80f18_oa 6.1390e-17
Cl80f18_agin3ob l80f18_agin3 l80f18_ob 5.5900e-17
Cl80f18_agin2oa l80f18_agin2 l80f18_oa 4.1100e-18
Vl80f18_clk l80f18_clk 0 pulse(0 1.8 18n 1e-10 1e-10 9.9000e-09 20n)
Cl80f18_s7 l80f18_clk l80f18_XA 2.3818e-16
* --- l40f0: core
Xl40f0_ienn hi 0 0 vdd vdd l40f0_enn sky130_fd_sc_hd__inv_1
Xl40f0_is1n 0 0 0 vdd vdd l40f0_s1n sky130_fd_sc_hd__inv_1
Xl40f0_is0n hi 0 0 vdd vdd l40f0_s0n sky130_fd_sc_hd__inv_1
Xl40f0_PREA pre l40f0_enn 0 0 vdd vdd l40f0_PREA sky130_fd_sc_hd__nor2_1
Xl40f0_PREB pre l40f0_enn 0 0 vdd vdd l40f0_PREB sky130_fd_sc_hd__nor2_1
Xl40f0_VBIAS hi 0 0 vdd vdd l40f0_VBIAS sky130_fd_sc_hd__buf_2
Xl40f0_C1 hi 0 0 vdd vdd l40f0_C1 sky130_fd_sc_hd__buf_2
Xl40f0_DUTA hi l40f0_s1n hi 0 0 vdd vdd l40f0_DUTA sky130_fd_sc_hd__and3_1
Xl40f0_DUTB hi l40f0_s1n hi 0 0 vdd vdd l40f0_DUTB sky130_fd_sc_hd__and3_1
Xl40f0_REFA hi 0 0 0 vdd vdd l40f0_REFA sky130_fd_sc_hd__and2_1
Xl40f0_REFB hi 0 0 0 vdd vdd l40f0_REFB sky130_fd_sc_hd__and2_1
Xl40f0_SA0B hi 0 hi 0 0 vdd vdd l40f0_SA0B sky130_fd_sc_hd__nand3_1
Xl40f0_SA1B hi 0 0 0 vdd vdd l40f0_SA1B sky130_fd_sc_hd__nand2_1
Xl40f0_SA2B hi 0 l40f0_s0n 0 0 vdd vdd l40f0_SA2B sky130_fd_sc_hd__nand3_1
Xl40f0_SB0B hi 0 0 0 vdd vdd l40f0_SB0B sky130_fd_sc_hd__nand2_1
Xl40f0_SB1B hi 0 0 0 vdd vdd l40f0_SB1B sky130_fd_sc_hd__nand2_1
Xl40f0_M l40f0_ob l40f0_SB0B l40f0_SB1B l40f0_REFB l40f0_oa l40f0_SA0B l40f0_SA1B l40f0_SA2B l40f0_REFA vdd 0 l40f0_VBIAS l40f0_C1 l40f0_PREA l40f0_XA l40f0_DUTA l40f0_PREB l40f0_XB l40f0_DUTB l40f0_VB 0 0 core

Cl40f0_XAoa l40f0_XA l40f0_oa 3.4540e-17
Cl40f0_XBob l40f0_XB l40f0_ob 3.3840e-17
Cl40f0_XAXB l40f0_XA l40f0_XB 2.3370e-17
Vl40f0_ag685 l40f0_ag685 0 1.8
Vl40f0_agin2 l40f0_agin2 0 0
Vl40f0_agin3 l40f0_agin3 0 0
Cl40f0_ag685ob l40f0_ag685 l40f0_ob 6.9200e-18
Cl40f0_agin3oa l40f0_agin3 l40f0_oa 6.1390e-17
Cl40f0_agin3ob l40f0_agin3 l40f0_ob 5.5900e-17
Cl40f0_agin2oa l40f0_agin2 l40f0_oa 4.1100e-18
Vl40f0_clk l40f0_clk 0 pulse(0 1.8 0n 1e-10 1e-10 9.9000e-09 20n)
Cl40f0_s7 l40f0_clk l40f0_XA 1.3475e-16
* --- l40f2: core
Xl40f2_ienn hi 0 0 vdd vdd l40f2_enn sky130_fd_sc_hd__inv_1
Xl40f2_is1n 0 0 0 vdd vdd l40f2_s1n sky130_fd_sc_hd__inv_1
Xl40f2_is0n hi 0 0 vdd vdd l40f2_s0n sky130_fd_sc_hd__inv_1
Xl40f2_PREA pre l40f2_enn 0 0 vdd vdd l40f2_PREA sky130_fd_sc_hd__nor2_1
Xl40f2_PREB pre l40f2_enn 0 0 vdd vdd l40f2_PREB sky130_fd_sc_hd__nor2_1
Xl40f2_VBIAS hi 0 0 vdd vdd l40f2_VBIAS sky130_fd_sc_hd__buf_2
Xl40f2_C1 hi 0 0 vdd vdd l40f2_C1 sky130_fd_sc_hd__buf_2
Xl40f2_DUTA hi l40f2_s1n hi 0 0 vdd vdd l40f2_DUTA sky130_fd_sc_hd__and3_1
Xl40f2_DUTB hi l40f2_s1n hi 0 0 vdd vdd l40f2_DUTB sky130_fd_sc_hd__and3_1
Xl40f2_REFA hi 0 0 0 vdd vdd l40f2_REFA sky130_fd_sc_hd__and2_1
Xl40f2_REFB hi 0 0 0 vdd vdd l40f2_REFB sky130_fd_sc_hd__and2_1
Xl40f2_SA0B hi 0 hi 0 0 vdd vdd l40f2_SA0B sky130_fd_sc_hd__nand3_1
Xl40f2_SA1B hi 0 0 0 vdd vdd l40f2_SA1B sky130_fd_sc_hd__nand2_1
Xl40f2_SA2B hi 0 l40f2_s0n 0 0 vdd vdd l40f2_SA2B sky130_fd_sc_hd__nand3_1
Xl40f2_SB0B hi 0 0 0 vdd vdd l40f2_SB0B sky130_fd_sc_hd__nand2_1
Xl40f2_SB1B hi 0 0 0 vdd vdd l40f2_SB1B sky130_fd_sc_hd__nand2_1
Xl40f2_M l40f2_ob l40f2_SB0B l40f2_SB1B l40f2_REFB l40f2_oa l40f2_SA0B l40f2_SA1B l40f2_SA2B l40f2_REFA vdd 0 l40f2_VBIAS l40f2_C1 l40f2_PREA l40f2_XA l40f2_DUTA l40f2_PREB l40f2_XB l40f2_DUTB l40f2_VB 0 0 core

Cl40f2_XAoa l40f2_XA l40f2_oa 3.4540e-17
Cl40f2_XBob l40f2_XB l40f2_ob 3.3840e-17
Cl40f2_XAXB l40f2_XA l40f2_XB 2.3370e-17
Vl40f2_ag685 l40f2_ag685 0 1.8
Vl40f2_agin2 l40f2_agin2 0 0
Vl40f2_agin3 l40f2_agin3 0 0
Cl40f2_ag685ob l40f2_ag685 l40f2_ob 6.9200e-18
Cl40f2_agin3oa l40f2_agin3 l40f2_oa 6.1390e-17
Cl40f2_agin3ob l40f2_agin3 l40f2_ob 5.5900e-17
Cl40f2_agin2oa l40f2_agin2 l40f2_oa 4.1100e-18
Vl40f2_clk l40f2_clk 0 pulse(0 1.8 2n 1e-10 1e-10 9.9000e-09 20n)
Cl40f2_s7 l40f2_clk l40f2_XA 1.3475e-16
* --- l40f4: core
Xl40f4_ienn hi 0 0 vdd vdd l40f4_enn sky130_fd_sc_hd__inv_1
Xl40f4_is1n 0 0 0 vdd vdd l40f4_s1n sky130_fd_sc_hd__inv_1
Xl40f4_is0n hi 0 0 vdd vdd l40f4_s0n sky130_fd_sc_hd__inv_1
Xl40f4_PREA pre l40f4_enn 0 0 vdd vdd l40f4_PREA sky130_fd_sc_hd__nor2_1
Xl40f4_PREB pre l40f4_enn 0 0 vdd vdd l40f4_PREB sky130_fd_sc_hd__nor2_1
Xl40f4_VBIAS hi 0 0 vdd vdd l40f4_VBIAS sky130_fd_sc_hd__buf_2
Xl40f4_C1 hi 0 0 vdd vdd l40f4_C1 sky130_fd_sc_hd__buf_2
Xl40f4_DUTA hi l40f4_s1n hi 0 0 vdd vdd l40f4_DUTA sky130_fd_sc_hd__and3_1
Xl40f4_DUTB hi l40f4_s1n hi 0 0 vdd vdd l40f4_DUTB sky130_fd_sc_hd__and3_1
Xl40f4_REFA hi 0 0 0 vdd vdd l40f4_REFA sky130_fd_sc_hd__and2_1
Xl40f4_REFB hi 0 0 0 vdd vdd l40f4_REFB sky130_fd_sc_hd__and2_1
Xl40f4_SA0B hi 0 hi 0 0 vdd vdd l40f4_SA0B sky130_fd_sc_hd__nand3_1
Xl40f4_SA1B hi 0 0 0 vdd vdd l40f4_SA1B sky130_fd_sc_hd__nand2_1
Xl40f4_SA2B hi 0 l40f4_s0n 0 0 vdd vdd l40f4_SA2B sky130_fd_sc_hd__nand3_1
Xl40f4_SB0B hi 0 0 0 vdd vdd l40f4_SB0B sky130_fd_sc_hd__nand2_1
Xl40f4_SB1B hi 0 0 0 vdd vdd l40f4_SB1B sky130_fd_sc_hd__nand2_1
Xl40f4_M l40f4_ob l40f4_SB0B l40f4_SB1B l40f4_REFB l40f4_oa l40f4_SA0B l40f4_SA1B l40f4_SA2B l40f4_REFA vdd 0 l40f4_VBIAS l40f4_C1 l40f4_PREA l40f4_XA l40f4_DUTA l40f4_PREB l40f4_XB l40f4_DUTB l40f4_VB 0 0 core

Cl40f4_XAoa l40f4_XA l40f4_oa 3.4540e-17
Cl40f4_XBob l40f4_XB l40f4_ob 3.3840e-17
Cl40f4_XAXB l40f4_XA l40f4_XB 2.3370e-17
Vl40f4_ag685 l40f4_ag685 0 1.8
Vl40f4_agin2 l40f4_agin2 0 0
Vl40f4_agin3 l40f4_agin3 0 0
Cl40f4_ag685ob l40f4_ag685 l40f4_ob 6.9200e-18
Cl40f4_agin3oa l40f4_agin3 l40f4_oa 6.1390e-17
Cl40f4_agin3ob l40f4_agin3 l40f4_ob 5.5900e-17
Cl40f4_agin2oa l40f4_agin2 l40f4_oa 4.1100e-18
Vl40f4_clk l40f4_clk 0 pulse(0 1.8 4n 1e-10 1e-10 9.9000e-09 20n)
Cl40f4_s7 l40f4_clk l40f4_XA 1.3475e-16
* --- l40f6: core
Xl40f6_ienn hi 0 0 vdd vdd l40f6_enn sky130_fd_sc_hd__inv_1
Xl40f6_is1n 0 0 0 vdd vdd l40f6_s1n sky130_fd_sc_hd__inv_1
Xl40f6_is0n hi 0 0 vdd vdd l40f6_s0n sky130_fd_sc_hd__inv_1
Xl40f6_PREA pre l40f6_enn 0 0 vdd vdd l40f6_PREA sky130_fd_sc_hd__nor2_1
Xl40f6_PREB pre l40f6_enn 0 0 vdd vdd l40f6_PREB sky130_fd_sc_hd__nor2_1
Xl40f6_VBIAS hi 0 0 vdd vdd l40f6_VBIAS sky130_fd_sc_hd__buf_2
Xl40f6_C1 hi 0 0 vdd vdd l40f6_C1 sky130_fd_sc_hd__buf_2
Xl40f6_DUTA hi l40f6_s1n hi 0 0 vdd vdd l40f6_DUTA sky130_fd_sc_hd__and3_1
Xl40f6_DUTB hi l40f6_s1n hi 0 0 vdd vdd l40f6_DUTB sky130_fd_sc_hd__and3_1
Xl40f6_REFA hi 0 0 0 vdd vdd l40f6_REFA sky130_fd_sc_hd__and2_1
Xl40f6_REFB hi 0 0 0 vdd vdd l40f6_REFB sky130_fd_sc_hd__and2_1
Xl40f6_SA0B hi 0 hi 0 0 vdd vdd l40f6_SA0B sky130_fd_sc_hd__nand3_1
Xl40f6_SA1B hi 0 0 0 vdd vdd l40f6_SA1B sky130_fd_sc_hd__nand2_1
Xl40f6_SA2B hi 0 l40f6_s0n 0 0 vdd vdd l40f6_SA2B sky130_fd_sc_hd__nand3_1
Xl40f6_SB0B hi 0 0 0 vdd vdd l40f6_SB0B sky130_fd_sc_hd__nand2_1
Xl40f6_SB1B hi 0 0 0 vdd vdd l40f6_SB1B sky130_fd_sc_hd__nand2_1
Xl40f6_M l40f6_ob l40f6_SB0B l40f6_SB1B l40f6_REFB l40f6_oa l40f6_SA0B l40f6_SA1B l40f6_SA2B l40f6_REFA vdd 0 l40f6_VBIAS l40f6_C1 l40f6_PREA l40f6_XA l40f6_DUTA l40f6_PREB l40f6_XB l40f6_DUTB l40f6_VB 0 0 core

Cl40f6_XAoa l40f6_XA l40f6_oa 3.4540e-17
Cl40f6_XBob l40f6_XB l40f6_ob 3.3840e-17
Cl40f6_XAXB l40f6_XA l40f6_XB 2.3370e-17
Vl40f6_ag685 l40f6_ag685 0 1.8
Vl40f6_agin2 l40f6_agin2 0 0
Vl40f6_agin3 l40f6_agin3 0 0
Cl40f6_ag685ob l40f6_ag685 l40f6_ob 6.9200e-18
Cl40f6_agin3oa l40f6_agin3 l40f6_oa 6.1390e-17
Cl40f6_agin3ob l40f6_agin3 l40f6_ob 5.5900e-17
Cl40f6_agin2oa l40f6_agin2 l40f6_oa 4.1100e-18
Vl40f6_clk l40f6_clk 0 pulse(0 1.8 6n 1e-10 1e-10 9.9000e-09 20n)
Cl40f6_s7 l40f6_clk l40f6_XA 1.3475e-16
* --- l40f8: core
Xl40f8_ienn hi 0 0 vdd vdd l40f8_enn sky130_fd_sc_hd__inv_1
Xl40f8_is1n 0 0 0 vdd vdd l40f8_s1n sky130_fd_sc_hd__inv_1
Xl40f8_is0n hi 0 0 vdd vdd l40f8_s0n sky130_fd_sc_hd__inv_1
Xl40f8_PREA pre l40f8_enn 0 0 vdd vdd l40f8_PREA sky130_fd_sc_hd__nor2_1
Xl40f8_PREB pre l40f8_enn 0 0 vdd vdd l40f8_PREB sky130_fd_sc_hd__nor2_1
Xl40f8_VBIAS hi 0 0 vdd vdd l40f8_VBIAS sky130_fd_sc_hd__buf_2
Xl40f8_C1 hi 0 0 vdd vdd l40f8_C1 sky130_fd_sc_hd__buf_2
Xl40f8_DUTA hi l40f8_s1n hi 0 0 vdd vdd l40f8_DUTA sky130_fd_sc_hd__and3_1
Xl40f8_DUTB hi l40f8_s1n hi 0 0 vdd vdd l40f8_DUTB sky130_fd_sc_hd__and3_1
Xl40f8_REFA hi 0 0 0 vdd vdd l40f8_REFA sky130_fd_sc_hd__and2_1
Xl40f8_REFB hi 0 0 0 vdd vdd l40f8_REFB sky130_fd_sc_hd__and2_1
Xl40f8_SA0B hi 0 hi 0 0 vdd vdd l40f8_SA0B sky130_fd_sc_hd__nand3_1
Xl40f8_SA1B hi 0 0 0 vdd vdd l40f8_SA1B sky130_fd_sc_hd__nand2_1
Xl40f8_SA2B hi 0 l40f8_s0n 0 0 vdd vdd l40f8_SA2B sky130_fd_sc_hd__nand3_1
Xl40f8_SB0B hi 0 0 0 vdd vdd l40f8_SB0B sky130_fd_sc_hd__nand2_1
Xl40f8_SB1B hi 0 0 0 vdd vdd l40f8_SB1B sky130_fd_sc_hd__nand2_1
Xl40f8_M l40f8_ob l40f8_SB0B l40f8_SB1B l40f8_REFB l40f8_oa l40f8_SA0B l40f8_SA1B l40f8_SA2B l40f8_REFA vdd 0 l40f8_VBIAS l40f8_C1 l40f8_PREA l40f8_XA l40f8_DUTA l40f8_PREB l40f8_XB l40f8_DUTB l40f8_VB 0 0 core

Cl40f8_XAoa l40f8_XA l40f8_oa 3.4540e-17
Cl40f8_XBob l40f8_XB l40f8_ob 3.3840e-17
Cl40f8_XAXB l40f8_XA l40f8_XB 2.3370e-17
Vl40f8_ag685 l40f8_ag685 0 1.8
Vl40f8_agin2 l40f8_agin2 0 0
Vl40f8_agin3 l40f8_agin3 0 0
Cl40f8_ag685ob l40f8_ag685 l40f8_ob 6.9200e-18
Cl40f8_agin3oa l40f8_agin3 l40f8_oa 6.1390e-17
Cl40f8_agin3ob l40f8_agin3 l40f8_ob 5.5900e-17
Cl40f8_agin2oa l40f8_agin2 l40f8_oa 4.1100e-18
Vl40f8_clk l40f8_clk 0 pulse(0 1.8 8n 1e-10 1e-10 9.9000e-09 20n)
Cl40f8_s7 l40f8_clk l40f8_XA 1.3475e-16
* --- l40f10: core
Xl40f10_ienn hi 0 0 vdd vdd l40f10_enn sky130_fd_sc_hd__inv_1
Xl40f10_is1n 0 0 0 vdd vdd l40f10_s1n sky130_fd_sc_hd__inv_1
Xl40f10_is0n hi 0 0 vdd vdd l40f10_s0n sky130_fd_sc_hd__inv_1
Xl40f10_PREA pre l40f10_enn 0 0 vdd vdd l40f10_PREA sky130_fd_sc_hd__nor2_1
Xl40f10_PREB pre l40f10_enn 0 0 vdd vdd l40f10_PREB sky130_fd_sc_hd__nor2_1
Xl40f10_VBIAS hi 0 0 vdd vdd l40f10_VBIAS sky130_fd_sc_hd__buf_2
Xl40f10_C1 hi 0 0 vdd vdd l40f10_C1 sky130_fd_sc_hd__buf_2
Xl40f10_DUTA hi l40f10_s1n hi 0 0 vdd vdd l40f10_DUTA sky130_fd_sc_hd__and3_1
Xl40f10_DUTB hi l40f10_s1n hi 0 0 vdd vdd l40f10_DUTB sky130_fd_sc_hd__and3_1
Xl40f10_REFA hi 0 0 0 vdd vdd l40f10_REFA sky130_fd_sc_hd__and2_1
Xl40f10_REFB hi 0 0 0 vdd vdd l40f10_REFB sky130_fd_sc_hd__and2_1
Xl40f10_SA0B hi 0 hi 0 0 vdd vdd l40f10_SA0B sky130_fd_sc_hd__nand3_1
Xl40f10_SA1B hi 0 0 0 vdd vdd l40f10_SA1B sky130_fd_sc_hd__nand2_1
Xl40f10_SA2B hi 0 l40f10_s0n 0 0 vdd vdd l40f10_SA2B sky130_fd_sc_hd__nand3_1
Xl40f10_SB0B hi 0 0 0 vdd vdd l40f10_SB0B sky130_fd_sc_hd__nand2_1
Xl40f10_SB1B hi 0 0 0 vdd vdd l40f10_SB1B sky130_fd_sc_hd__nand2_1
Xl40f10_M l40f10_ob l40f10_SB0B l40f10_SB1B l40f10_REFB l40f10_oa l40f10_SA0B l40f10_SA1B l40f10_SA2B l40f10_REFA vdd 0 l40f10_VBIAS l40f10_C1 l40f10_PREA l40f10_XA l40f10_DUTA l40f10_PREB l40f10_XB l40f10_DUTB l40f10_VB 0 0 core

Cl40f10_XAoa l40f10_XA l40f10_oa 3.4540e-17
Cl40f10_XBob l40f10_XB l40f10_ob 3.3840e-17
Cl40f10_XAXB l40f10_XA l40f10_XB 2.3370e-17
Vl40f10_ag685 l40f10_ag685 0 1.8
Vl40f10_agin2 l40f10_agin2 0 0
Vl40f10_agin3 l40f10_agin3 0 0
Cl40f10_ag685ob l40f10_ag685 l40f10_ob 6.9200e-18
Cl40f10_agin3oa l40f10_agin3 l40f10_oa 6.1390e-17
Cl40f10_agin3ob l40f10_agin3 l40f10_ob 5.5900e-17
Cl40f10_agin2oa l40f10_agin2 l40f10_oa 4.1100e-18
Vl40f10_clk l40f10_clk 0 pulse(0 1.8 10n 1e-10 1e-10 9.9000e-09 20n)
Cl40f10_s7 l40f10_clk l40f10_XA 1.3475e-16
Vgrid grid 0 pwl(0 0 2.875410e-05 0.0 2.875415e-05 0.001 2.875420e-05 0.0 2.875425e-05 0.001 2.875430e-05 0.0 2.875435e-05 0.001 2.875440e-05 0.0 2.875445e-05 0.001 2.875450e-05 0.0 2.875455e-05 0.001 2.875460e-05 0.0 2.875465e-05 0.001 2.875470e-05 0.0 2.875475e-05 0.001 2.875480e-05 0.0 2.875485e-05 0.001 2.875490e-05 0.0 2.875495e-05 0.001 2.875500e-05 0.0 2.875505e-05 0.001 2.875510e-05 0.0 2.875515e-05 0.001 2.875520e-05 0.0 2.875525e-05 0.001 2.875530e-05 0.0 2.875535e-05 0.001 2.875540e-05 0.0 2.875545e-05 0.001 2.875550e-05 0.0 2.875555e-05 0.001 2.875560e-05 0.0 2.875565e-05 0.001 2.875570e-05 0.0 2.875575e-05 0.001 2.875580e-05 0.0 2.875585e-05 0.001 2.875590e-05 0.0 2.875595e-05 0.001 2.875600e-05 0.0 2.875605e-05 0.001 2.875610e-05 0.0 2.875615e-05 0.001 2.875620e-05 0.0 2.875625e-05 0.001 2.875630e-05 0.0 2.875635e-05 0.001 2.875640e-05 0.0 2.875645e-05 0.001 2.875650e-05 0.0 2.875655e-05 0.001 2.875660e-05 0.0 2.875665e-05 0.001 2.875670e-05 0.0 2.875675e-05 0.001 2.875680e-05 0.0 2.875685e-05 0.001 2.875690e-05 0.0 2.875695e-05 0.001 2.875700e-05 0.0 2.875705e-05 0.001 2.875710e-05 0.0 2.875715e-05 0.001 2.875720e-05 0.0 2.875725e-05 0.001 2.875730e-05 0.0 2.875735e-05 0.001 2.875740e-05 0.0 2.875745e-05 0.001 2.875750e-05 0.0 2.875755e-05 0.001 2.875760e-05 0.0 2.875765e-05 0.001 2.875770e-05 0.0 2.875775e-05 0.001 2.875780e-05 0.0 2.875785e-05 0.001 2.875790e-05 0.0 2.875795e-05 0.001 2.875800e-05 0.0 2.875805e-05 0.001 2.875810e-05 0.0 2.875815e-05 0.001 2.875820e-05 0.0 2.875825e-05 0.001 2.875830e-05 0.0 2.875835e-05 0.001 2.875840e-05 0.0 2.875845e-05 0.001 2.875850e-05 0.0 2.875855e-05 0.001 2.875860e-05 0.0 2.875865e-05 0.001 2.875870e-05 0.0 2.875875e-05 0.001 2.875880e-05 0.0 2.875885e-05 0.001 2.875890e-05 0.0 2.875895e-05 0.001 2.875900e-05 0.0 2.875905e-05 0.001 2.875910e-05 0.0 2.875915e-05 0.001 2.875920e-05 0.0 2.875925e-05 0.001 2.875930e-05 0.0 2.875935e-05 0.001 2.875940e-05 0.0 2.875945e-05 0.001 2.875950e-05 0.0 2.875955e-05 0.001 2.875960e-05 0.0 2.875965e-05 0.001 2.875970e-05 0.0 2.875975e-05 0.001 2.875980e-05 0.0 2.875985e-05 0.001 2.875990e-05 0.0 2.875995e-05 0.001 2.876000e-05 0.0 2.876005e-05 0.001 2.876010e-05 0.0 2.876015e-05 0.001 2.876020e-05 0.0 2.876025e-05 0.001 2.876030e-05 0.0 2.876035e-05 0.001 2.876040e-05 0.0 2.876045e-05 0.001 2.876050e-05 0.0 2.876055e-05 0.001 2.876060e-05 0.0 2.876065e-05 0.001 2.876070e-05 0.0 2.876075e-05 0.001 2.876080e-05 0.0 2.876085e-05 0.001 2.876090e-05 0.0 2.876095e-05 0.001 2.876100e-05 0.0 2.876105e-05 0.001 2.876110e-05 0.0 2.876115e-05 0.001 2.876120e-05 0.0 2.876125e-05 0.001 2.876130e-05 0.0 2.876135e-05 0.001 2.876140e-05 0.0 2.876145e-05 0.001 2.876150e-05 0.0 2.876155e-05 0.001 2.876160e-05 0.0 2.876165e-05 0.001 2.876170e-05 0.0 2.876175e-05 0.001 2.876180e-05 0.0 2.876185e-05 0.001 2.876190e-05 0.0 2.876195e-05 0.001 2.876200e-05 0.0 2.876205e-05 0.001 2.876210e-05 0.0 2.876215e-05 0.001 2.876220e-05 0.0 2.876225e-05 0.001 2.876230e-05 0.0 2.876235e-05 0.001 2.876240e-05 0.0 2.876245e-05 0.001 2.876250e-05 0.0 2.876255e-05 0.001 2.876260e-05 0.0 2.876265e-05 0.001 2.876270e-05 0.0 2.876275e-05 0.001 2.876280e-05 0.0 2.876285e-05 0.001 2.876290e-05 0.0 2.876295e-05 0.001 2.876300e-05 0.0 2.876305e-05 0.001 2.876310e-05 0.0 2.876315e-05 0.001 2.876320e-05 0.0 2.876325e-05 0.001 2.876330e-05 0.0 2.876335e-05 0.001 2.876340e-05 0.0 2.876345e-05 0.001 2.876350e-05 0.0 2.876355e-05 0.001 2.876360e-05 0.0 2.876365e-05 0.001 2.876370e-05 0.0 2.876375e-05 0.001 2.876380e-05 0.0 2.876385e-05 0.001 2.876390e-05 0.0 2.876395e-05 0.001 2.876400e-05 0.0 2.876405e-05 0.001 2.876410e-05 0.0 2.876415e-05 0.001 2.876420e-05 0.0 2.876425e-05 0.001 2.876430e-05 0.0 2.876435e-05 0.001 2.876440e-05 0.0 2.876445e-05 0.001 2.876450e-05 0.0 2.876455e-05 0.001 2.876460e-05 0.0 2.876465e-05 0.001 2.876470e-05 0.0 2.876475e-05 0.001 2.876480e-05 0.0 2.876485e-05 0.001 2.876490e-05 0.0 2.876495e-05 0.001 2.876500e-05 0.0 2.876505e-05 0.001 2.876510e-05 0.0 2.876515e-05 0.001 2.876520e-05 0.0 2.876525e-05 0.001 2.876530e-05 0.0 2.876535e-05 0.001 2.876540e-05 0.0 2.876545e-05 0.001 2.876550e-05 0.0 2.876555e-05 0.001 2.876560e-05 0.0 2.876565e-05 0.001 2.876570e-05 0.0 2.876575e-05 0.001 2.876580e-05 0.0 2.876585e-05 0.001 2.876590e-05 0.0 2.876595e-05 0.001 2.876600e-05 0.0 2.876605e-05 0.001 2.876610e-05 0.0 2.876615e-05 0.001 2.876620e-05 0.0 2.876625e-05 0.001 2.876630e-05 0.0 2.876635e-05 0.001 2.876640e-05 0.0 2.876645e-05 0.001 2.876650e-05 0.0 2.876655e-05 0.001 2.876660e-05 0.0 2.876665e-05 0.001 2.876670e-05 0.0 2.876675e-05 0.001 2.876680e-05 0.0 2.876685e-05 0.001 2.876690e-05 0.0 2.876695e-05 0.001 2.876700e-05 0.0 2.876705e-05 0.001 2.876710e-05 0.0 2.876715e-05 0.001 2.876720e-05 0.0 2.876725e-05 0.001 2.876730e-05 0.0 2.876735e-05 0.001 2.876740e-05 0.0 2.876745e-05 0.001 2.876750e-05 0.0 2.876755e-05 0.001 2.876760e-05 0.0 2.876765e-05 0.001 2.876770e-05 0.0 2.876775e-05 0.001 2.876780e-05 0.0 2.876785e-05 0.001 2.876790e-05 0.0 2.876795e-05 0.001 2.876800e-05 0.0 2.876805e-05 0.001 2.876810e-05 0.0 2.876815e-05 0.001 2.876820e-05 0.0 2.876825e-05 0.001 2.876830e-05 0.0 2.876835e-05 0.001 2.876840e-05 0.0 2.876845e-05 0.001 2.876850e-05 0.0 2.876855e-05 0.001 2.876860e-05 0.0 2.876865e-05 0.001 2.876870e-05 0.0 2.876875e-05 0.001 2.876880e-05 0.0 2.876885e-05 0.001 2.876890e-05 0.0 2.876895e-05 0.001 2.876900e-05 0.0 2.876905e-05 0.001 2.876910e-05 0.0 2.876915e-05 0.001 2.876920e-05 0.0 2.876925e-05 0.001 2.876930e-05 0.0 2.876935e-05 0.001 2.876940e-05 0.0 2.876945e-05 0.001 2.876950e-05 0.0 2.876955e-05 0.001 2.876960e-05 0.0 2.876965e-05 0.001 2.876970e-05 0.0 2.876975e-05 0.001 2.876980e-05 0.0 2.876985e-05 0.001 2.876990e-05 0.0 2.876995e-05 0.001 2.877000e-05 0.0 2.877005e-05 0.001 2.877010e-05 0.0 2.877015e-05 0.001 2.877020e-05 0.0 2.877025e-05 0.001 2.877030e-05 0.0 2.877035e-05 0.001 2.877040e-05 0.0 2.877045e-05 0.001 2.877050e-05 0.0 2.877055e-05 0.001 2.877060e-05 0.0 2.877065e-05 0.001 2.877070e-05 0.0 2.877075e-05 0.001 2.877080e-05 0.0 2.877085e-05 0.001 2.877090e-05 0.0 2.877095e-05 0.001 2.877100e-05 0.0 2.877105e-05 0.001 2.877110e-05 0.0 2.877115e-05 0.001 2.877120e-05 0.0 2.877125e-05 0.001 2.877130e-05 0.0 2.877135e-05 0.001 2.877140e-05 0.0 2.877145e-05 0.001 2.877150e-05 0.0 2.877155e-05 0.001 2.877160e-05 0.0 2.877165e-05 0.001 2.877170e-05 0.0 2.877175e-05 0.001 2.877180e-05 0.0 2.877185e-05 0.001 2.877190e-05 0.0 2.877195e-05 0.001 2.877200e-05 0.0 2.877205e-05 0.001 2.877210e-05 0.0 2.877215e-05 0.001 2.877220e-05 0.0 2.877225e-05 0.001 2.877230e-05 0.0 2.877235e-05 0.001 2.877240e-05 0.0 2.877245e-05 0.001 2.877250e-05 0.0 2.877255e-05 0.001 2.877260e-05 0.0 2.877265e-05 0.001 2.877270e-05 0.0 2.877275e-05 0.001 2.877280e-05 0.0 2.877285e-05 0.001 2.877290e-05 0.0 2.877295e-05 0.001 2.877300e-05 0.0 2.877305e-05 0.001 2.877310e-05 0.0 2.877315e-05 0.001 2.877320e-05 0.0 2.877325e-05 0.001 2.877330e-05 0.0 2.877335e-05 0.001 2.877340e-05 0.0 2.877345e-05 0.001 2.877350e-05 0.0 2.877355e-05 0.001 2.877360e-05 0.0 2.877365e-05 0.001 2.877370e-05 0.0 2.877375e-05 0.001 2.877380e-05 0.0 2.877385e-05 0.001 2.877390e-05 0.0 2.877395e-05 0.001 2.877400e-05 0.0 2.877405e-05 0.001 2.877410e-05 0.0 2.877415e-05 0.001 2.877420e-05 0.0 2.877425e-05 0.001 2.877430e-05 0.0 2.877435e-05 0.001 2.877440e-05 0.0 2.877445e-05 0.001 2.877450e-05 0.0 2.877455e-05 0.001 2.877460e-05 0.0 2.877465e-05 0.001 2.877470e-05 0.0 2.877475e-05 0.001 2.877480e-05 0.0 2.877485e-05 0.001 2.877490e-05 0.0 2.877495e-05 0.001 2.877500e-05 0.0 2.877505e-05 0.001 2.877510e-05 0.0 2.877515e-05 0.001 2.877520e-05 0.0 2.877525e-05 0.001 2.877530e-05 0.0 2.877535e-05 0.001 2.877540e-05 0.0 2.877545e-05 0.001 2.877550e-05 0.0 2.877555e-05 0.001 2.877560e-05 0.0 2.877565e-05 0.001 2.877570e-05 0.0 2.877575e-05 0.001 2.877580e-05 0.0 2.877585e-05 0.001 2.877590e-05 0.0 2.877595e-05 0.001 2.877600e-05 0.0 2.877605e-05 0.001 2.877610e-05 0.0 2.877615e-05 0.001 2.877620e-05 0.0 2.877625e-05 0.001 2.877630e-05 0.0 2.877635e-05 0.001 2.877640e-05 0.0 2.877645e-05 0.001 2.877650e-05 0.0 2.877655e-05 0.001 2.877660e-05 0.0 2.877665e-05 0.001 2.877670e-05 0.0 2.877675e-05 0.001 2.877680e-05 0.0 2.877685e-05 0.001 2.877690e-05 0.0 2.877695e-05 0.001 2.877700e-05 0.0 2.877705e-05 0.001 2.877710e-05 0.0 2.877715e-05 0.001 2.877720e-05 0.0 2.877725e-05 0.001 2.877730e-05 0.0 2.877735e-05 0.001 2.877740e-05 0.0 2.877745e-05 0.001 2.877750e-05 0.0 2.877755e-05 0.001 2.877760e-05 0.0 2.877765e-05 0.001 2.877770e-05 0.0 2.877775e-05 0.001 2.877780e-05 0.0 2.877785e-05 0.001 2.877790e-05 0.0 2.877795e-05 0.001 2.877800e-05 0.0 2.877805e-05 0.001 2.877810e-05 0.0 2.877815e-05 0.001 2.877820e-05 0.0 2.877825e-05 0.001 2.877830e-05 0.0 2.877835e-05 0.001 2.877840e-05 0.0 2.877845e-05 0.001 2.877850e-05 0.0 2.877855e-05 0.001 2.877860e-05 0.0 2.877865e-05 0.001 2.877870e-05 0.0 2.877875e-05 0.001 2.877880e-05 0.0 2.877885e-05 0.001 2.877890e-05 0.0 2.877895e-05 0.001 2.877900e-05 0.0 2.877905e-05 0.001 2.877910e-05 0.0 2.877915e-05 0.001 2.877920e-05 0.0 2.877925e-05 0.001 2.877930e-05 0.0 2.877935e-05 0.001 2.877940e-05 0.0 2.877945e-05 0.001 2.877950e-05 0.0 2.877955e-05 0.001 2.877960e-05 0.0 2.877965e-05 0.001 2.877970e-05 0.0 2.877975e-05 0.001 2.877980e-05 0.0 2.877985e-05 0.001 2.877990e-05 0.0 2.877995e-05 0.001 2.878000e-05 0.0 2.878005e-05 0.001 2.878010e-05 0.0 2.878015e-05 0.001 2.878020e-05 0.0 2.878025e-05 0.001 2.878030e-05 0.0 2.878035e-05 0.001 2.878040e-05 0.0 2.878045e-05 0.001 2.878050e-05 0.0 2.878055e-05 0.001 2.878060e-05 0.0 2.878065e-05 0.001 2.878070e-05 0.0 2.878075e-05 0.001 2.878080e-05 0.0 2.878085e-05 0.001 2.878090e-05 0.0 2.878095e-05 0.001 2.878100e-05 0.0 2.878105e-05 0.001 2.878110e-05 0.0 2.878115e-05 0.001 2.878120e-05 0.0 2.878125e-05 0.001 2.878130e-05 0.0 2.878135e-05 0.001 2.878140e-05 0.0 2.878145e-05 0.001 2.878150e-05 0.0 2.878155e-05 0.001 2.878160e-05 0.0 2.878165e-05 0.001 2.878170e-05 0.0 2.878175e-05 0.001 2.878180e-05 0.0 2.878185e-05 0.001 2.878190e-05 0.0 2.878195e-05 0.001 2.878200e-05 0.0 2.878205e-05 0.001 2.878210e-05 0.0 2.878215e-05 0.001 2.878220e-05 0.0 2.878225e-05 0.001 2.878230e-05 0.0 2.878235e-05 0.001 2.878240e-05 0.0 2.878245e-05 0.001 2.878250e-05 0.0 2.878255e-05 0.001 2.878260e-05 0.0 2.878265e-05 0.001 2.878270e-05 0.0 2.878275e-05 0.001 2.878280e-05 0.0 2.878285e-05 0.001 2.878290e-05 0.0 2.878295e-05 0.001 2.878300e-05 0.0 2.878305e-05 0.001 2.878310e-05 0.0 2.878315e-05 0.001 2.878320e-05 0.0 2.878325e-05 0.001 2.878330e-05 0.0 2.878335e-05 0.001 2.878340e-05 0.0 2.878345e-05 0.001 2.878350e-05 0.0 2.878355e-05 0.001 2.878360e-05 0.0 2.878365e-05 0.001 2.878370e-05 0.0 2.878375e-05 0.001 2.878380e-05 0.0 2.878385e-05 0.001 2.878390e-05 0.0 2.878395e-05 0.001 2.878400e-05 0.0 2.878405e-05 0.001 2.878410e-05 0.0 2.878415e-05 0.001 2.878420e-05 0.0 2.878425e-05 0.001 2.878430e-05 0.0 2.878435e-05 0.001 2.878440e-05 0.0 2.878445e-05 0.001 2.878450e-05 0.0 2.878455e-05 0.001 2.878460e-05 0.0 2.878465e-05 0.001 2.878470e-05 0.0 2.878475e-05 0.001 2.878480e-05 0.0 2.878485e-05 0.001 2.878490e-05 0.0 2.878495e-05 0.001 2.878500e-05 0.0 2.878505e-05 0.001 2.878510e-05 0.0 2.878515e-05 0.001 2.878520e-05 0.0 2.878525e-05 0.001 2.878530e-05 0.0 2.878535e-05 0.001 2.878540e-05 0.0 2.878545e-05 0.001 2.878550e-05 0.0 2.878555e-05 0.001 2.878560e-05 0.0 2.878565e-05 0.001 2.878570e-05 0.0 2.878575e-05 0.001 2.878580e-05 0.0 2.878585e-05 0.001 2.878590e-05 0.0 2.878595e-05 0.001 2.878600e-05 0.0 2.878605e-05 0.001 2.878610e-05 0.0 2.878615e-05 0.001 2.878620e-05 0.0 2.878625e-05 0.001 2.878630e-05 0.0 2.878635e-05 0.001 2.878640e-05 0.0 2.878645e-05 0.001 2.878650e-05 0.0 2.878655e-05 0.001 2.878660e-05 0.0 2.878665e-05 0.001 2.878670e-05 0.0 2.878675e-05 0.001 2.878680e-05 0.0 2.878685e-05 0.001 2.878690e-05 0.0 2.878695e-05 0.001 2.878700e-05 0.0 2.878705e-05 0.001 2.878710e-05 0.0 2.878715e-05 0.001 2.878720e-05 0.0 2.878725e-05 0.001 2.878730e-05 0.0 2.878735e-05 0.001 2.878740e-05 0.0 2.878745e-05 0.001 2.878750e-05 0.0 2.878755e-05 0.001 2.878760e-05 0.0 2.878765e-05 0.001 2.878770e-05 0.0 2.878775e-05 0.001 2.878780e-05 0.0 2.878785e-05 0.001 2.878790e-05 0.0 2.878795e-05 0.001 2.878800e-05 0.0 2.878805e-05 0.001 2.878810e-05 0.0 2.878815e-05 0.001 2.878820e-05 0.0 2.878825e-05 0.001 2.878830e-05 0.0 2.878835e-05 0.001 2.878840e-05 0.0 2.878845e-05 0.001 2.878850e-05 0.0 2.878855e-05 0.001 2.878860e-05 0.0 2.878865e-05 0.001 2.878870e-05 0.0 2.878875e-05 0.001 2.878880e-05 0.0 2.878885e-05 0.001 2.878890e-05 0.0 2.878895e-05 0.001 2.878900e-05 0.0 2.878905e-05 0.001 2.878910e-05 0.0 2.878915e-05 0.001 2.878920e-05 0.0 2.878925e-05 0.001 2.878930e-05 0.0 2.878935e-05 0.001 2.878940e-05 0.0 2.878945e-05 0.001 2.878950e-05 0.0 2.878955e-05 0.001 2.878960e-05 0.0 2.878965e-05 0.001 2.878970e-05 0.0 2.878975e-05 0.001 2.878980e-05 0.0 2.878985e-05 0.001 2.878990e-05 0.0 2.878995e-05 0.001 2.879000e-05 0.0 2.879005e-05 0.001 2.879010e-05 0.0 2.879015e-05 0.001 2.879020e-05 0.0 2.879025e-05 0.001 2.879030e-05 0.0 2.879035e-05 0.001 2.879040e-05 0.0 2.879045e-05 0.001 2.879050e-05 0.0 2.879055e-05 0.001 2.879060e-05 0.0 2.879065e-05 0.001 2.879070e-05 0.0 2.879075e-05 0.001 2.879080e-05 0.0 2.879085e-05 0.001 2.879090e-05 0.0 2.879095e-05 0.001 2.879100e-05 0.0 2.879105e-05 0.001 2.879110e-05 0.0 2.879115e-05 0.001 2.879120e-05 0.0 2.879125e-05 0.001 2.879130e-05 0.0 2.879135e-05 0.001 2.879140e-05 0.0 2.879145e-05 0.001 2.879150e-05 0.0 2.879155e-05 0.001 2.879160e-05 0.0 2.879165e-05 0.001 2.879170e-05 0.0 2.879175e-05 0.001 2.879180e-05 0.0 2.879185e-05 0.001 2.879190e-05 0.0 2.879195e-05 0.001 2.879200e-05 0.0 2.879205e-05 0.001 2.879210e-05 0.0 2.879215e-05 0.001 2.879220e-05 0.0 2.879225e-05 0.001 2.879230e-05 0.0 2.879235e-05 0.001 2.879240e-05 0.0 2.879245e-05 0.001 2.879250e-05 0.0 2.879255e-05 0.001 2.879260e-05 0.0 2.879265e-05 0.001 2.879270e-05 0.0 2.879275e-05 0.001 2.879280e-05 0.0 2.879285e-05 0.001 2.879290e-05 0.0 2.879295e-05 0.001 2.879300e-05 0.0 2.879305e-05 0.001 2.879310e-05 0.0 2.879315e-05 0.001 2.879320e-05 0.0 2.879325e-05 0.001 2.879330e-05 0.0 2.879335e-05 0.001 2.879340e-05 0.0 2.879345e-05 0.001 2.879350e-05 0.0 2.879355e-05 0.001 2.879360e-05 0.0 2.879365e-05 0.001 2.879370e-05 0.0 2.879375e-05 0.001 2.879380e-05 0.0 2.879385e-05 0.001 2.879390e-05 0.0 2.879395e-05 0.001 2.879400e-05 0.0 2.879405e-05 0.001 2.879410e-05 0.0 2.879415e-05 0.001 2.879420e-05 0.0 2.879425e-05 0.001 2.879430e-05 0.0 2.879435e-05 0.001 2.879440e-05 0.0 2.879445e-05 0.001 2.879450e-05 0.0 2.879455e-05 0.001 2.879460e-05 0.0 2.879465e-05 0.001 2.879470e-05 0.0 2.879475e-05 0.001 2.879480e-05 0.0 2.879485e-05 0.001 2.879490e-05 0.0 2.879495e-05 0.001 2.879500e-05 0.0 2.879505e-05 0.001 2.879510e-05 0.0 2.879515e-05 0.001 2.879520e-05 0.0 2.879525e-05 0.001 2.879530e-05 0.0 2.879535e-05 0.001 2.879540e-05 0.0 2.879545e-05 0.001 2.879550e-05 0.0 2.879555e-05 0.001 2.879560e-05 0.0 2.879565e-05 0.001 2.879570e-05 0.0 2.879575e-05 0.001 2.879580e-05 0.0 2.879585e-05 0.001 2.879590e-05 0.0 2.879595e-05 0.001 2.879600e-05 0.0 2.879605e-05 0.001 2.879610e-05 0.0 2.879615e-05 0.001 2.879620e-05 0.0 2.879625e-05 0.001 2.879630e-05 0.0 2.879635e-05 0.001 2.879640e-05 0.0 2.879645e-05 0.001 2.879650e-05 0.0 2.879655e-05 0.001 2.879660e-05 0.0 2.879665e-05 0.001 2.879670e-05 0.0 2.879675e-05 0.001 2.879680e-05 0.0 2.879685e-05 0.001 2.879690e-05 0.0 2.879695e-05 0.001 2.879700e-05 0.0 2.879705e-05 0.001 2.879710e-05 0.0 2.879715e-05 0.001 2.879720e-05 0.0 2.879725e-05 0.001 2.879730e-05 0.0 2.879735e-05 0.001 2.879740e-05 0.0 2.879745e-05 0.001 2.879750e-05 0.0 2.879755e-05 0.001 2.879760e-05 0.0 2.879765e-05 0.001 2.879770e-05 0.0 2.879775e-05 0.001 2.879780e-05 0.0 2.879785e-05 0.001 2.879790e-05 0.0 2.879795e-05 0.001 2.879800e-05 0.0 2.879805e-05 0.001 2.879810e-05 0.0 2.879815e-05 0.001 2.879820e-05 0.0 2.879825e-05 0.001 2.879830e-05 0.0 2.879835e-05 0.001 2.879840e-05 0.0 2.879845e-05 0.001 2.879850e-05 0.0 2.879855e-05 0.001 2.879860e-05 0.0 2.879865e-05 0.001 2.879870e-05 0.0 2.879875e-05 0.001 2.879880e-05 0.0 2.879885e-05 0.001 2.879890e-05 0.0 2.879895e-05 0.001 2.879900e-05 0.0 2.879905e-05 0.001 2.879910e-05 0.0 2.879915e-05 0.001 2.879920e-05 0.0 2.879925e-05 0.001 2.879930e-05 0.0 2.879935e-05 0.001 2.879940e-05 0.0 2.879945e-05 0.001 2.879950e-05 0.0 2.879955e-05 0.001 2.879960e-05 0.0 2.879965e-05 0.001 2.879970e-05 0.0 2.879975e-05 0.001 2.879980e-05 0.0 2.879985e-05 0.001 2.879990e-05 0.0 2.879995e-05 0.001 2.880000e-05 0.0 2.880005e-05 0.001 2.880010e-05 0.0 2.880015e-05 0.001 2.880020e-05 0.0 2.880025e-05 0.001 2.880030e-05 0.0 2.880035e-05 0.001 2.880040e-05 0.0 2.880045e-05 0.001 2.880050e-05 0.0 2.880055e-05 0.001 2.880060e-05 0.0 2.880065e-05 0.001 2.880070e-05 0.0 2.880075e-05 0.001 2.880080e-05 0.0 2.880085e-05 0.001 2.880090e-05 0.0 2.880095e-05 0.001 2.880100e-05 0.0 2.880105e-05 0.001 2.880110e-05 0.0 2.880115e-05 0.001 2.880120e-05 0.0 2.880125e-05 0.001 2.880130e-05 0.0 2.880135e-05 0.001 2.880140e-05 0.0 2.880145e-05 0.001 2.880150e-05 0.0 2.880155e-05 0.001 2.880160e-05 0.0 2.880165e-05 0.001 2.880170e-05 0.0 2.880175e-05 0.001 2.880180e-05 0.0 2.880185e-05 0.001 2.880190e-05 0.0 2.880195e-05 0.001 2.880200e-05 0.0 2.880205e-05 0.001 2.880210e-05 0.0 2.880215e-05 0.001 2.880220e-05 0.0 2.880225e-05 0.001 2.880230e-05 0.0 2.880235e-05 0.001 2.880240e-05 0.0 2.880245e-05 0.001 2.880250e-05 0.0 2.880255e-05 0.001 2.880260e-05 0.0 2.880265e-05 0.001 2.880270e-05 0.0 2.880275e-05 0.001 2.880280e-05 0.0 2.880285e-05 0.001 2.880290e-05 0.0 2.880295e-05 0.001 2.880300e-05 0.0 2.880305e-05 0.001 2.880310e-05 0.0 2.880315e-05 0.001 2.880320e-05 0.0 2.880325e-05 0.001 2.880330e-05 0.0 2.880335e-05 0.001 2.880340e-05 0.0 2.880345e-05 0.001 2.880350e-05 0.0 2.880355e-05 0.001 2.880360e-05 0.0 2.880365e-05 0.001 2.880370e-05 0.0 2.880375e-05 0.001 2.880380e-05 0.0 2.880385e-05 0.001 2.880390e-05 0.0 2.880395e-05 0.001 2.880400e-05 0.0 2.880405e-05 0.001 2.880410e-05 0.0 2.880415e-05 0.001 2.880420e-05 0.0 2.880425e-05 0.001 2.880430e-05 0.0 2.880435e-05 0.001 2.880440e-05 0.0 2.880445e-05 0.001 2.880450e-05 0.0 2.880455e-05 0.001 2.880460e-05 0.0 2.880465e-05 0.001 2.880470e-05 0.0 2.880475e-05 0.001 2.880480e-05 0.0 2.880485e-05 0.001 2.880490e-05 0.0 2.880495e-05 0.001 2.880500e-05 0.0 2.880505e-05 0.001 2.880510e-05 0.0 2.880515e-05 0.001 2.880520e-05 0.0 2.880525e-05 0.001 2.880530e-05 0.0 2.880535e-05 0.001 2.880540e-05 0.0 2.880545e-05 0.001 2.880550e-05 0.0 2.880555e-05 0.001 2.880560e-05 0.0 2.880565e-05 0.001 2.880570e-05 0.0 2.880575e-05 0.001 2.880580e-05 0.0 2.880585e-05 0.001 2.880590e-05 0.0 2.880595e-05 0.001 2.880600e-05 0.0 2.880605e-05 0.001 2.880610e-05 0.0 2.880615e-05 0.001 2.880620e-05 0.0 2.880625e-05 0.001 2.880630e-05 0.0 2.880635e-05 0.001 2.880640e-05 0.0 2.880645e-05 0.001 2.880650e-05 0.0 2.880655e-05 0.001 2.880660e-05 0.0 2.880665e-05 0.001 2.880670e-05 0.0 2.880675e-05 0.001 2.880680e-05 0.0 2.880685e-05 0.001 2.880690e-05 0.0 2.880695e-05 0.001 2.880700e-05 0.0 2.880705e-05 0.001 2.880710e-05 0.0 2.880715e-05 0.001 2.880720e-05 0.0 2.880725e-05 0.001 2.880730e-05 0.0 2.880735e-05 0.001 2.880740e-05 0.0 2.880745e-05 0.001 2.880750e-05 0.0 2.880755e-05 0.001 2.880760e-05 0.0 2.880765e-05 0.001 2.880770e-05 0.0 2.880775e-05 0.001 2.880780e-05 0.0 2.880785e-05 0.001 2.880790e-05 0.0 2.880795e-05 0.001 2.880800e-05 0.0 2.880805e-05 0.001 2.880810e-05 0.0 2.880815e-05 0.001 2.880820e-05 0.0 2.880825e-05 0.001 2.880830e-05 0.0 2.880835e-05 0.001 2.880840e-05 0.0 2.880845e-05 0.001 2.880850e-05 0.0 2.880855e-05 0.001 2.880860e-05 0.0 2.880865e-05 0.001 2.880870e-05 0.0 2.880875e-05 0.001 2.880880e-05 0.0 2.880885e-05 0.001 2.880890e-05 0.0 2.880895e-05 0.001 2.880900e-05 0.0 2.880905e-05 0.001 2.880910e-05 0.0 2.880915e-05 0.001 2.880920e-05 0.0 2.880925e-05 0.001 2.880930e-05 0.0 2.880935e-05 0.001 2.880940e-05 0.0 2.880945e-05 0.001 2.880950e-05 0.0 2.880955e-05 0.001 2.880960e-05 0.0 2.880965e-05 0.001 2.880970e-05 0.0 2.880975e-05 0.001 2.880980e-05 0.0 2.880985e-05 0.001 2.880990e-05 0.0 2.880995e-05 0.001 2.881000e-05 0.0 2.881005e-05 0.001 2.881010e-05 0.0 2.881015e-05 0.001 2.881020e-05 0.0 2.881025e-05 0.001 2.881030e-05 0.0 2.881035e-05 0.001 2.881040e-05 0.0 2.881045e-05 0.001 2.881050e-05 0.0 2.881055e-05 0.001 2.881060e-05 0.0 2.881065e-05 0.001 2.881070e-05 0.0 2.881075e-05 0.001 2.881080e-05 0.0 2.881085e-05 0.001 2.881090e-05 0.0 2.881095e-05 0.001 2.881100e-05 0.0 2.881105e-05 0.001 2.881110e-05 0.0 2.881115e-05 0.001 2.881120e-05 0.0 2.881125e-05 0.001 2.881130e-05 0.0 2.881135e-05 0.001 2.881140e-05 0.0 2.881145e-05 0.001 2.881150e-05 0.0 2.881155e-05 0.001 2.881160e-05 0.0 2.881165e-05 0.001 2.881170e-05 0.0 2.881175e-05 0.001 2.881180e-05 0.0 2.881185e-05 0.001 2.881190e-05 0.0 2.881195e-05 0.001 2.881200e-05 0.0 2.881205e-05 0.001 2.881210e-05 0.0 2.881215e-05 0.001 2.881220e-05 0.0 2.881225e-05 0.001 2.881230e-05 0.0 2.881235e-05 0.001 2.881240e-05 0.0 2.881245e-05 0.001 2.881250e-05 0.0 2.881255e-05 0.001 2.881260e-05 0.0 2.881265e-05 0.001 2.881270e-05 0.0 2.881275e-05 0.001 2.881280e-05 0.0 2.881285e-05 0.001 2.881290e-05 0.0 2.881295e-05 0.001 2.881300e-05 0.0 2.881305e-05 0.001 2.881310e-05 0.0 2.881315e-05 0.001 2.881320e-05 0.0 2.881325e-05 0.001 2.881330e-05 0.0 2.881335e-05 0.001 2.881340e-05 0.0 2.881345e-05 0.001 2.881350e-05 0.0 2.881355e-05 0.001 2.881360e-05 0.0 2.881365e-05 0.001 2.881370e-05 0.0 2.881375e-05 0.001 2.881380e-05 0.0 2.881385e-05 0.001 2.881390e-05 0.0 2.881395e-05 0.001 2.881400e-05 0.0 2.881405e-05 0.001 2.881410e-05 0.0 2.881415e-05 0.001 2.881420e-05 0.0 2.881425e-05 0.001 2.881430e-05 0.0 2.881435e-05 0.001 2.881440e-05 0.0 2.881445e-05 0.001 2.881450e-05 0.0 2.881455e-05 0.001 2.881460e-05 0.0 2.881465e-05 0.001 2.881470e-05 0.0 2.881475e-05 0.001 2.881480e-05 0.0 2.881485e-05 0.001 2.881490e-05 0.0 2.881495e-05 0.001 2.881500e-05 0.0 2.881505e-05 0.001 2.881510e-05 0.0 2.881515e-05 0.001 2.881520e-05 0.0 2.881525e-05 0.001 2.881530e-05 0.0 2.881535e-05 0.001 2.881540e-05 0.0 2.881545e-05 0.001 2.881550e-05 0.0 2.881555e-05 0.001 2.881560e-05 0.0 2.881565e-05 0.001 2.881570e-05 0.0 2.881575e-05 0.001 2.881580e-05 0.0 2.881585e-05 0.001 2.881590e-05 0.0 2.881595e-05 0.001 2.881600e-05 0.0 2.881605e-05 0.001 2.881610e-05 0.0 2.881615e-05 0.001 2.881620e-05 0.0 2.881625e-05 0.001 2.881630e-05 0.0 2.881635e-05 0.001 2.881640e-05 0.0 2.881645e-05 0.001 2.881650e-05 0.0 2.881655e-05 0.001 2.881660e-05 0.0 2.881665e-05 0.001 2.881670e-05 0.0 2.881675e-05 0.001 2.881680e-05 0.0 2.881685e-05 0.001 2.881690e-05 0.0 2.881695e-05 0.001 2.881700e-05 0.0 2.881705e-05 0.001 2.881710e-05 0.0 2.881715e-05 0.001 2.881720e-05 0.0 2.881725e-05 0.001 2.881730e-05 0.0 2.881735e-05 0.001 2.881740e-05 0.0 2.881745e-05 0.001 2.881750e-05 0.0 2.881755e-05 0.001 2.881760e-05 0.0 2.881765e-05 0.001 2.881770e-05 0.0 2.881775e-05 0.001 2.881780e-05 0.0 2.881785e-05 0.001 2.881790e-05 0.0 2.881795e-05 0.001 2.881800e-05 0.0 2.881805e-05 0.001 2.881810e-05 0.0 2.881815e-05 0.001 2.881820e-05 0.0 2.881825e-05 0.001 2.881830e-05 0.0 2.881835e-05 0.001 2.881840e-05 0.0 2.881845e-05 0.001 2.881850e-05 0.0 2.881855e-05 0.001 2.881860e-05 0.0 2.881865e-05 0.001 2.881870e-05 0.0 2.881875e-05 0.001 2.881880e-05 0.0 2.881885e-05 0.001 2.881890e-05 0.0 2.881895e-05 0.001 2.881900e-05 0.0 2.881905e-05 0.001 2.881910e-05 0.0 2.881915e-05 0.001 2.881920e-05 0.0 2.881925e-05 0.001 2.881930e-05 0.0 2.881935e-05 0.001 2.881940e-05 0.0 2.881945e-05 0.001 2.881950e-05 0.0 2.881955e-05 0.001 2.881960e-05 0.0 2.881965e-05 0.001 2.881970e-05 0.0 2.881975e-05 0.001 2.881980e-05 0.0 2.881985e-05 0.001 2.881990e-05 0.0 2.881995e-05 0.001 2.882000e-05 0.0 2.882005e-05 0.001 2.882010e-05 0.0 2.882015e-05 0.001 2.882020e-05 0.0 2.882025e-05 0.001 2.882030e-05 0.0 2.882035e-05 0.001 2.882040e-05 0.0 2.882045e-05 0.001 2.882050e-05 0.0 2.882055e-05 0.001 2.882060e-05 0.0 2.882065e-05 0.001 2.882070e-05 0.0 2.882075e-05 0.001 2.882080e-05 0.0 2.882085e-05 0.001 2.882090e-05 0.0 2.882095e-05 0.001 2.882100e-05 0.0 2.882105e-05 0.001 2.882110e-05 0.0 2.882115e-05 0.001 2.882120e-05 0.0 2.882125e-05 0.001 2.882130e-05 0.0 2.882135e-05 0.001 2.882140e-05 0.0 2.882145e-05 0.001 2.882150e-05 0.0 2.882155e-05 0.001 2.882160e-05 0.0 2.882165e-05 0.001 2.882170e-05 0.0 2.882175e-05 0.001 2.882180e-05 0.0 2.882185e-05 0.001 2.882190e-05 0.0 2.882195e-05 0.001 2.882200e-05 0.0 2.882205e-05 0.001 2.882210e-05 0.0 2.882215e-05 0.001 2.882220e-05 0.0 2.882225e-05 0.001 2.882230e-05 0.0 2.882235e-05 0.001 2.882240e-05 0.0 2.882245e-05 0.001 2.882250e-05 0.0 2.882255e-05 0.001 2.882260e-05 0.0 2.882265e-05 0.001 2.882270e-05 0.0 2.882275e-05 0.001 2.882280e-05 0.0 2.882285e-05 0.001 2.882290e-05 0.0 2.882295e-05 0.001 2.882300e-05 0.0 2.882305e-05 0.001 2.882310e-05 0.0 2.882315e-05 0.001 2.882320e-05 0.0 2.882325e-05 0.001 2.882330e-05 0.0 2.882335e-05 0.001 2.882340e-05 0.0 2.882345e-05 0.001 2.882350e-05 0.0 2.882355e-05 0.001 2.882360e-05 0.0 2.882365e-05 0.001 2.882370e-05 0.0 2.882375e-05 0.001 2.882380e-05 0.0 2.882385e-05 0.001 2.882390e-05 0.0 2.882395e-05 0.001 2.882400e-05 0.0 2.882405e-05 0.001 2.882410e-05 0.0 2.882415e-05 0.001 2.882420e-05 0.0 2.882425e-05 0.001 2.882430e-05 0.0 2.882435e-05 0.001 2.882440e-05 0.0 2.882445e-05 0.001 2.882450e-05 0.0 2.882455e-05 0.001 2.882460e-05 0.0 2.882465e-05 0.001 2.882470e-05 0.0 2.882475e-05 0.001 2.882480e-05 0.0 2.882485e-05 0.001 2.882490e-05 0.0 2.882495e-05 0.001 2.882500e-05 0.0 2.882505e-05 0.001 2.882510e-05 0.0 2.882515e-05 0.001 2.882520e-05 0.0 2.882525e-05 0.001 2.882530e-05 0.0 2.882535e-05 0.001 2.882540e-05 0.0 2.882545e-05 0.001 2.882550e-05 0.0 2.882555e-05 0.001 2.882560e-05 0.0 2.882565e-05 0.001 2.882570e-05 0.0 2.882575e-05 0.001 2.882580e-05 0.0 2.882585e-05 0.001 2.882590e-05 0.0 2.882595e-05 0.001 2.882600e-05 0.0 2.882605e-05 0.001 2.882610e-05 0.0 2.882615e-05 0.001 2.882620e-05 0.0 2.882625e-05 0.001 2.882630e-05 0.0 2.882635e-05 0.001 2.882640e-05 0.0 2.882645e-05 0.001 2.882650e-05 0.0 2.882655e-05 0.001 2.882660e-05 0.0 2.882665e-05 0.001 2.882670e-05 0.0 2.882675e-05 0.001 2.882680e-05 0.0 2.882685e-05 0.001 2.882690e-05 0.0 2.882695e-05 0.001 2.882700e-05 0.0 2.882705e-05 0.001 2.882710e-05 0.0 2.882715e-05 0.001 2.882720e-05 0.0 2.882725e-05 0.001 2.882730e-05 0.0 2.882735e-05 0.001 2.882740e-05 0.0 2.882745e-05 0.001 2.882750e-05 0.0 2.882755e-05 0.001 2.882760e-05 0.0 2.882765e-05 0.001 2.882770e-05 0.0 2.882775e-05 0.001 2.882780e-05 0.0 2.882785e-05 0.001 2.882790e-05 0.0 2.882795e-05 0.001 2.882800e-05 0.0 2.882805e-05 0.001 2.882810e-05 0.0 2.882815e-05 0.001 2.882820e-05 0.0 2.882825e-05 0.001 2.882830e-05 0.0 2.882835e-05 0.001 2.882840e-05 0.0 2.882845e-05 0.001 2.882850e-05 0.0 2.882855e-05 0.001 2.882860e-05 0.0 2.882865e-05 0.001 2.882870e-05 0.0 2.882875e-05 0.001 2.882880e-05 0.0 2.882885e-05 0.001 2.882890e-05 0.0 2.882895e-05 0.001 2.882900e-05 0.0 2.882905e-05 0.001 2.882910e-05 0.0 2.882915e-05 0.001 2.882920e-05 0.0 2.882925e-05 0.001 2.882930e-05 0.0 2.882935e-05 0.001 2.882940e-05 0.0 2.882945e-05 0.001 2.882950e-05 0.0 2.882955e-05 0.001 2.882960e-05 0.0 2.882965e-05 0.001 2.882970e-05 0.0 2.882975e-05 0.001 2.882980e-05 0.0 2.882985e-05 0.001 2.882990e-05 0.0 2.882995e-05 0.001 2.883000e-05 0.0 2.883005e-05 0.001 2.883010e-05 0.0 2.883015e-05 0.001 2.883020e-05 0.0 2.883025e-05 0.001 2.883030e-05 0.0 2.883035e-05 0.001 2.883040e-05 0.0 2.883045e-05 0.001 2.883050e-05 0.0 2.883055e-05 0.001 2.883060e-05 0.0 2.883065e-05 0.001 2.883070e-05 0.0 2.883075e-05 0.001 2.883080e-05 0.0 2.883085e-05 0.001 2.883090e-05 0.0 2.883095e-05 0.001 2.883100e-05 0.0 2.883105e-05 0.001 2.883110e-05 0.0 2.883115e-05 0.001 2.883120e-05 0.0 2.883125e-05 0.001 2.883130e-05 0.0 2.883135e-05 0.001 2.883140e-05 0.0 2.883145e-05 0.001 2.883150e-05 0.0 2.883155e-05 0.001 2.883160e-05 0.0 2.883165e-05 0.001 2.883170e-05 0.0 2.883175e-05 0.001 2.883180e-05 0.0 2.883185e-05 0.001 2.883190e-05 0.0 2.883195e-05 0.001 2.883200e-05 0.0 2.883205e-05 0.001 2.883210e-05 0.0 2.883215e-05 0.001 2.883220e-05 0.0 2.883225e-05 0.001 2.883230e-05 0.0 2.883235e-05 0.001 2.883240e-05 0.0 2.883245e-05 0.001 2.883250e-05 0.0 2.883255e-05 0.001 2.883260e-05 0.0 2.883265e-05 0.001 2.883270e-05 0.0 2.883275e-05 0.001 2.883280e-05 0.0 2.883285e-05 0.001 2.883290e-05 0.0 2.883295e-05 0.001 2.883300e-05 0.0 2.883305e-05 0.001 2.883310e-05 0.0 2.883315e-05 0.001 2.883320e-05 0.0 2.883325e-05 0.001 2.883330e-05 0.0 2.883335e-05 0.001 2.883340e-05 0.0 2.883345e-05 0.001 2.883350e-05 0.0 2.883355e-05 0.001 2.883360e-05 0.0 2.883365e-05 0.001 2.883370e-05 0.0 2.883375e-05 0.001 2.883380e-05 0.0 2.883385e-05 0.001 2.883390e-05 0.0 2.883395e-05 0.001 2.883400e-05 0.0 2.883405e-05 0.001 2.883410e-05 0.0 2.883415e-05 0.001 2.883420e-05 0.0 2.883425e-05 0.001 2.883430e-05 0.0 2.883435e-05 0.001 2.883440e-05 0.0 2.883445e-05 0.001 2.883450e-05 0.0 2.883455e-05 0.001 2.883460e-05 0.0 2.883465e-05 0.001 2.883470e-05 0.0 2.883475e-05 0.001 2.883480e-05 0.0 2.883485e-05 0.001 2.883490e-05 0.0 2.883495e-05 0.001 2.883500e-05 0.0 2.883505e-05 0.001 2.883510e-05 0.0 2.883515e-05 0.001 2.883520e-05 0.0 2.883525e-05 0.001 2.883530e-05 0.0 2.883535e-05 0.001 2.883540e-05 0.0 2.883545e-05 0.001 2.883550e-05 0.0 2.883555e-05 0.001 2.883560e-05 0.0 2.883565e-05 0.001 2.883570e-05 0.0 2.883575e-05 0.001 2.883580e-05 0.0 2.883585e-05 0.001 2.883590e-05 0.0 2.883595e-05 0.001 2.883600e-05 0.0 2.883605e-05 0.001 2.883610e-05 0.0 2.883615e-05 0.001 2.883620e-05 0.0 2.883625e-05 0.001 2.883630e-05 0.0 2.883635e-05 0.001 2.883640e-05 0.0 2.883645e-05 0.001 2.883650e-05 0.0 2.883655e-05 0.001 2.883660e-05 0.0 2.883665e-05 0.001 2.883670e-05 0.0 2.883675e-05 0.001 2.883680e-05 0.0 2.883685e-05 0.001 2.883690e-05 0.0 2.883695e-05 0.001 2.883700e-05 0.0 2.883705e-05 0.001 2.883710e-05 0.0 2.883715e-05 0.001 2.883720e-05 0.0 2.883725e-05 0.001 2.883730e-05 0.0 2.883735e-05 0.001 2.883740e-05 0.0 2.883745e-05 0.001 2.883750e-05 0.0 2.883755e-05 0.001 2.883760e-05 0.0 2.883765e-05 0.001 2.883770e-05 0.0 2.883775e-05 0.001 2.883780e-05 0.0 2.883785e-05 0.001 2.883790e-05 0.0 2.883795e-05 0.001 2.883800e-05 0.0 2.883805e-05 0.001 2.883810e-05 0.0 2.883815e-05 0.001 2.883820e-05 0.0 2.883825e-05 0.001 2.883830e-05 0.0 2.883835e-05 0.001 2.883840e-05 0.0 2.883845e-05 0.001 2.883850e-05 0.0 2.883855e-05 0.001 2.883860e-05 0.0 2.883865e-05 0.001 2.883870e-05 0.0 2.883875e-05 0.001 2.883880e-05 0.0 2.883885e-05 0.001 2.883890e-05 0.0 2.883895e-05 0.001 2.883900e-05 0.0 2.883905e-05 0.001 2.883910e-05 0.0 2.883915e-05 0.001 2.883920e-05 0.0 2.883925e-05 0.001 2.883930e-05 0.0 2.883935e-05 0.001 2.883940e-05 0.0 2.883945e-05 0.001 2.883950e-05 0.0 2.883955e-05 0.001 2.883960e-05 0.0 2.883965e-05 0.001 2.883970e-05 0.0 2.883975e-05 0.001 2.883980e-05 0.0 2.883985e-05 0.001 2.883990e-05 0.0 2.883995e-05 0.001 2.884000e-05 0.0 2.884005e-05 0.001 2.884010e-05 0.0 2.884015e-05 0.001 2.884020e-05 0.0 2.884025e-05 0.001 2.884030e-05 0.0 2.884035e-05 0.001 2.884040e-05 0.0 2.884045e-05 0.001 2.884050e-05 0.0 2.884055e-05 0.001 2.884060e-05 0.0 2.884065e-05 0.001 2.884070e-05 0.0 2.884075e-05 0.001 2.884080e-05 0.0 2.884085e-05 0.001 2.884090e-05 0.0 2.884095e-05 0.001 2.884100e-05 0.0 2.884105e-05 0.001 2.884110e-05 0.0 2.884115e-05 0.001 2.884120e-05 0.0 2.884125e-05 0.001 2.884130e-05 0.0 2.884135e-05 0.001 2.884140e-05 0.0 2.884145e-05 0.001 2.884150e-05 0.0 2.884155e-05 0.001 2.884160e-05 0.0 2.884165e-05 0.001 2.884170e-05 0.0 2.884175e-05 0.001 2.884180e-05 0.0 2.884185e-05 0.001 2.884190e-05 0.0 2.884195e-05 0.001 2.884200e-05 0.0 2.884205e-05 0.001 2.884210e-05 0.0 2.884215e-05 0.001 2.884220e-05 0.0 2.884225e-05 0.001 2.884230e-05 0.0 2.884235e-05 0.001 2.884240e-05 0.0 2.884245e-05 0.001 2.884250e-05 0.0 2.884255e-05 0.001 2.884260e-05 0.0 2.884265e-05 0.001 2.884270e-05 0.0 2.884275e-05 0.001 2.884280e-05 0.0 2.884285e-05 0.001 2.884290e-05 0.0 2.884295e-05 0.001 2.884300e-05 0.0 2.884305e-05 0.001 2.884310e-05 0.0 2.884315e-05 0.001 2.884320e-05 0.0 2.884325e-05 0.001 2.884330e-05 0.0 2.884335e-05 0.001 2.884340e-05 0.0 2.884345e-05 0.001 2.884350e-05 0.0 2.884355e-05 0.001 2.884360e-05 0.0 2.884365e-05 0.001 2.884370e-05 0.0 2.884375e-05 0.001 2.884380e-05 0.0 2.884385e-05 0.001 2.884390e-05 0.0 2.884395e-05 0.001 2.884400e-05 0.0 2.884405e-05 0.001 2.884410e-05 0.0 2.884415e-05 0.001 2.884420e-05 0.0 2.884425e-05 0.001 2.884430e-05 0.0 2.884435e-05 0.001 2.884440e-05 0.0 2.884445e-05 0.001 2.884450e-05 0.0 2.884455e-05 0.001 2.884460e-05 0.0 2.884465e-05 0.001 2.884470e-05 0.0 2.884475e-05 0.001 2.884480e-05 0.0 2.884485e-05 0.001 2.884490e-05 0.0 2.884495e-05 0.001 2.884500e-05 0.0 2.884505e-05 0.001 2.884510e-05 0.0 2.884515e-05 0.001 2.884520e-05 0.0 2.884525e-05 0.001 2.884530e-05 0.0 2.884535e-05 0.001 2.884540e-05 0.0 2.884545e-05 0.001 2.884550e-05 0.0 2.884555e-05 0.001 2.884560e-05 0.0 2.884565e-05 0.001 2.884570e-05 0.0 2.884575e-05 0.001 2.884580e-05 0.0 2.884585e-05 0.001 2.884590e-05 0.0 2.884595e-05 0.001 2.884600e-05 0.0 2.884605e-05 0.001 2.884610e-05 0.0 2.884615e-05 0.001 2.884620e-05 0.0 2.884625e-05 0.001 2.884630e-05 0.0 2.884635e-05 0.001 2.884640e-05 0.0 2.884645e-05 0.001 2.884650e-05 0.0 2.884655e-05 0.001 2.884660e-05 0.0 2.884665e-05 0.001 2.884670e-05 0.0 2.884675e-05 0.001 2.884680e-05 0.0 2.884685e-05 0.001 2.884690e-05 0.0 2.884695e-05 0.001 2.884700e-05 0.0 2.884705e-05 0.001 2.884710e-05 0.0 2.884715e-05 0.001 2.884720e-05 0.0 2.884725e-05 0.001 2.884730e-05 0.0 2.884735e-05 0.001 2.884740e-05 0.0 2.884745e-05 0.001 2.884750e-05 0.0 2.884755e-05 0.001 2.884760e-05 0.0 2.884765e-05 0.001 2.884770e-05 0.0 2.884775e-05 0.001 2.884780e-05 0.0 2.884785e-05 0.001 2.884790e-05 0.0 2.884795e-05 0.001 2.884800e-05 0.0 2.884805e-05 0.001 2.884810e-05 0.0 2.884815e-05 0.001 2.884820e-05 0.0 2.884825e-05 0.001 2.884830e-05 0.0 2.884835e-05 0.001 2.884840e-05 0.0 2.884845e-05 0.001 2.884850e-05 0.0 2.884855e-05 0.001 2.884860e-05 0.0 2.884865e-05 0.001 2.884870e-05 0.0 2.884875e-05 0.001 2.884880e-05 0.0 2.884885e-05 0.001 2.884890e-05 0.0 2.884895e-05 0.001 2.884900e-05 0.0 2.884905e-05 0.001 2.884910e-05 0.0 2.884915e-05 0.001 2.884920e-05 0.0 2.884925e-05 0.001 2.884930e-05 0.0 2.884935e-05 0.001 2.884940e-05 0.0 2.884945e-05 0.001 2.884950e-05 0.0 2.884955e-05 0.001 2.884960e-05 0.0 2.884965e-05 0.001 2.884970e-05 0.0 2.884975e-05 0.001 2.884980e-05 0.0 2.884985e-05 0.001 2.884990e-05 0.0 2.884995e-05 0.001 2.885000e-05 0.0 2.885005e-05 0.001 2.885010e-05 0.0 2.885015e-05 0.001 2.885020e-05 0.0 2.885025e-05 0.001 2.885030e-05 0.0 2.885035e-05 0.001 2.885040e-05 0.0 2.885045e-05 0.001 2.885050e-05 0.0 2.885055e-05 0.001 2.885060e-05 0.0 2.885065e-05 0.001 2.885070e-05 0.0 2.885075e-05 0.001 2.885080e-05 0.0 2.885085e-05 0.001 2.885090e-05 0.0 2.885095e-05 0.001 2.885100e-05 0.0 2.885105e-05 0.001 2.885110e-05 0.0 2.885115e-05 0.001 2.885120e-05 0.0 2.885125e-05 0.001 2.885130e-05 0.0 2.885135e-05 0.001 2.885140e-05 0.0 2.885145e-05 0.001 2.885150e-05 0.0 2.885155e-05 0.001 2.885160e-05 0.0 2.885165e-05 0.001 2.885170e-05 0.0 2.885175e-05 0.001 2.885180e-05 0.0 2.885185e-05 0.001 2.885190e-05 0.0 2.885195e-05 0.001 2.885200e-05 0.0 2.885205e-05 0.001 2.885210e-05 0.0 2.885215e-05 0.001 2.885220e-05 0.0 2.885225e-05 0.001 2.885230e-05 0.0 2.885235e-05 0.001 2.885240e-05 0.0 2.885245e-05 0.001 2.885250e-05 0.0 2.885255e-05 0.001 2.885260e-05 0.0 2.885265e-05 0.001 2.885270e-05 0.0 2.885275e-05 0.001 2.885280e-05 0.0 2.885285e-05 0.001 2.885290e-05 0.0 2.885295e-05 0.001 2.885300e-05 0.0 2.885305e-05 0.001 2.885310e-05 0.0 2.885315e-05 0.001 2.885320e-05 0.0 2.885325e-05 0.001 2.885330e-05 0.0 2.885335e-05 0.001 2.885340e-05 0.0 2.885345e-05 0.001 2.885350e-05 0.0 2.885355e-05 0.001 2.885360e-05 0.0 2.885365e-05 0.001 2.885370e-05 0.0 2.885375e-05 0.001 2.885380e-05 0.0 2.885385e-05 0.001 2.885390e-05 0.0 2.885395e-05 0.001 2.885400e-05 0.0 2.885405e-05 0.001 2.885410e-05 0.0 2.885415e-05 0.001 2.885420e-05 0.0 2.885425e-05 0.001 2.885430e-05 0.0 2.885435e-05 0.001 2.885440e-05 0.0 2.885445e-05 0.001 2.885450e-05 0.0 2.885455e-05 0.001 2.885460e-05 0.0 2.885465e-05 0.001 2.885470e-05 0.0 2.885475e-05 0.001 2.885480e-05 0.0 2.885485e-05 0.001 2.885490e-05 0.0 2.885495e-05 0.001 2.885500e-05 0.0 2.885505e-05 0.001 2.885510e-05 0.0 2.885515e-05 0.001 2.885520e-05 0.0 2.885525e-05 0.001 2.885530e-05 0.0 2.885535e-05 0.001 2.885540e-05 0.0 2.885545e-05 0.001 2.885550e-05 0.0 2.885555e-05 0.001 2.885560e-05 0.0 2.885565e-05 0.001 2.885570e-05 0.0 2.885575e-05 0.001 2.885580e-05 0.0 2.885585e-05 0.001 2.885590e-05 0.0 2.885595e-05 0.001 2.885600e-05 0.0 2.885605e-05 0.001 2.885610e-05 0.0 2.885615e-05 0.001 2.885620e-05 0.0 2.885625e-05 0.001 2.885630e-05 0.0 2.885635e-05 0.001 2.885640e-05 0.0 2.885645e-05 0.001 2.885650e-05 0.0 2.885655e-05 0.001 2.885660e-05 0.0 2.885665e-05 0.001 2.885670e-05 0.0 2.885675e-05 0.001 2.885680e-05 0.0 2.885685e-05 0.001 2.885690e-05 0.0 2.885695e-05 0.001 2.885700e-05 0.0 2.885705e-05 0.001 2.885710e-05 0.0 2.885715e-05 0.001 2.885720e-05 0.0 2.885725e-05 0.001 2.885730e-05 0.0 2.885735e-05 0.001 2.885740e-05 0.0 2.885745e-05 0.001 2.885750e-05 0.0 2.885755e-05 0.001 2.885760e-05 0.0 2.885765e-05 0.001 2.885770e-05 0.0 2.885775e-05 0.001 2.885780e-05 0.0 2.885785e-05 0.001 2.885790e-05 0.0 2.885795e-05 0.001 2.885800e-05 0.0 2.885805e-05 0.001 2.885810e-05 0.0 2.885815e-05 0.001 2.885820e-05 0.0 2.885825e-05 0.001 2.885830e-05 0.0 2.885835e-05 0.001 2.885840e-05 0.0 2.885845e-05 0.001 2.885850e-05 0.0 2.885855e-05 0.001 2.885860e-05 0.0 2.885865e-05 0.001 2.885870e-05 0.0 2.885875e-05 0.001 2.885880e-05 0.0 2.885885e-05 0.001 2.885890e-05 0.0 2.885895e-05 0.001 2.885900e-05 0.0 2.885905e-05 0.001 2.885910e-05 0.0 2.885915e-05 0.001 2.885920e-05 0.0 2.885925e-05 0.001 2.885930e-05 0.0 2.885935e-05 0.001 2.885940e-05 0.0 2.885945e-05 0.001 2.885950e-05 0.0 2.885955e-05 0.001 2.885960e-05 0.0 2.885965e-05 0.001 2.885970e-05 0.0 2.885975e-05 0.001 2.885980e-05 0.0 2.885985e-05 0.001 2.885990e-05 0.0 2.885995e-05 0.001 2.886000e-05 0.0 2.886005e-05 0.001 2.886010e-05 0.0 2.886015e-05 0.001 2.886020e-05 0.0 2.886025e-05 0.001 2.886030e-05 0.0 2.886035e-05 0.001 2.886040e-05 0.0 2.886045e-05 0.001 2.886050e-05 0.0 2.886055e-05 0.001 2.886060e-05 0.0 2.886065e-05 0.001 2.886070e-05 0.0 2.886075e-05 0.001 2.886080e-05 0.0 2.886085e-05 0.001 2.886090e-05 0.0 2.886095e-05 0.001 2.886100e-05 0.0 2.886105e-05 0.001 2.886110e-05 0.0 2.886115e-05 0.001 2.886120e-05 0.0 2.886125e-05 0.001 2.886130e-05 0.0 2.886135e-05 0.001 2.886140e-05 0.0 2.886145e-05 0.001 2.886150e-05 0.0 2.886155e-05 0.001 2.886160e-05 0.0 2.886165e-05 0.001 2.886170e-05 0.0 2.886175e-05 0.001 2.886180e-05 0.0 2.886185e-05 0.001 2.886190e-05 0.0 2.886195e-05 0.001 2.886200e-05 0.0 2.886205e-05 0.001 2.886210e-05 0.0 2.886215e-05 0.001 2.886220e-05 0.0 2.886225e-05 0.001 2.886230e-05 0.0 2.886235e-05 0.001 2.886240e-05 0.0 2.886245e-05 0.001 2.886250e-05 0.0 2.886255e-05 0.001 2.886260e-05 0.0 2.886265e-05 0.001 2.886270e-05 0.0 2.886275e-05 0.001 2.886280e-05 0.0 2.886285e-05 0.001 2.886290e-05 0.0 2.886295e-05 0.001 2.886300e-05 0.0 2.886305e-05 0.001 2.886310e-05 0.0 2.886315e-05 0.001 2.886320e-05 0.0 2.886325e-05 0.001 2.886330e-05 0.0 2.886335e-05 0.001 2.886340e-05 0.0 2.886345e-05 0.001 2.886350e-05 0.0 2.886355e-05 0.001 2.886360e-05 0.0 2.886365e-05 0.001 2.886370e-05 0.0 2.886375e-05 0.001 2.886380e-05 0.0 2.886385e-05 0.001 2.886390e-05 0.0 2.886395e-05 0.001 2.886400e-05 0.0 2.886405e-05 0.001 2.886410e-05 0.0 2.886415e-05 0.001 2.886420e-05 0.0 2.886425e-05 0.001 2.886430e-05 0.0 2.886435e-05 0.001 2.886440e-05 0.0 2.886445e-05 0.001 2.886450e-05 0.0 2.886455e-05 0.001 2.886460e-05 0.0 2.886465e-05 0.001 2.886470e-05 0.0 2.886475e-05 0.001 2.886480e-05 0.0 2.886485e-05 0.001 2.886490e-05 0.0 2.886495e-05 0.001 2.886500e-05 0.0 2.886505e-05 0.001 2.886510e-05 0.0 2.886515e-05 0.001 2.886520e-05 0.0 2.886525e-05 0.001 2.886530e-05 0.0 2.886535e-05 0.001 2.886540e-05 0.0 2.886545e-05 0.001 2.886550e-05 0.0 2.886555e-05 0.001 2.886560e-05 0.0 2.886565e-05 0.001 2.886570e-05 0.0 2.886575e-05 0.001 2.886580e-05 0.0 2.886585e-05 0.001 2.886590e-05 0.0 2.886595e-05 0.001 2.886600e-05 0.0 2.886605e-05 0.001 2.886610e-05 0.0 2.886615e-05 0.001 2.886620e-05 0.0 2.886625e-05 0.001 2.886630e-05 0.0 2.886635e-05 0.001 2.886640e-05 0.0 2.886645e-05 0.001 2.886650e-05 0.0 2.886655e-05 0.001 2.886660e-05 0.0 2.886665e-05 0.001 2.886670e-05 0.0 2.886675e-05 0.001 2.886680e-05 0.0 2.886685e-05 0.001 2.886690e-05 0.0 2.886695e-05 0.001 2.886700e-05 0.0 2.886705e-05 0.001 2.886710e-05 0.0 2.886715e-05 0.001 2.886720e-05 0.0 2.886725e-05 0.001 2.886730e-05 0.0 2.886735e-05 0.001 2.886740e-05 0.0 2.886745e-05 0.001 2.886750e-05 0.0 2.886755e-05 0.001 2.886760e-05 0.0 2.886765e-05 0.001 2.886770e-05 0.0 2.886775e-05 0.001 2.886780e-05 0.0 2.886785e-05 0.001 2.886790e-05 0.0 2.886795e-05 0.001 2.886800e-05 0.0 2.886805e-05 0.001 2.886810e-05 0.0 2.886815e-05 0.001 2.886820e-05 0.0 2.886825e-05 0.001 2.886830e-05 0.0 2.886835e-05 0.001 2.886840e-05 0.0 2.886845e-05 0.001 2.886850e-05 0.0 2.886855e-05 0.001 2.886860e-05 0.0 2.886865e-05 0.001 2.886870e-05 0.0 2.886875e-05 0.001 2.886880e-05 0.0 2.886885e-05 0.001 2.886890e-05 0.0 2.886895e-05 0.001 2.886900e-05 0.0 2.886905e-05 0.001 2.886910e-05 0.0 2.886915e-05 0.001 2.886920e-05 0.0 2.886925e-05 0.001 2.886930e-05 0.0 2.886935e-05 0.001 2.886940e-05 0.0 2.886945e-05 0.001 2.886950e-05 0.0 2.886955e-05 0.001 2.886960e-05 0.0 2.886965e-05 0.001 2.886970e-05 0.0 2.886975e-05 0.001 2.886980e-05 0.0 2.886985e-05 0.001 2.886990e-05 0.0 2.886995e-05 0.001 2.887000e-05 0.0 2.887005e-05 0.001 2.887010e-05 0.0 2.887015e-05 0.001 2.887020e-05 0.0 2.887025e-05 0.001 2.887030e-05 0.0 2.887035e-05 0.001 2.887040e-05 0.0 2.887045e-05 0.001 2.887050e-05 0.0 2.887055e-05 0.001 2.887060e-05 0.0 2.887065e-05 0.001 2.887070e-05 0.0 2.887075e-05 0.001 2.887080e-05 0.0 2.887085e-05 0.001 2.887090e-05 0.0 2.887095e-05 0.001 2.887100e-05 0.0 2.887105e-05 0.001 2.887110e-05 0.0 2.887115e-05 0.001 2.887120e-05 0.0 2.887125e-05 0.001 2.887130e-05 0.0 2.887135e-05 0.001 2.887140e-05 0.0 2.887145e-05 0.001 2.887150e-05 0.0 2.887155e-05 0.001 2.887160e-05 0.0 2.887165e-05 0.001 2.887170e-05 0.0 2.887175e-05 0.001 2.887180e-05 0.0 2.887185e-05 0.001 2.887190e-05 0.0 2.887195e-05 0.001 2.887200e-05 0.0 2.887205e-05 0.001 2.887210e-05 0.0 2.887215e-05 0.001 2.887220e-05 0.0 2.887225e-05 0.001 2.887230e-05 0.0 2.887235e-05 0.001 2.887240e-05 0.0 2.887245e-05 0.001 2.887250e-05 0.0 2.887255e-05 0.001 2.887260e-05 0.0 2.887265e-05 0.001 2.887270e-05 0.0 2.887275e-05 0.001 2.887280e-05 0.0 2.887285e-05 0.001 2.887290e-05 0.0 2.887295e-05 0.001 2.887300e-05 0.0 2.887305e-05 0.001 2.887310e-05 0.0 2.887315e-05 0.001 2.887320e-05 0.0 2.887325e-05 0.001 2.887330e-05 0.0 2.887335e-05 0.001 2.887340e-05 0.0 2.887345e-05 0.001 2.887350e-05 0.0 2.887355e-05 0.001 2.887360e-05 0.0 2.887365e-05 0.001 2.887370e-05 0.0 2.887375e-05 0.001 2.887380e-05 0.0 2.887385e-05 0.001 2.887390e-05 0.0 2.887395e-05 0.001 2.887400e-05 0.0 2.887405e-05 0.001 2.887410e-05 0.0 2.887415e-05 0.001 2.887420e-05 0.0 2.887425e-05 0.001 2.887430e-05 0.0 2.887435e-05 0.001 2.887440e-05 0.0 2.887445e-05 0.001 2.887450e-05 0.0 2.887455e-05 0.001 2.887460e-05 0.0 2.887465e-05 0.001 2.887470e-05 0.0 2.887475e-05 0.001 2.887480e-05 0.0 2.887485e-05 0.001 2.887490e-05 0.0 2.887495e-05 0.001 2.887500e-05 0.0 2.887505e-05 0.001 2.887510e-05 0.0 2.887515e-05 0.001 2.887520e-05 0.0 2.887525e-05 0.001 2.887530e-05 0.0 2.887535e-05 0.001 2.887540e-05 0.0 2.887545e-05 0.001 2.887550e-05 0.0 2.887555e-05 0.001 2.887560e-05 0.0 2.887565e-05 0.001 2.887570e-05 0.0 2.887575e-05 0.001 2.887580e-05 0.0 2.887585e-05 0.001 2.887590e-05 0.0 2.887595e-05 0.001 2.887600e-05 0.0 2.887605e-05 0.001 2.887610e-05 0.0 2.887615e-05 0.001 2.887620e-05 0.0 2.887625e-05 0.001 2.887630e-05 0.0 2.887635e-05 0.001 2.887640e-05 0.0 2.887645e-05 0.001 2.887650e-05 0.0 2.887655e-05 0.001 2.887660e-05 0.0 2.887665e-05 0.001 2.887670e-05 0.0 2.887675e-05 0.001 2.887680e-05 0.0 2.887685e-05 0.001 2.887690e-05 0.0 2.887695e-05 0.001 2.887700e-05 0.0 2.887705e-05 0.001 2.887710e-05 0.0 2.887715e-05 0.001 2.887720e-05 0.0 2.887725e-05 0.001 2.887730e-05 0.0 2.887735e-05 0.001 2.887740e-05 0.0 2.887745e-05 0.001 2.887750e-05 0.0 2.887755e-05 0.001 2.887760e-05 0.0 2.887765e-05 0.001 2.887770e-05 0.0 2.887775e-05 0.001 2.887780e-05 0.0 2.887785e-05 0.001 2.887790e-05 0.0 2.887795e-05 0.001 2.887800e-05 0.0 2.887805e-05 0.001 2.887810e-05 0.0 2.887815e-05 0.001 2.887820e-05 0.0 2.887825e-05 0.001 2.887830e-05 0.0 2.887835e-05 0.001 2.887840e-05 0.0 2.887845e-05 0.001 2.887850e-05 0.0 2.887855e-05 0.001 2.887860e-05 0.0 2.887865e-05 0.001 2.887870e-05 0.0 2.887875e-05 0.001 2.887880e-05 0.0 2.887885e-05 0.001 2.887890e-05 0.0 2.887895e-05 0.001 2.887900e-05 0.0 2.887905e-05 0.001 2.887910e-05 0.0 2.887915e-05 0.001 2.887920e-05 0.0 2.887925e-05 0.001 2.887930e-05 0.0 2.887935e-05 0.001 2.887940e-05 0.0 2.887945e-05 0.001 2.887950e-05 0.0 2.887955e-05 0.001 2.887960e-05 0.0 2.887965e-05 0.001 2.887970e-05 0.0 2.887975e-05 0.001 2.887980e-05 0.0 2.887985e-05 0.001 2.887990e-05 0.0 2.887995e-05 0.001 2.888000e-05 0.0 2.888005e-05 0.001 2.888010e-05 0.0 2.888015e-05 0.001 2.888020e-05 0.0 2.888025e-05 0.001 2.888030e-05 0.0 2.888035e-05 0.001 2.888040e-05 0.0 2.888045e-05 0.001 2.888050e-05 0.0 2.888055e-05 0.001 2.888060e-05 0.0 2.888065e-05 0.001 2.888070e-05 0.0 2.888075e-05 0.001 2.888080e-05 0.0 2.888085e-05 0.001 2.888090e-05 0.0 2.888095e-05 0.001 2.888100e-05 0.0 2.888105e-05 0.001 2.888110e-05 0.0 2.888115e-05 0.001 2.888120e-05 0.0 2.888125e-05 0.001 2.888130e-05 0.0 2.888135e-05 0.001 2.888140e-05 0.0 2.888145e-05 0.001 2.888150e-05 0.0 2.888155e-05 0.001 2.888160e-05 0.0 2.888165e-05 0.001 2.888170e-05 0.0 2.888175e-05 0.001 2.888180e-05 0.0 2.888185e-05 0.001 2.888190e-05 0.0 2.888195e-05 0.001 2.888200e-05 0.0 2.888205e-05 0.001 2.888210e-05 0.0 2.888215e-05 0.001 2.888220e-05 0.0 2.888225e-05 0.001 2.888230e-05 0.0 2.888235e-05 0.001 2.888240e-05 0.0 2.888245e-05 0.001 2.888250e-05 0.0 2.888255e-05 0.001 2.888260e-05 0.0 2.888265e-05 0.001 2.888270e-05 0.0 2.888275e-05 0.001 2.888280e-05 0.0 2.888285e-05 0.001 2.888290e-05 0.0 2.888295e-05 0.001 2.888300e-05 0.0 2.888305e-05 0.001 2.888310e-05 0.0 2.888315e-05 0.001 2.888320e-05 0.0 2.888325e-05 0.001 2.888330e-05 0.0 2.888335e-05 0.001 2.888340e-05 0.0 2.888345e-05 0.001 2.888350e-05 0.0 2.888355e-05 0.001 2.888360e-05 0.0 2.888365e-05 0.001 2.888370e-05 0.0 2.888375e-05 0.001 2.888380e-05 0.0 2.888385e-05 0.001 2.888390e-05 0.0 2.888395e-05 0.001 2.888400e-05 0.0 2.888405e-05 0.001 2.888410e-05 0.0 2.888415e-05 0.001 2.888420e-05 0.0 2.888425e-05 0.001 2.888430e-05 0.0 2.888435e-05 0.001 2.888440e-05 0.0 2.888445e-05 0.001 2.888450e-05 0.0 2.888455e-05 0.001 2.888460e-05 0.0 2.888465e-05 0.001 2.888470e-05 0.0 2.888475e-05 0.001 2.888480e-05 0.0 2.888485e-05 0.001 2.888490e-05 0.0 2.888495e-05 0.001 2.888500e-05 0.0 2.888505e-05 0.001 2.888510e-05 0.0 2.888515e-05 0.001 2.888520e-05 0.0 2.888525e-05 0.001 2.888530e-05 0.0 2.888535e-05 0.001 2.888540e-05 0.0 2.888545e-05 0.001 2.888550e-05 0.0 2.888555e-05 0.001 2.888560e-05 0.0 2.888565e-05 0.001 2.888570e-05 0.0 2.888575e-05 0.001 2.888580e-05 0.0 2.888585e-05 0.001 2.888590e-05 0.0 2.888595e-05 0.001 2.888600e-05 0.0 2.888605e-05 0.001 2.888610e-05 0.0 2.888615e-05 0.001 2.888620e-05 0.0 2.888625e-05 0.001 2.888630e-05 0.0 2.888635e-05 0.001 2.888640e-05 0.0 2.888645e-05 0.001 2.888650e-05 0.0 2.888655e-05 0.001 2.888660e-05 0.0 2.888665e-05 0.001 2.888670e-05 0.0 2.888675e-05 0.001 2.888680e-05 0.0 2.888685e-05 0.001 2.888690e-05 0.0 2.888695e-05 0.001 2.888700e-05 0.0 2.888705e-05 0.001 2.888710e-05 0.0 2.888715e-05 0.001 2.888720e-05 0.0 2.888725e-05 0.001 2.888730e-05 0.0 2.888735e-05 0.001 2.888740e-05 0.0 2.888745e-05 0.001 2.888750e-05 0.0 2.888755e-05 0.001 2.888760e-05 0.0 2.888765e-05 0.001 2.888770e-05 0.0 2.888775e-05 0.001 2.888780e-05 0.0 2.888785e-05 0.001 2.888790e-05 0.0 2.888795e-05 0.001 2.888800e-05 0.0 2.888805e-05 0.001 2.888810e-05 0.0 2.888815e-05 0.001 2.888820e-05 0.0 2.888825e-05 0.001 2.888830e-05 0.0 2.888835e-05 0.001 2.888840e-05 0.0 2.888845e-05 0.001 2.888850e-05 0.0 2.888855e-05 0.001 2.888860e-05 0.0 2.888865e-05 0.001 2.888870e-05 0.0 2.888875e-05 0.001 2.888880e-05 0.0 2.888885e-05 0.001 2.888890e-05 0.0 2.888895e-05 0.001 2.888900e-05 0.0 2.888905e-05 0.001 2.888910e-05 0.0 2.888915e-05 0.001 2.888920e-05 0.0 2.888925e-05 0.001 2.888930e-05 0.0 2.888935e-05 0.001 2.888940e-05 0.0 2.888945e-05 0.001 2.888950e-05 0.0 2.888955e-05 0.001 2.888960e-05 0.0 2.888965e-05 0.001 2.888970e-05 0.0 2.888975e-05 0.001 2.888980e-05 0.0 2.888985e-05 0.001 2.888990e-05 0.0 2.888995e-05 0.001 2.889000e-05 0.0 2.889005e-05 0.001 2.889010e-05 0.0 2.889015e-05 0.001 2.889020e-05 0.0 2.889025e-05 0.001 2.889030e-05 0.0 2.889035e-05 0.001 2.889040e-05 0.0 2.889045e-05 0.001 2.889050e-05 0.0 2.889055e-05 0.001 2.889060e-05 0.0 2.889065e-05 0.001 2.889070e-05 0.0 2.889075e-05 0.001 2.889080e-05 0.0 2.889085e-05 0.001 2.889090e-05 0.0 2.889095e-05 0.001 2.889100e-05 0.0 2.889105e-05 0.001 2.889110e-05 0.0 2.889115e-05 0.001 2.889120e-05 0.0 2.889125e-05 0.001 2.889130e-05 0.0 2.889135e-05 0.001 2.889140e-05 0.0 2.889145e-05 0.001 2.889150e-05 0.0 2.889155e-05 0.001 2.889160e-05 0.0 2.889165e-05 0.001 2.889170e-05 0.0 2.889175e-05 0.001 2.889180e-05 0.0 2.889185e-05 0.001 2.889190e-05 0.0 2.889195e-05 0.001 2.889200e-05 0.0 2.889205e-05 0.001 2.889210e-05 0.0 2.889215e-05 0.001 2.889220e-05 0.0 2.889225e-05 0.001 2.889230e-05 0.0 2.889235e-05 0.001 2.889240e-05 0.0 2.889245e-05 0.001 2.889250e-05 0.0 2.889255e-05 0.001 2.889260e-05 0.0 2.889265e-05 0.001 2.889270e-05 0.0 2.889275e-05 0.001 2.889280e-05 0.0 2.889285e-05 0.001 2.889290e-05 0.0 2.889295e-05 0.001 2.889300e-05 0.0 2.889305e-05 0.001 2.889310e-05 0.0 2.889315e-05 0.001 2.889320e-05 0.0 2.889325e-05 0.001 2.889330e-05 0.0 2.889335e-05 0.001 2.889340e-05 0.0 2.889345e-05 0.001 2.889350e-05 0.0 2.889355e-05 0.001 2.889360e-05 0.0 2.889365e-05 0.001 2.889370e-05 0.0 2.889375e-05 0.001 2.889380e-05 0.0 2.889385e-05 0.001 2.889390e-05 0.0 2.889395e-05 0.001 2.889400e-05 0.0 2.889405e-05 0.001 2.889410e-05 0.0 2.889415e-05 0.001 2.889420e-05 0.0 2.889425e-05 0.001 2.889430e-05 0.0 2.889435e-05 0.001 2.889440e-05 0.0 2.889445e-05 0.001 2.889450e-05 0.0 2.889455e-05 0.001 2.889460e-05 0.0 2.889465e-05 0.001 2.889470e-05 0.0 2.889475e-05 0.001 2.889480e-05 0.0 2.889485e-05 0.001 2.889490e-05 0.0 2.889495e-05 0.001 2.889500e-05 0.0 2.889505e-05 0.001 2.889510e-05 0.0 2.889515e-05 0.001 2.889520e-05 0.0 2.889525e-05 0.001 2.889530e-05 0.0 2.889535e-05 0.001 2.889540e-05 0.0 2.889545e-05 0.001 2.889550e-05 0.0 2.889555e-05 0.001 2.889560e-05 0.0 2.889565e-05 0.001 2.889570e-05 0.0 2.889575e-05 0.001 2.889580e-05 0.0 2.889585e-05 0.001 2.889590e-05 0.0 2.889595e-05 0.001 2.889600e-05 0.0 2.889605e-05 0.001 2.889610e-05 0.0 2.889615e-05 0.001 2.889620e-05 0.0 2.889625e-05 0.001 2.889630e-05 0.0 2.889635e-05 0.001 2.889640e-05 0.0 2.889645e-05 0.001 2.889650e-05 0.0 2.889655e-05 0.001 2.889660e-05 0.0 2.889665e-05 0.001 2.889670e-05 0.0 2.889675e-05 0.001 2.889680e-05 0.0 2.889685e-05 0.001 2.889690e-05 0.0 2.889695e-05 0.001 2.889700e-05 0.0 2.889705e-05 0.001 2.889710e-05 0.0 2.889715e-05 0.001 2.889720e-05 0.0 2.889725e-05 0.001 2.889730e-05 0.0 2.889735e-05 0.001 2.889740e-05 0.0 2.889745e-05 0.001 2.889750e-05 0.0 2.889755e-05 0.001 2.889760e-05 0.0 2.889765e-05 0.001 2.889770e-05 0.0 2.889775e-05 0.001 2.889780e-05 0.0 2.889785e-05 0.001 2.889790e-05 0.0 2.889795e-05 0.001 2.889800e-05 0.0 2.889805e-05 0.001 2.889810e-05 0.0 2.889815e-05 0.001 2.889820e-05 0.0 2.889825e-05 0.001 2.889830e-05 0.0 2.889835e-05 0.001 2.889840e-05 0.0 2.889845e-05 0.001 2.889850e-05 0.0 2.889855e-05 0.001 2.889860e-05 0.0 2.889865e-05 0.001 2.889870e-05 0.0 2.889875e-05 0.001 2.889880e-05 0.0 2.889885e-05 0.001 2.889890e-05 0.0 2.889895e-05 0.001 2.889900e-05 0.0 2.889905e-05 0.001 2.889910e-05 0.0 2.889915e-05 0.001 2.889920e-05 0.0 2.889925e-05 0.001 2.889930e-05 0.0 2.889935e-05 0.001 2.889940e-05 0.0 2.889945e-05 0.001 2.889950e-05 0.0 2.889955e-05 0.001 2.889960e-05 0.0 2.889965e-05 0.001 2.889970e-05 0.0 2.889975e-05 0.001 2.889980e-05 0.0 2.889985e-05 0.001 2.889990e-05 0.0 2.889995e-05 0.001 2.890000e-05 0.0 2.890005e-05 0.001 2.890010e-05 0.0 2.890015e-05 0.001 2.890020e-05 0.0 2.890025e-05 0.001 2.890030e-05 0.0 2.890035e-05 0.001 2.890040e-05 0.0 2.890045e-05 0.001 2.890050e-05 0.0 2.890055e-05 0.001 2.890060e-05 0.0 2.890065e-05 0.001 2.890070e-05 0.0 2.890075e-05 0.001 2.890080e-05 0.0 2.890085e-05 0.001 2.890090e-05 0.0 2.890095e-05 0.001 2.890100e-05 0.0 2.890105e-05 0.001 2.890110e-05 0.0 2.890115e-05 0.001 2.890120e-05 0.0 2.890125e-05 0.001 2.890130e-05 0.0 2.890135e-05 0.001 2.890140e-05 0.0 2.890145e-05 0.001 2.890150e-05 0.0 2.890155e-05 0.001 2.890160e-05 0.0 2.890165e-05 0.001 2.890170e-05 0.0 2.890175e-05 0.001 2.890180e-05 0.0 2.890185e-05 0.001 2.890190e-05 0.0 2.890195e-05 0.001 2.890200e-05 0.0 2.890205e-05 0.001 2.890210e-05 0.0 2.890215e-05 0.001 2.890220e-05 0.0 2.890225e-05 0.001 2.890230e-05 0.0 2.890235e-05 0.001 2.890240e-05 0.0 2.890245e-05 0.001 2.890250e-05 0.0 2.890255e-05 0.001 2.890260e-05 0.0 2.890265e-05 0.001 2.890270e-05 0.0 2.890275e-05 0.001 2.890280e-05 0.0 2.890285e-05 0.001 2.890290e-05 0.0 2.890295e-05 0.001 2.890300e-05 0.0 2.890305e-05 0.001 2.890310e-05 0.0 2.890315e-05 0.001 2.890320e-05 0.0 2.890325e-05 0.001 2.890330e-05 0.0 2.890335e-05 0.001 2.890340e-05 0.0 2.890345e-05 0.001 2.890350e-05 0.0 2.890355e-05 0.001 2.890360e-05 0.0 2.890365e-05 0.001 2.890370e-05 0.0 2.890375e-05 0.001 2.890380e-05 0.0 2.890385e-05 0.001 2.890390e-05 0.0 2.890395e-05 0.001 2.890400e-05 0.0 2.890405e-05 0.001 2.890410e-05 0.0 2.890415e-05 0.001 2.890420e-05 0.0 2.890425e-05 0.001 2.890430e-05 0.0 2.890435e-05 0.001 2.890440e-05 0.0 2.890445e-05 0.001 2.890450e-05 0.0 2.890455e-05 0.001 2.890460e-05 0.0 2.890465e-05 0.001 2.890470e-05 0.0 2.890475e-05 0.001 2.890480e-05 0.0 2.890485e-05 0.001 2.890490e-05 0.0 2.890495e-05 0.001 2.890500e-05 0.0 2.890505e-05 0.001 2.890510e-05 0.0 2.890515e-05 0.001 2.890520e-05 0.0 2.890525e-05 0.001 2.890530e-05 0.0 2.890535e-05 0.001 2.890540e-05 0.0 2.890545e-05 0.001 2.890550e-05 0.0 2.890555e-05 0.001 2.890560e-05 0.0 2.890565e-05 0.001 2.890570e-05 0.0 2.890575e-05 0.001 2.890580e-05 0.0 2.890585e-05 0.001 2.890590e-05 0.0 2.890595e-05 0.001 2.890600e-05 0.0 2.890605e-05 0.001 2.890610e-05 0.0 2.890615e-05 0.001 2.890620e-05 0.0 2.890625e-05 0.001 2.890630e-05 0.0 2.890635e-05 0.001 2.890640e-05 0.0 2.890645e-05 0.001 2.890650e-05 0.0 2.890655e-05 0.001 2.890660e-05 0.0 2.890665e-05 0.001 2.890670e-05 0.0 2.890675e-05 0.001 2.890680e-05 0.0 2.890685e-05 0.001 2.890690e-05 0.0 2.890695e-05 0.001 2.890700e-05 0.0 2.890705e-05 0.001 2.890710e-05 0.0 2.890715e-05 0.001 2.890720e-05 0.0 2.890725e-05 0.001 2.890730e-05 0.0 2.890735e-05 0.001 2.890740e-05 0.0 2.890745e-05 0.001 2.890750e-05 0.0 2.890755e-05 0.001 2.890760e-05 0.0 2.890765e-05 0.001 2.890770e-05 0.0 2.890775e-05 0.001 2.890780e-05 0.0 2.890785e-05 0.001 2.890790e-05 0.0 2.890795e-05 0.001 2.890800e-05 0.0 2.890805e-05 0.001 2.890810e-05 0.0 2.890815e-05 0.001 2.890820e-05 0.0 2.890825e-05 0.001 2.890830e-05 0.0 2.890835e-05 0.001 2.890840e-05 0.0 2.890845e-05 0.001 2.890850e-05 0.0 2.890855e-05 0.001 2.890860e-05 0.0 2.890865e-05 0.001 2.890870e-05 0.0 2.890875e-05 0.001 2.890880e-05 0.0 2.890885e-05 0.001 2.890890e-05 0.0 2.890895e-05 0.001 2.890900e-05 0.0 2.890905e-05 0.001 2.890910e-05 0.0 2.890915e-05 0.001 2.890920e-05 0.0 2.890925e-05 0.001 2.890930e-05 0.0 2.890935e-05 0.001 2.890940e-05 0.0 2.890945e-05 0.001 2.890950e-05 0.0 2.890955e-05 0.001 2.890960e-05 0.0 2.890965e-05 0.001 2.890970e-05 0.0 2.890975e-05 0.001 2.890980e-05 0.0 2.890985e-05 0.001 2.890990e-05 0.0 2.890995e-05 0.001 2.891000e-05 0.0 2.891005e-05 0.001 2.891010e-05 0.0 2.891015e-05 0.001 2.891020e-05 0.0 2.891025e-05 0.001 2.891030e-05 0.0 2.891035e-05 0.001 2.891040e-05 0.0 2.891045e-05 0.001 2.891050e-05 0.0 2.891055e-05 0.001 2.891060e-05 0.0 2.891065e-05 0.001 2.891070e-05 0.0 2.891075e-05 0.001 2.891080e-05 0.0 2.891085e-05 0.001 2.891090e-05 0.0 2.891095e-05 0.001 2.891100e-05 0.0 2.891105e-05 0.001 2.891110e-05 0.0 2.891115e-05 0.001 2.891120e-05 0.0 2.891125e-05 0.001 2.891130e-05 0.0 2.891135e-05 0.001 2.891140e-05 0.0 2.891145e-05 0.001 2.891150e-05 0.0 2.891155e-05 0.001 2.891160e-05 0.0 2.891165e-05 0.001 2.891170e-05 0.0 2.891175e-05 0.001 2.891180e-05 0.0 2.891185e-05 0.001 2.891190e-05 0.0 2.891195e-05 0.001 2.891200e-05 0.0 2.891205e-05 0.001 2.891210e-05 0.0 2.891215e-05 0.001 2.891220e-05 0.0 2.891225e-05 0.001 2.891230e-05 0.0 2.891235e-05 0.001 2.891240e-05 0.0 2.891245e-05 0.001 2.891250e-05 0.0 2.891255e-05 0.001 2.891260e-05 0.0 2.891265e-05 0.001 2.891270e-05 0.0 2.891275e-05 0.001 2.891280e-05 0.0 2.891285e-05 0.001 2.891290e-05 0.0 2.891295e-05 0.001 2.891300e-05 0.0 2.891305e-05 0.001 2.891310e-05 0.0 2.891315e-05 0.001 2.891320e-05 0.0 2.891325e-05 0.001 2.891330e-05 0.0 2.891335e-05 0.001 2.891340e-05 0.0 2.891345e-05 0.001 2.891350e-05 0.0 2.891355e-05 0.001 2.891360e-05 0.0 2.891365e-05 0.001 2.891370e-05 0.0 2.891375e-05 0.001 2.891380e-05 0.0 2.891385e-05 0.001 2.891390e-05 0.0 2.891395e-05 0.001 2.891400e-05 0.0 2.891405e-05 0.001 2.891410e-05 0.0 2.891415e-05 0.001 2.891420e-05 0.0 2.891425e-05 0.001 2.891430e-05 0.0 2.891435e-05 0.001 2.891440e-05 0.0 2.891445e-05 0.001 2.891450e-05 0.0 2.891455e-05 0.001 2.891460e-05 0.0 2.891465e-05 0.001 2.891470e-05 0.0 2.891475e-05 0.001 2.891480e-05 0.0 2.891485e-05 0.001 2.891490e-05 0.0 2.891495e-05 0.001 2.891500e-05 0.0 2.891505e-05 0.001 2.891510e-05 0.0 2.891515e-05 0.001 2.891520e-05 0.0 2.891525e-05 0.001 2.891530e-05 0.0 2.891535e-05 0.001 2.891540e-05 0.0 2.891545e-05 0.001 2.891550e-05 0.0 2.891555e-05 0.001 2.891560e-05 0.0 2.891565e-05 0.001 2.891570e-05 0.0 2.891575e-05 0.001 2.891580e-05 0.0 2.891585e-05 0.001 2.891590e-05 0.0 2.891595e-05 0.001 2.891600e-05 0.0 2.891605e-05 0.001 2.891610e-05 0.0 2.891615e-05 0.001 2.891620e-05 0.0 2.891625e-05 0.001 2.891630e-05 0.0 2.891635e-05 0.001 2.891640e-05 0.0 2.891645e-05 0.001 2.891650e-05 0.0 2.891655e-05 0.001 2.891660e-05 0.0 2.891665e-05 0.001 2.891670e-05 0.0 2.891675e-05 0.001 2.891680e-05 0.0 2.891685e-05 0.001 2.891690e-05 0.0 2.891695e-05 0.001 2.891700e-05 0.0 2.891705e-05 0.001 2.891710e-05 0.0 2.891715e-05 0.001 2.891720e-05 0.0 2.891725e-05 0.001 2.891730e-05 0.0 2.891735e-05 0.001 2.891740e-05 0.0 2.891745e-05 0.001 2.891750e-05 0.0 2.891755e-05 0.001 2.891760e-05 0.0 2.891765e-05 0.001 2.891770e-05 0.0 2.891775e-05 0.001 2.891780e-05 0.0 2.891785e-05 0.001 2.891790e-05 0.0 2.891795e-05 0.001 2.891800e-05 0.0 2.891805e-05 0.001 2.891810e-05 0.0 2.891815e-05 0.001 2.891820e-05 0.0 2.891825e-05 0.001 2.891830e-05 0.0 2.891835e-05 0.001 2.891840e-05 0.0 2.891845e-05 0.001 2.891850e-05 0.0 2.891855e-05 0.001 2.891860e-05 0.0 2.891865e-05 0.001 2.891870e-05 0.0 2.891875e-05 0.001 2.891880e-05 0.0 2.891885e-05 0.001 2.891890e-05 0.0 2.891895e-05 0.001 2.891900e-05 0.0 2.891905e-05 0.001 2.891910e-05 0.0 2.891915e-05 0.001 2.891920e-05 0.0 2.891925e-05 0.001 2.891930e-05 0.0 2.891935e-05 0.001 2.891940e-05 0.0 2.891945e-05 0.001 2.891950e-05 0.0 2.891955e-05 0.001 2.891960e-05 0.0 2.891965e-05 0.001 2.891970e-05 0.0 2.891975e-05 0.001 2.891980e-05 0.0 2.891985e-05 0.001 2.891990e-05 0.0 2.891995e-05 0.001 2.892000e-05 0.0 2.892005e-05 0.001 2.892010e-05 0.0 2.892015e-05 0.001 2.892020e-05 0.0 2.892025e-05 0.001 2.892030e-05 0.0 2.892035e-05 0.001 2.892040e-05 0.0 2.892045e-05 0.001 2.892050e-05 0.0 2.892055e-05 0.001 2.892060e-05 0.0 2.892065e-05 0.001 2.892070e-05 0.0 2.892075e-05 0.001 2.892080e-05 0.0 2.892085e-05 0.001 2.892090e-05 0.0 2.892095e-05 0.001 2.892100e-05 0.0 2.892105e-05 0.001 2.892110e-05 0.0 2.892115e-05 0.001 2.892120e-05 0.0 2.892125e-05 0.001 2.892130e-05 0.0 2.892135e-05 0.001 2.892140e-05 0.0 2.892145e-05 0.001 2.892150e-05 0.0 2.892155e-05 0.001 2.892160e-05 0.0 2.892165e-05 0.001 2.892170e-05 0.0 2.892175e-05 0.001 2.892180e-05 0.0 2.892185e-05 0.001 2.892190e-05 0.0 2.892195e-05 0.001 2.892200e-05 0.0 2.892205e-05 0.001 2.892210e-05 0.0 2.892215e-05 0.001 2.892220e-05 0.0 2.892225e-05 0.001 2.892230e-05 0.0 2.892235e-05 0.001 2.892240e-05 0.0 2.892245e-05 0.001 2.892250e-05 0.0 2.892255e-05 0.001 2.892260e-05 0.0 2.892265e-05 0.001 2.892270e-05 0.0 2.892275e-05 0.001 2.892280e-05 0.0 2.892285e-05 0.001 2.892290e-05 0.0 2.892295e-05 0.001 2.892300e-05 0.0 2.892305e-05 0.001 2.892310e-05 0.0 2.892315e-05 0.001 2.892320e-05 0.0 2.892325e-05 0.001 2.892330e-05 0.0 2.892335e-05 0.001 2.892340e-05 0.0 2.892345e-05 0.001 2.892350e-05 0.0 2.892355e-05 0.001 2.892360e-05 0.0 2.892365e-05 0.001 2.892370e-05 0.0 2.892375e-05 0.001 2.892380e-05 0.0 2.892385e-05 0.001 2.892390e-05 0.0 2.892395e-05 0.001 2.892400e-05 0.0 2.892405e-05 0.001 2.892410e-05 0.0 2.892415e-05 0.001 2.892420e-05 0.0 2.892425e-05 0.001 2.892430e-05 0.0 2.892435e-05 0.001 2.892440e-05 0.0 2.892445e-05 0.001 2.892450e-05 0.0 2.892455e-05 0.001 2.892460e-05 0.0 2.892465e-05 0.001 2.892470e-05 0.0 2.892475e-05 0.001 2.892480e-05 0.0 2.892485e-05 0.001 2.892490e-05 0.0 2.892495e-05 0.001 2.892500e-05 0.0 2.892505e-05 0.001 2.892510e-05 0.0 2.892515e-05 0.001 2.892520e-05 0.0 2.892525e-05 0.001 2.892530e-05 0.0 2.892535e-05 0.001 2.892540e-05 0.0 2.892545e-05 0.001 2.892550e-05 0.0 2.892555e-05 0.001 2.892560e-05 0.0 2.892565e-05 0.001 2.892570e-05 0.0 2.892575e-05 0.001 2.892580e-05 0.0 2.892585e-05 0.001 2.892590e-05 0.0 2.892595e-05 0.001 2.892600e-05 0.0 2.892605e-05 0.001 2.892610e-05 0.0 2.892615e-05 0.001 2.892620e-05 0.0 2.892625e-05 0.001 2.892630e-05 0.0 2.892635e-05 0.001 2.892640e-05 0.0 2.892645e-05 0.001 2.892650e-05 0.0 2.892655e-05 0.001 2.892660e-05 0.0 2.892665e-05 0.001 2.892670e-05 0.0 2.892675e-05 0.001 2.892680e-05 0.0 2.892685e-05 0.001 2.892690e-05 0.0 2.892695e-05 0.001 2.892700e-05 0.0 2.892705e-05 0.001 2.892710e-05 0.0 2.892715e-05 0.001 2.892720e-05 0.0 2.892725e-05 0.001 2.892730e-05 0.0 2.892735e-05 0.001 2.892740e-05 0.0 2.892745e-05 0.001 2.892750e-05 0.0 2.892755e-05 0.001 2.892760e-05 0.0 2.892765e-05 0.001 2.892770e-05 0.0 2.892775e-05 0.001 2.892780e-05 0.0 2.892785e-05 0.001 2.892790e-05 0.0 2.892795e-05 0.001 2.892800e-05 0.0 2.892805e-05 0.001 2.892810e-05 0.0 2.892815e-05 0.001 2.892820e-05 0.0 2.892825e-05 0.001 2.892830e-05 0.0 2.892835e-05 0.001 2.892840e-05 0.0 2.892845e-05 0.001 2.892850e-05 0.0 2.892855e-05 0.001 2.892860e-05 0.0 2.892865e-05 0.001 2.892870e-05 0.0 2.892875e-05 0.001 2.892880e-05 0.0 2.892885e-05 0.001 2.892890e-05 0.0 2.892895e-05 0.001 2.892900e-05 0.0 2.892905e-05 0.001 2.892910e-05 0.0 2.892915e-05 0.001 2.892920e-05 0.0 2.892925e-05 0.001 2.892930e-05 0.0 2.892935e-05 0.001 2.892940e-05 0.0 2.892945e-05 0.001 2.892950e-05 0.0 2.892955e-05 0.001 2.892960e-05 0.0 2.892965e-05 0.001 2.892970e-05 0.0 2.892975e-05 0.001 2.892980e-05 0.0 2.892985e-05 0.001 2.892990e-05 0.0 2.892995e-05 0.001 2.893000e-05 0.0 2.893005e-05 0.001 2.893010e-05 0.0 2.893015e-05 0.001 2.893020e-05 0.0 2.893025e-05 0.001 2.893030e-05 0.0 2.893035e-05 0.001 2.893040e-05 0.0 2.893045e-05 0.001 2.893050e-05 0.0 2.893055e-05 0.001 2.893060e-05 0.0 2.893065e-05 0.001 2.893070e-05 0.0 2.893075e-05 0.001 2.893080e-05 0.0 2.893085e-05 0.001 2.893090e-05 0.0 2.893095e-05 0.001 2.893100e-05 0.0 2.893105e-05 0.001 2.893110e-05 0.0 2.893115e-05 0.001 2.893120e-05 0.0 2.893125e-05 0.001 2.893130e-05 0.0 2.893135e-05 0.001 2.893140e-05 0.0 2.893145e-05 0.001 2.893150e-05 0.0 2.893155e-05 0.001 2.893160e-05 0.0 2.893165e-05 0.001 2.893170e-05 0.0 2.893175e-05 0.001 2.893180e-05 0.0 2.893185e-05 0.001 2.893190e-05 0.0 2.893195e-05 0.001 2.893200e-05 0.0 2.893205e-05 0.001 2.893210e-05 0.0 2.893215e-05 0.001 2.893220e-05 0.0 2.893225e-05 0.001 2.893230e-05 0.0 2.893235e-05 0.001 2.893240e-05 0.0 2.893245e-05 0.001 2.893250e-05 0.0 2.893255e-05 0.001 2.893260e-05 0.0 2.893265e-05 0.001 2.893270e-05 0.0 2.893275e-05 0.001 2.893280e-05 0.0 2.893285e-05 0.001 2.893290e-05 0.0 2.893295e-05 0.001 2.893300e-05 0.0 2.893305e-05 0.001 2.893310e-05 0.0 2.893315e-05 0.001 2.893320e-05 0.0 2.893325e-05 0.001 2.893330e-05 0.0 2.893335e-05 0.001 2.893340e-05 0.0 2.893345e-05 0.001 2.893350e-05 0.0 2.893355e-05 0.001 2.893360e-05 0.0 2.893365e-05 0.001 2.893370e-05 0.0 2.893375e-05 0.001 2.893380e-05 0.0 2.893385e-05 0.001 2.893390e-05 0.0 2.893395e-05 0.001 2.893400e-05 0.0 2.893405e-05 0.001 2.893410e-05 0.0 2.893415e-05 0.001 2.893420e-05 0.0 2.893425e-05 0.001 2.893430e-05 0.0 2.893435e-05 0.001 2.893440e-05 0.0 2.893445e-05 0.001 2.893450e-05 0.0 2.893455e-05 0.001 2.893460e-05 0.0 2.893465e-05 0.001 2.893470e-05 0.0 2.893475e-05 0.001 2.893480e-05 0.0 2.893485e-05 0.001 2.893490e-05 0.0 2.893495e-05 0.001 2.893500e-05 0.0 2.893505e-05 0.001 2.893510e-05 0.0 2.893515e-05 0.001 2.893520e-05 0.0 2.893525e-05 0.001 2.893530e-05 0.0 2.893535e-05 0.001 2.893540e-05 0.0 2.893545e-05 0.001 2.893550e-05 0.0 2.893555e-05 0.001 2.893560e-05 0.0 2.893565e-05 0.001 2.893570e-05 0.0 2.893575e-05 0.001 2.893580e-05 0.0 2.893585e-05 0.001 2.893590e-05 0.0 2.893595e-05 0.001 2.893600e-05 0.0 2.893605e-05 0.001 2.893610e-05 0.0 2.893615e-05 0.001 2.893620e-05 0.0 2.893625e-05 0.001 2.893630e-05 0.0 2.893635e-05 0.001 2.893640e-05 0.0 2.893645e-05 0.001 2.893650e-05 0.0 2.893655e-05 0.001 2.893660e-05 0.0 2.893665e-05 0.001 2.893670e-05 0.0 2.893675e-05 0.001 2.893680e-05 0.0 2.893685e-05 0.001 2.893690e-05 0.0 2.893695e-05 0.001 2.893700e-05 0.0 2.893705e-05 0.001 2.893710e-05 0.0 2.893715e-05 0.001 2.893720e-05 0.0 2.893725e-05 0.001 2.893730e-05 0.0 2.893735e-05 0.001 2.893740e-05 0.0 2.893745e-05 0.001 2.893750e-05 0.0 2.893755e-05 0.001 2.893760e-05 0.0 2.893765e-05 0.001 2.893770e-05 0.0 2.893775e-05 0.001 2.893780e-05 0.0 2.893785e-05 0.001 2.893790e-05 0.0 2.893795e-05 0.001 2.893800e-05 0.0 2.893805e-05 0.001 2.893810e-05 0.0 2.893815e-05 0.001 2.893820e-05 0.0 2.893825e-05 0.001 2.893830e-05 0.0 2.893835e-05 0.001 2.893840e-05 0.0 2.893845e-05 0.001 2.893850e-05 0.0 2.893855e-05 0.001 2.893860e-05 0.0 2.893865e-05 0.001 2.893870e-05 0.0 2.893875e-05 0.001 2.893880e-05 0.0 2.893885e-05 0.001 2.893890e-05 0.0 2.893895e-05 0.001 2.893900e-05 0.0 2.893905e-05 0.001 2.893910e-05 0.0 2.893915e-05 0.001 2.893920e-05 0.0 2.893925e-05 0.001 2.893930e-05 0.0 2.893935e-05 0.001 2.893940e-05 0.0 2.893945e-05 0.001 2.893950e-05 0.0 2.893955e-05 0.001 2.893960e-05 0.0 2.893965e-05 0.001 2.893970e-05 0.0 2.893975e-05 0.001 2.893980e-05 0.0 2.893985e-05 0.001 2.893990e-05 0.0 2.893995e-05 0.001 2.894000e-05 0.0 2.894005e-05 0.001 2.894010e-05 0.0 2.894015e-05 0.001 2.894020e-05 0.0 2.894025e-05 0.001 2.894030e-05 0.0 2.894035e-05 0.001 2.894040e-05 0.0 2.894045e-05 0.001 2.894050e-05 0.0 2.894055e-05 0.001 2.894060e-05 0.0 2.894065e-05 0.001 2.894070e-05 0.0 2.894075e-05 0.001 2.894080e-05 0.0 2.894085e-05 0.001 2.894090e-05 0.0 2.894095e-05 0.001 2.894100e-05 0.0 2.894105e-05 0.001 2.894110e-05 0.0 2.894115e-05 0.001 2.894120e-05 0.0 2.894125e-05 0.001 2.894130e-05 0.0 2.894135e-05 0.001 2.894140e-05 0.0 2.894145e-05 0.001 2.894150e-05 0.0 2.894155e-05 0.001 2.894160e-05 0.0 2.894165e-05 0.001 2.894170e-05 0.0 2.894175e-05 0.001 2.894180e-05 0.0 2.894185e-05 0.001 2.894190e-05 0.0 2.894195e-05 0.001 2.894200e-05 0.0 2.894205e-05 0.001 2.894210e-05 0.0 2.894215e-05 0.001 2.894220e-05 0.0 2.894225e-05 0.001 2.894230e-05 0.0 2.894235e-05 0.001 2.894240e-05 0.0 2.894245e-05 0.001 2.894250e-05 0.0 2.894255e-05 0.001 2.894260e-05 0.0 2.894265e-05 0.001 2.894270e-05 0.0 2.894275e-05 0.001 2.894280e-05 0.0 2.894285e-05 0.001 2.894290e-05 0.0 2.894295e-05 0.001 2.894300e-05 0.0 2.894305e-05 0.001 2.894310e-05 0.0 2.894315e-05 0.001 2.894320e-05 0.0 2.894325e-05 0.001 2.894330e-05 0.0 2.894335e-05 0.001 2.894340e-05 0.0 2.894345e-05 0.001 2.894350e-05 0.0 2.894355e-05 0.001 2.894360e-05 0.0 2.894365e-05 0.001 2.894370e-05 0.0 2.894375e-05 0.001 2.894380e-05 0.0 2.894385e-05 0.001 2.894390e-05 0.0 2.894395e-05 0.001 2.894400e-05 0.0 2.894405e-05 0.001 2.894410e-05 0.0 2.894415e-05 0.001 2.894420e-05 0.0 2.894425e-05 0.001 2.894430e-05 0.0 2.894435e-05 0.001 2.894440e-05 0.0 2.894445e-05 0.001 2.894450e-05 0.0 2.894455e-05 0.001 2.894460e-05 0.0 2.894465e-05 0.001 2.894470e-05 0.0 2.894475e-05 0.001 2.894480e-05 0.0 2.894485e-05 0.001 2.894490e-05 0.0 2.894495e-05 0.001 2.894500e-05 0.0 2.894505e-05 0.001 2.894510e-05 0.0 2.894515e-05 0.001 2.894520e-05 0.0 2.894525e-05 0.001 2.894530e-05 0.0 2.894535e-05 0.001 2.894540e-05 0.0 2.894545e-05 0.001 2.894550e-05 0.0 2.894555e-05 0.001 2.894560e-05 0.0 2.894565e-05 0.001 2.894570e-05 0.0 2.894575e-05 0.001 2.894580e-05 0.0 2.894585e-05 0.001 2.894590e-05 0.0 2.894595e-05 0.001 2.894600e-05 0.0 2.894605e-05 0.001 2.894610e-05 0.0 2.894615e-05 0.001 2.894620e-05 0.0 2.894625e-05 0.001 2.894630e-05 0.0 2.894635e-05 0.001 2.894640e-05 0.0 2.894645e-05 0.001 2.894650e-05 0.0 2.894655e-05 0.001 2.894660e-05 0.0 2.894665e-05 0.001 2.894670e-05 0.0 2.894675e-05 0.001 2.894680e-05 0.0 2.894685e-05 0.001 2.894690e-05 0.0 2.894695e-05 0.001 2.894700e-05 0.0 2.894705e-05 0.001 2.894710e-05 0.0 2.894715e-05 0.001 2.894720e-05 0.0 2.894725e-05 0.001 2.894730e-05 0.0 2.894735e-05 0.001 2.894740e-05 0.0 2.894745e-05 0.001 2.894750e-05 0.0 2.894755e-05 0.001 2.894760e-05 0.0 2.894765e-05 0.001 2.894770e-05 0.0 2.894775e-05 0.001 2.894780e-05 0.0 2.894785e-05 0.001 2.894790e-05 0.0 2.894795e-05 0.001 2.894800e-05 0.0 2.894805e-05 0.001 2.894810e-05 0.0 2.894815e-05 0.001 2.894820e-05 0.0 2.894825e-05 0.001 2.894830e-05 0.0 2.894835e-05 0.001 2.894840e-05 0.0 2.894845e-05 0.001 2.894850e-05 0.0 2.894855e-05 0.001 2.894860e-05 0.0 2.894865e-05 0.001 2.894870e-05 0.0 2.894875e-05 0.001 2.894880e-05 0.0 2.894885e-05 0.001 2.894890e-05 0.0 2.894895e-05 0.001 2.894900e-05 0.0 2.894905e-05 0.001 2.894910e-05 0.0 2.894915e-05 0.001 2.894920e-05 0.0 2.894925e-05 0.001 2.894930e-05 0.0 2.894935e-05 0.001 2.894940e-05 0.0 2.894945e-05 0.001 2.894950e-05 0.0 2.894955e-05 0.001 2.894960e-05 0.0 2.894965e-05 0.001 2.894970e-05 0.0 2.894975e-05 0.001 2.894980e-05 0.0 2.894985e-05 0.001 2.894990e-05 0.0 2.894995e-05 0.001 2.895000e-05 0.0 2.895005e-05 0.001 2.895010e-05 0.0 2.895015e-05 0.001 2.895020e-05 0.0 2.895025e-05 0.001 2.895030e-05 0.0 2.895035e-05 0.001 2.895040e-05 0.0 2.895045e-05 0.001 2.895050e-05 0.0 2.895055e-05 0.001 2.895060e-05 0.0 2.895065e-05 0.001 2.895070e-05 0.0 2.895075e-05 0.001 2.895080e-05 0.0 2.895085e-05 0.001 2.895090e-05 0.0 2.895095e-05 0.001 2.895100e-05 0.0 2.895105e-05 0.001 2.895110e-05 0.0 2.895115e-05 0.001 2.895120e-05 0.0 2.895125e-05 0.001 2.895130e-05 0.0 2.895135e-05 0.001 2.895140e-05 0.0 2.895145e-05 0.001 2.895150e-05 0.0 2.895155e-05 0.001 2.895160e-05 0.0 2.895165e-05 0.001 2.895170e-05 0.0 2.895175e-05 0.001 2.895180e-05 0.0 2.895185e-05 0.001 2.895190e-05 0.0 2.895195e-05 0.001 2.895200e-05 0.0 2.895205e-05 0.001 2.895210e-05 0.0 2.895215e-05 0.001 2.895220e-05 0.0 2.895225e-05 0.001 2.895230e-05 0.0 2.895235e-05 0.001 2.895240e-05 0.0 2.895245e-05 0.001 2.895250e-05 0.0 2.895255e-05 0.001 2.895260e-05 0.0 2.895265e-05 0.001 2.895270e-05 0.0 2.895275e-05 0.001 2.895280e-05 0.0 2.895285e-05 0.001 2.895290e-05 0.0 2.895295e-05 0.001 2.895300e-05 0.0 2.895305e-05 0.001 2.895310e-05 0.0 2.895315e-05 0.001 2.895320e-05 0.0 2.895325e-05 0.001 2.895330e-05 0.0 2.895335e-05 0.001 2.895340e-05 0.0 2.895345e-05 0.001 2.895350e-05 0.0 2.895355e-05 0.001 2.895360e-05 0.0 2.895365e-05 0.001 2.895370e-05 0.0 2.895375e-05 0.001 2.895380e-05 0.0 2.895385e-05 0.001 2.895390e-05 0.0 2.895395e-05 0.001 2.895400e-05 0.0 2.895405e-05 0.001 2.895410e-05 0.0 2.895415e-05 0.001 2.895420e-05 0.0 2.895425e-05 0.001 2.895430e-05 0.0 2.895435e-05 0.001 2.895440e-05 0.0 2.895445e-05 0.001 2.895450e-05 0.0 2.895455e-05 0.001 2.895460e-05 0.0 2.895465e-05 0.001 2.895470e-05 0.0 2.895475e-05 0.001 2.895480e-05 0.0 2.895485e-05 0.001 2.895490e-05 0.0 2.895495e-05 0.001 2.895500e-05 0.0 2.895505e-05 0.001 2.895510e-05 0.0 2.895515e-05 0.001 2.895520e-05 0.0 2.895525e-05 0.001 2.895530e-05 0.0 2.895535e-05 0.001 2.895540e-05 0.0 2.895545e-05 0.001 2.895550e-05 0.0 2.895555e-05 0.001 2.895560e-05 0.0 2.895565e-05 0.001 2.895570e-05 0.0 2.895575e-05 0.001 2.895580e-05 0.0 2.895585e-05 0.001 2.895590e-05 0.0 2.895595e-05 0.001 2.895600e-05 0.0 2.895605e-05 0.001 2.895610e-05 0.0 2.895615e-05 0.001 2.895620e-05 0.0 2.895625e-05 0.001 2.895630e-05 0.0 2.895635e-05 0.001 2.895640e-05 0.0 2.895645e-05 0.001 2.895650e-05 0.0 2.895655e-05 0.001 2.895660e-05 0.0 2.895665e-05 0.001 2.895670e-05 0.0 2.895675e-05 0.001 2.895680e-05 0.0 2.895685e-05 0.001 2.895690e-05 0.0 2.895695e-05 0.001 2.895700e-05 0.0 2.895705e-05 0.001 2.895710e-05 0.0 2.895715e-05 0.001 2.895720e-05 0.0 2.895725e-05 0.001 2.895730e-05 0.0 2.895735e-05 0.001 2.895740e-05 0.0 2.895745e-05 0.001 2.895750e-05 0.0 2.895755e-05 0.001 2.895760e-05 0.0 2.895765e-05 0.001 2.895770e-05 0.0 2.895775e-05 0.001 2.895780e-05 0.0 2.895785e-05 0.001 2.895790e-05 0.0 2.895795e-05 0.001 2.895800e-05 0.0 2.895805e-05 0.001 2.895810e-05 0.0 2.895815e-05 0.001 2.895820e-05 0.0 2.895825e-05 0.001 2.895830e-05 0.0 2.895835e-05 0.001 2.895840e-05 0.0 2.895845e-05 0.001 2.895850e-05 0.0 2.895855e-05 0.001 2.895860e-05 0.0 2.895865e-05 0.001 2.895870e-05 0.0 2.895875e-05 0.001 2.895880e-05 0.0 2.895885e-05 0.001 2.895890e-05 0.0 2.895895e-05 0.001 2.895900e-05 0.0 2.895905e-05 0.001 2.895910e-05 0.0 2.895915e-05 0.001 2.895920e-05 0.0 2.895925e-05 0.001 2.895930e-05 0.0 2.895935e-05 0.001 2.895940e-05 0.0 2.895945e-05 0.001 2.895950e-05 0.0 2.895955e-05 0.001 2.895960e-05 0.0 2.895965e-05 0.001 2.895970e-05 0.0 2.895975e-05 0.001 2.895980e-05 0.0 2.895985e-05 0.001 2.895990e-05 0.0 2.895995e-05 0.001 2.896000e-05 0.0 2.896005e-05 0.001 2.896010e-05 0.0 2.896015e-05 0.001 2.896020e-05 0.0 2.896025e-05 0.001 2.896030e-05 0.0 2.896035e-05 0.001 2.896040e-05 0.0 2.896045e-05 0.001 2.896050e-05 0.0 2.896055e-05 0.001 2.896060e-05 0.0 2.896065e-05 0.001 2.896070e-05 0.0 2.896075e-05 0.001 2.896080e-05 0.0 2.896085e-05 0.001 2.896090e-05 0.0 2.896095e-05 0.001 2.896100e-05 0.0 2.896105e-05 0.001 2.896110e-05 0.0 2.896115e-05 0.001 2.896120e-05 0.0 2.896125e-05 0.001 2.896130e-05 0.0 2.896135e-05 0.001 2.896140e-05 0.0 2.896145e-05 0.001 2.896150e-05 0.0 2.896155e-05 0.001 2.896160e-05 0.0 2.896165e-05 0.001 2.896170e-05 0.0 2.896175e-05 0.001 2.896180e-05 0.0 2.896185e-05 0.001 2.896190e-05 0.0 2.896195e-05 0.001 2.896200e-05 0.0 2.896205e-05 0.001 2.896210e-05 0.0 2.896215e-05 0.001 2.896220e-05 0.0 2.896225e-05 0.001 2.896230e-05 0.0 2.896235e-05 0.001 2.896240e-05 0.0 2.896245e-05 0.001 2.896250e-05 0.0 2.896255e-05 0.001 2.896260e-05 0.0 2.896265e-05 0.001 2.896270e-05 0.0 2.896275e-05 0.001 2.896280e-05 0.0 2.896285e-05 0.001 2.896290e-05 0.0 2.896295e-05 0.001 2.896300e-05 0.0 2.896305e-05 0.001 2.896310e-05 0.0 2.896315e-05 0.001 2.896320e-05 0.0 2.896325e-05 0.001 2.896330e-05 0.0 2.896335e-05 0.001 2.896340e-05 0.0 2.896345e-05 0.001 2.896350e-05 0.0 2.896355e-05 0.001 2.896360e-05 0.0 2.896365e-05 0.001 2.896370e-05 0.0 2.896375e-05 0.001 2.896380e-05 0.0 2.896385e-05 0.001 2.896390e-05 0.0 2.896395e-05 0.001 2.896400e-05 0.0 2.896405e-05 0.001 2.896410e-05 0.0 2.896415e-05 0.001 2.896420e-05 0.0 2.896425e-05 0.001 2.896430e-05 0.0 2.896435e-05 0.001 2.896440e-05 0.0 2.896445e-05 0.001 2.896450e-05 0.0 2.896455e-05 0.001 2.896460e-05 0.0 2.896465e-05 0.001 2.896470e-05 0.0 2.896475e-05 0.001 2.896480e-05 0.0 2.896485e-05 0.001 2.896490e-05 0.0 2.896495e-05 0.001 2.896500e-05 0.0 2.896505e-05 0.001 2.896510e-05 0.0 2.896515e-05 0.001 2.896520e-05 0.0 2.896525e-05 0.001 2.896530e-05 0.0 2.896535e-05 0.001 2.896540e-05 0.0 2.896545e-05 0.001 2.896550e-05 0.0 2.896555e-05 0.001 2.896560e-05 0.0 2.896565e-05 0.001 2.896570e-05 0.0 2.896575e-05 0.001 2.896580e-05 0.0 2.896585e-05 0.001 2.896590e-05 0.0 2.896595e-05 0.001 2.896600e-05 0.0 2.896605e-05 0.001 2.896610e-05 0.0 2.896615e-05 0.001 2.896620e-05 0.0 2.896625e-05 0.001 2.896630e-05 0.0 2.896635e-05 0.001 2.896640e-05 0.0 2.896645e-05 0.001 2.896650e-05 0.0 2.896655e-05 0.001 2.896660e-05 0.0 2.896665e-05 0.001 2.896670e-05 0.0 2.896675e-05 0.001 2.896680e-05 0.0 2.896685e-05 0.001 2.896690e-05 0.0 2.896695e-05 0.001 2.896700e-05 0.0 2.896705e-05 0.001 2.896710e-05 0.0 2.896715e-05 0.001 2.896720e-05 0.0 2.896725e-05 0.001 2.896730e-05 0.0 2.896735e-05 0.001 2.896740e-05 0.0 2.896745e-05 0.001 2.896750e-05 0.0 2.896755e-05 0.001 2.896760e-05 0.0 2.896765e-05 0.001 2.896770e-05 0.0 2.896775e-05 0.001 2.896780e-05 0.0 2.896785e-05 0.001 2.896790e-05 0.0 2.896795e-05 0.001 2.896800e-05 0.0 2.896805e-05 0.001 2.896810e-05 0.0 2.896815e-05 0.001 2.896820e-05 0.0 2.896825e-05 0.001 2.896830e-05 0.0 2.896835e-05 0.001 2.896840e-05 0.0 2.896845e-05 0.001 2.896850e-05 0.0 2.896855e-05 0.001 2.896860e-05 0.0 2.896865e-05 0.001 2.896870e-05 0.0 2.896875e-05 0.001 2.896880e-05 0.0 2.896885e-05 0.001 2.896890e-05 0.0 2.896895e-05 0.001 2.896900e-05 0.0 2.896905e-05 0.001 2.896910e-05 0.0 2.896915e-05 0.001 2.896920e-05 0.0 2.896925e-05 0.001 2.896930e-05 0.0 2.896935e-05 0.001 2.896940e-05 0.0 2.896945e-05 0.001 2.896950e-05 0.0 2.896955e-05 0.001 2.896960e-05 0.0 2.896965e-05 0.001 2.896970e-05 0.0 2.896975e-05 0.001 2.896980e-05 0.0 2.896985e-05 0.001 2.896990e-05 0.0 2.896995e-05 0.001 2.897000e-05 0.0 2.897005e-05 0.001 2.897010e-05 0.0 2.897015e-05 0.001 2.897020e-05 0.0 2.897025e-05 0.001 2.897030e-05 0.0 2.897035e-05 0.001 2.897040e-05 0.0 2.897045e-05 0.001 2.897050e-05 0.0 2.897055e-05 0.001 2.897060e-05 0.0 2.897065e-05 0.001 2.897070e-05 0.0 2.897075e-05 0.001 2.897080e-05 0.0 2.897085e-05 0.001 2.897090e-05 0.0 2.897095e-05 0.001 2.897100e-05 0.0 2.897105e-05 0.001 2.897110e-05 0.0 2.897115e-05 0.001 2.897120e-05 0.0 2.897125e-05 0.001 2.897130e-05 0.0 2.897135e-05 0.001 2.897140e-05 0.0 2.897145e-05 0.001 2.897150e-05 0.0 2.897155e-05 0.001 2.897160e-05 0.0 2.897165e-05 0.001 2.897170e-05 0.0 2.897175e-05 0.001 2.897180e-05 0.0 2.897185e-05 0.001 2.897190e-05 0.0 2.897195e-05 0.001 2.897200e-05 0.0 2.897205e-05 0.001 2.897210e-05 0.0 2.897215e-05 0.001 2.897220e-05 0.0 2.897225e-05 0.001 2.897230e-05 0.0 2.897235e-05 0.001 2.897240e-05 0.0 2.897245e-05 0.001 2.897250e-05 0.0 2.897255e-05 0.001 2.897260e-05 0.0 2.897265e-05 0.001 2.897270e-05 0.0 2.897275e-05 0.001 2.897280e-05 0.0 2.897285e-05 0.001 2.897290e-05 0.0 2.897295e-05 0.001 2.897300e-05 0.0 2.897305e-05 0.001 2.897310e-05 0.0 2.897315e-05 0.001 2.897320e-05 0.0 2.897325e-05 0.001 2.897330e-05 0.0 2.897335e-05 0.001 2.897340e-05 0.0 2.897345e-05 0.001 2.897350e-05 0.0 2.897355e-05 0.001 2.897360e-05 0.0 2.897365e-05 0.001 2.897370e-05 0.0 2.897375e-05 0.001 2.897380e-05 0.0 2.897385e-05 0.001 2.897390e-05 0.0 2.897395e-05 0.001 2.897400e-05 0.0 2.897405e-05 0.001 2.897410e-05 0.0 2.897415e-05 0.001 2.897420e-05 0.0 2.897425e-05 0.001 2.897430e-05 0.0 2.897435e-05 0.001 2.897440e-05 0.0 2.897445e-05 0.001 2.897450e-05 0.0 2.897455e-05 0.001 2.897460e-05 0.0 2.897465e-05 0.001 2.897470e-05 0.0 2.897475e-05 0.001 2.897480e-05 0.0 2.897485e-05 0.001 2.897490e-05 0.0 2.897495e-05 0.001 2.897500e-05 0.0 2.897505e-05 0.001 2.897510e-05 0.0 2.897515e-05 0.001 2.897520e-05 0.0 2.897525e-05 0.001 2.897530e-05 0.0 2.897535e-05 0.001 2.897540e-05 0.0 2.897545e-05 0.001 2.897550e-05 0.0 2.897555e-05 0.001 2.897560e-05 0.0 2.897565e-05 0.001 2.897570e-05 0.0 2.897575e-05 0.001 2.897580e-05 0.0 2.897585e-05 0.001 2.897590e-05 0.0 2.897595e-05 0.001 2.897600e-05 0.0 2.897605e-05 0.001 2.897610e-05 0.0 2.897615e-05 0.001 2.897620e-05 0.0 2.897625e-05 0.001 2.897630e-05 0.0 2.897635e-05 0.001 2.897640e-05 0.0 2.897645e-05 0.001 2.897650e-05 0.0 2.897655e-05 0.001 2.897660e-05 0.0 2.897665e-05 0.001 2.897670e-05 0.0 2.897675e-05 0.001 2.897680e-05 0.0 2.897685e-05 0.001 2.897690e-05 0.0 2.897695e-05 0.001 2.897700e-05 0.0 2.897705e-05 0.001 2.897710e-05 0.0 2.897715e-05 0.001 2.897720e-05 0.0 2.897725e-05 0.001 2.897730e-05 0.0 2.897735e-05 0.001 2.897740e-05 0.0 2.897745e-05 0.001 2.897750e-05 0.0 2.897755e-05 0.001 2.897760e-05 0.0 2.897765e-05 0.001 2.897770e-05 0.0 2.897775e-05 0.001 2.897780e-05 0.0 2.897785e-05 0.001 2.897790e-05 0.0 2.897795e-05 0.001 2.897800e-05 0.0 2.897805e-05 0.001 2.897810e-05 0.0 2.897815e-05 0.001 2.897820e-05 0.0 2.897825e-05 0.001 2.897830e-05 0.0 2.897835e-05 0.001 2.897840e-05 0.0 2.897845e-05 0.001 2.897850e-05 0.0 2.897855e-05 0.001 2.897860e-05 0.0 2.897865e-05 0.001 2.897870e-05 0.0 2.897875e-05 0.001 2.897880e-05 0.0 2.897885e-05 0.001 2.897890e-05 0.0 2.897895e-05 0.001 2.897900e-05 0.0 2.897905e-05 0.001 2.897910e-05 0.0 2.897915e-05 0.001 2.897920e-05 0.0 2.897925e-05 0.001 2.897930e-05 0.0 2.897935e-05 0.001 2.897940e-05 0.0 2.897945e-05 0.001 2.897950e-05 0.0 2.897955e-05 0.001 2.897960e-05 0.0 2.897965e-05 0.001 2.897970e-05 0.0 2.897975e-05 0.001 2.897980e-05 0.0 2.897985e-05 0.001 2.897990e-05 0.0 2.897995e-05 0.001 2.898000e-05 0.0 2.898005e-05 0.001 2.898010e-05 0.0 2.898015e-05 0.001 2.898020e-05 0.0 2.898025e-05 0.001 2.898030e-05 0.0 2.898035e-05 0.001 2.898040e-05 0.0 2.898045e-05 0.001 2.898050e-05 0.0 2.898055e-05 0.001 2.898060e-05 0.0 2.898065e-05 0.001 2.898070e-05 0.0 2.898075e-05 0.001 2.898080e-05 0.0 2.898085e-05 0.001 2.898090e-05 0.0 2.898095e-05 0.001 2.898100e-05 0.0 2.898105e-05 0.001 2.898110e-05 0.0 2.898115e-05 0.001 2.898120e-05 0.0 2.898125e-05 0.001 2.898130e-05 0.0 2.898135e-05 0.001 2.898140e-05 0.0 2.898145e-05 0.001 2.898150e-05 0.0 2.898155e-05 0.001 2.898160e-05 0.0 2.898165e-05 0.001 2.898170e-05 0.0 2.898175e-05 0.001 2.898180e-05 0.0 2.898185e-05 0.001 2.898190e-05 0.0 2.898195e-05 0.001 2.898200e-05 0.0 2.898205e-05 0.001 2.898210e-05 0.0 2.898215e-05 0.001 2.898220e-05 0.0 2.898225e-05 0.001 2.898230e-05 0.0 2.898235e-05 0.001 2.898240e-05 0.0 2.898245e-05 0.001 2.898250e-05 0.0 2.898255e-05 0.001 2.898260e-05 0.0 2.898265e-05 0.001 2.898270e-05 0.0 2.898275e-05 0.001 2.898280e-05 0.0 2.898285e-05 0.001 2.898290e-05 0.0 2.898295e-05 0.001 2.898300e-05 0.0 2.898305e-05 0.001 2.898310e-05 0.0 2.898315e-05 0.001 2.898320e-05 0.0 2.898325e-05 0.001 2.898330e-05 0.0 2.898335e-05 0.001 2.898340e-05 0.0 2.898345e-05 0.001 2.898350e-05 0.0 2.898355e-05 0.001 2.898360e-05 0.0 2.898365e-05 0.001 2.898370e-05 0.0 2.898375e-05 0.001 2.898380e-05 0.0 2.898385e-05 0.001 2.898390e-05 0.0 2.898395e-05 0.001 2.898400e-05 0.0 2.898405e-05 0.001 2.898410e-05 0.0 2.898415e-05 0.001 2.898420e-05 0.0 2.898425e-05 0.001 2.898430e-05 0.0 2.898435e-05 0.001 2.898440e-05 0.0 2.898445e-05 0.001 2.898450e-05 0.0 2.898455e-05 0.001 2.898460e-05 0.0 2.898465e-05 0.001 2.898470e-05 0.0 2.898475e-05 0.001 2.898480e-05 0.0 2.898485e-05 0.001 2.898490e-05 0.0 2.898495e-05 0.001 2.898500e-05 0.0 2.898505e-05 0.001 2.898510e-05 0.0 2.898515e-05 0.001 2.898520e-05 0.0 2.898525e-05 0.001 2.898530e-05 0.0 2.898535e-05 0.001 2.898540e-05 0.0 2.898545e-05 0.001 2.898550e-05 0.0 2.898555e-05 0.001 2.898560e-05 0.0 2.898565e-05 0.001 2.898570e-05 0.0 2.898575e-05 0.001 2.898580e-05 0.0 2.898585e-05 0.001 2.898590e-05 0.0 2.898595e-05 0.001 2.898600e-05 0.0 2.898605e-05 0.001 2.898610e-05 0.0 2.898615e-05 0.001 2.898620e-05 0.0 2.898625e-05 0.001 2.898630e-05 0.0 2.898635e-05 0.001 2.898640e-05 0.0 2.898645e-05 0.001 2.898650e-05 0.0 2.898655e-05 0.001 2.898660e-05 0.0 2.898665e-05 0.001 2.898670e-05 0.0 2.898675e-05 0.001 2.898680e-05 0.0 2.898685e-05 0.001 2.898690e-05 0.0 2.898695e-05 0.001 2.898700e-05 0.0 2.898705e-05 0.001 2.898710e-05 0.0 2.898715e-05 0.001 2.898720e-05 0.0 2.898725e-05 0.001 2.898730e-05 0.0 2.898735e-05 0.001 2.898740e-05 0.0 2.898745e-05 0.001 2.898750e-05 0.0 2.898755e-05 0.001 2.898760e-05 0.0 2.898765e-05 0.001 2.898770e-05 0.0 2.898775e-05 0.001 2.898780e-05 0.0 2.898785e-05 0.001 2.898790e-05 0.0 2.898795e-05 0.001 2.898800e-05 0.0 2.898805e-05 0.001 2.898810e-05 0.0 2.898815e-05 0.001 2.898820e-05 0.0 2.898825e-05 0.001 2.898830e-05 0.0 2.898835e-05 0.001 2.898840e-05 0.0 2.898845e-05 0.001 2.898850e-05 0.0 2.898855e-05 0.001 2.898860e-05 0.0 2.898865e-05 0.001 2.898870e-05 0.0 2.898875e-05 0.001 2.898880e-05 0.0 2.898885e-05 0.001 2.898890e-05 0.0 2.898895e-05 0.001 2.898900e-05 0.0 2.898905e-05 0.001 2.898910e-05 0.0 2.898915e-05 0.001 2.898920e-05 0.0 2.898925e-05 0.001 2.898930e-05 0.0 2.898935e-05 0.001 2.898940e-05 0.0 2.898945e-05 0.001 2.898950e-05 0.0 2.898955e-05 0.001 2.898960e-05 0.0 2.898965e-05 0.001 2.898970e-05 0.0 2.898975e-05 0.001 2.898980e-05 0.0 2.898985e-05 0.001 2.898990e-05 0.0 2.898995e-05 0.001 2.899000e-05 0.0 2.899005e-05 0.001 2.899010e-05 0.0 2.899015e-05 0.001 2.899020e-05 0.0 2.899025e-05 0.001 2.899030e-05 0.0 2.899035e-05 0.001 2.899040e-05 0.0 2.899045e-05 0.001 2.899050e-05 0.0 2.899055e-05 0.001 2.899060e-05 0.0 2.899065e-05 0.001 2.899070e-05 0.0 2.899075e-05 0.001 2.899080e-05 0.0 2.899085e-05 0.001 2.899090e-05 0.0 2.899095e-05 0.001 2.899100e-05 0.0 2.899105e-05 0.001 2.899110e-05 0.0 2.899115e-05 0.001 2.899120e-05 0.0 2.899125e-05 0.001 2.899130e-05 0.0 2.899135e-05 0.001 2.899140e-05 0.0 2.899145e-05 0.001 2.899150e-05 0.0 2.899155e-05 0.001 2.899160e-05 0.0 2.899165e-05 0.001 2.899170e-05 0.0 2.899175e-05 0.001 2.899180e-05 0.0 2.899185e-05 0.001 2.899190e-05 0.0 2.899195e-05 0.001 2.899200e-05 0.0 2.899205e-05 0.001 2.899210e-05 0.0 2.899215e-05 0.001 2.899220e-05 0.0 2.899225e-05 0.001 2.899230e-05 0.0 2.899235e-05 0.001 2.899240e-05 0.0 2.899245e-05 0.001 2.899250e-05 0.0 2.899255e-05 0.001 2.899260e-05 0.0 2.899265e-05 0.001 2.899270e-05 0.0 2.899275e-05 0.001 2.899280e-05 0.0 2.899285e-05 0.001 2.899290e-05 0.0 2.899295e-05 0.001 2.899300e-05 0.0 2.899305e-05 0.001 2.899310e-05 0.0 2.899315e-05 0.001 2.899320e-05 0.0 2.899325e-05 0.001 2.899330e-05 0.0 2.899335e-05 0.001 2.899340e-05 0.0 2.899345e-05 0.001 2.899350e-05 0.0 2.899355e-05 0.001 2.899360e-05 0.0 2.899365e-05 0.001 2.899370e-05 0.0 2.899375e-05 0.001 2.899380e-05 0.0 2.899385e-05 0.001 2.899390e-05 0.0 2.899395e-05 0.001 2.899400e-05 0.0 2.899405e-05 0.001 2.899410e-05 0.0 2.899415e-05 0.001 2.899420e-05 0.0 2.899425e-05 0.001 2.899430e-05 0.0 2.899435e-05 0.001 2.899440e-05 0.0 2.899445e-05 0.001 2.899450e-05 0.0 2.899455e-05 0.001 2.899460e-05 0.0 2.899465e-05 0.001 2.899470e-05 0.0 2.899475e-05 0.001 2.899480e-05 0.0 2.899485e-05 0.001 2.899490e-05 0.0 2.899495e-05 0.001 2.899500e-05 0.0 2.899505e-05 0.001 2.899510e-05 0.0 2.899515e-05 0.001 2.899520e-05 0.0 2.899525e-05 0.001 2.899530e-05 0.0 2.899535e-05 0.001 2.899540e-05 0.0 2.899545e-05 0.001 2.899550e-05 0.0 2.899555e-05 0.001 2.899560e-05 0.0 2.899565e-05 0.001 2.899570e-05 0.0 2.899575e-05 0.001 2.899580e-05 0.0 2.899585e-05 0.001 2.899590e-05 0.0 2.899595e-05 0.001 2.899600e-05 0.0 2.899605e-05 0.001 2.899610e-05 0.0 2.899615e-05 0.001 2.899620e-05 0.0 2.899625e-05 0.001 2.899630e-05 0.0 2.899635e-05 0.001 2.899640e-05 0.0 2.899645e-05 0.001 2.899650e-05 0.0 2.899655e-05 0.001 2.899660e-05 0.0 2.899665e-05 0.001 2.899670e-05 0.0 2.899675e-05 0.001 2.899680e-05 0.0 2.899685e-05 0.001 2.899690e-05 0.0 2.899695e-05 0.001 2.899700e-05 0.0 2.899705e-05 0.001 2.899710e-05 0.0 2.899715e-05 0.001 2.899720e-05 0.0 2.899725e-05 0.001 2.899730e-05 0.0 2.899735e-05 0.001 2.899740e-05 0.0 2.899745e-05 0.001 2.899750e-05 0.0 2.899755e-05 0.001 2.899760e-05 0.0 2.899765e-05 0.001 2.899770e-05 0.0 2.899775e-05 0.001 2.899780e-05 0.0 2.899785e-05 0.001 2.899790e-05 0.0 2.899795e-05 0.001 2.899800e-05 0.0 2.899805e-05 0.001 2.899810e-05 0.0 2.899815e-05 0.001 2.899820e-05 0.0 2.899825e-05 0.001 2.899830e-05 0.0 2.899835e-05 0.001 2.899840e-05 0.0 2.899845e-05 0.001 2.899850e-05 0.0 2.899855e-05 0.001 2.899860e-05 0.0 2.899865e-05 0.001 2.899870e-05 0.0 2.899875e-05 0.001 2.899880e-05 0.0 2.899885e-05 0.001 2.899890e-05 0.0 2.899895e-05 0.001 2.899900e-05 0.0 2.899905e-05 0.001 2.899910e-05 0.0 2.899915e-05 0.001 2.899920e-05 0.0 2.899925e-05 0.001 2.899930e-05 0.0 2.899935e-05 0.001 2.899940e-05 0.0 2.899945e-05 0.001 2.899950e-05 0.0 2.899955e-05 0.001 2.899960e-05 0.0 2.899965e-05 0.001 2.899970e-05 0.0 2.899975e-05 0.001 2.899980e-05 0.0 2.899985e-05 0.001 2.899990e-05 0.0 2.899995e-05 0.001 2.900000e-05 0.0 2.900005e-05 0.001 2.900010e-05 0.0 2.900015e-05 0.001 2.900020e-05 0.0 2.900025e-05 0.001 2.900030e-05 0.0 2.900035e-05 0.001 2.900040e-05 0.0 2.900045e-05 0.001 2.900050e-05 0.0 2.900055e-05 0.001 2.900060e-05 0.0 2.900065e-05 0.001 2.900070e-05 0.0 2.900075e-05 0.001 2.900080e-05 0.0 2.900085e-05 0.001 2.900090e-05 0.0 2.900095e-05 0.001 2.900100e-05 0.0 2.900105e-05 0.001 2.900110e-05 0.0 2.900115e-05 0.001 2.900120e-05 0.0 2.900125e-05 0.001 2.900130e-05 0.0 2.900135e-05 0.001 2.900140e-05 0.0 2.900145e-05 0.001 2.900150e-05 0.0 2.900155e-05 0.001 2.900160e-05 0.0 2.900165e-05 0.001 2.900170e-05 0.0 2.900175e-05 0.001 2.900180e-05 0.0 2.900185e-05 0.001 2.900190e-05 0.0 2.900195e-05 0.001 2.900200e-05 0.0 2.900205e-05 0.001 2.900210e-05 0.0 2.900215e-05 0.001 2.900220e-05 0.0 2.900225e-05 0.001 2.900230e-05 0.0 2.900235e-05 0.001 2.900240e-05 0.0 2.900245e-05 0.001 2.900250e-05 0.0 2.900255e-05 0.001 2.900260e-05 0.0 2.900265e-05 0.001 2.900270e-05 0.0 2.900275e-05 0.001 2.900280e-05 0.0 2.900285e-05 0.001 2.900290e-05 0.0 2.900295e-05 0.001 2.900300e-05 0.0 2.900305e-05 0.001 2.900310e-05 0.0 2.900315e-05 0.001 2.900320e-05 0.0 2.900325e-05 0.001 2.900330e-05 0.0 2.900335e-05 0.001 2.900340e-05 0.0 2.900345e-05 0.001 2.900350e-05 0.0 2.900355e-05 0.001 2.900360e-05 0.0 2.900365e-05 0.001 2.900370e-05 0.0 2.900375e-05 0.001 2.900380e-05 0.0 2.900385e-05 0.001 2.900390e-05 0.0 2.900395e-05 0.001 2.900400e-05 0.0 2.900405e-05 0.001 2.900410e-05 0.0 2.900415e-05 0.001 2.900420e-05 0.0 2.900425e-05 0.001 2.900430e-05 0.0 2.900435e-05 0.001 2.900440e-05 0.0 2.900445e-05 0.001 2.900450e-05 0.0 2.900455e-05 0.001 2.900460e-05 0.0 2.900465e-05 0.001 2.900470e-05 0.0 2.900475e-05 0.001 2.900480e-05 0.0 2.900485e-05 0.001 2.900490e-05 0.0 2.900495e-05 0.001 2.900500e-05 0.0 2.900505e-05 0.001 2.900510e-05 0.0 2.900515e-05 0.001 2.900520e-05 0.0 2.900525e-05 0.001 2.900530e-05 0.0 2.900535e-05 0.001 2.900540e-05 0.0 2.900545e-05 0.001 2.900550e-05 0.0 2.900555e-05 0.001 2.900560e-05 0.0 2.900565e-05 0.001 2.900570e-05 0.0 2.900575e-05 0.001 2.900580e-05 0.0 2.900585e-05 0.001 2.900590e-05 0.0 2.900595e-05 0.001 2.900600e-05 0.0 2.900605e-05 0.001 2.900610e-05 0.0 2.900615e-05 0.001 2.900620e-05 0.0 2.900625e-05 0.001 2.900630e-05 0.0 2.900635e-05 0.001 2.900640e-05 0.0 2.900645e-05 0.001 2.900650e-05 0.0 2.900655e-05 0.001 2.900660e-05 0.0 2.900665e-05 0.001 2.900670e-05 0.0 2.900675e-05 0.001 2.900680e-05 0.0 2.900685e-05 0.001 2.900690e-05 0.0 2.900695e-05 0.001 2.900700e-05 0.0 2.900705e-05 0.001 2.900710e-05 0.0 2.900715e-05 0.001 2.900720e-05 0.0 2.900725e-05 0.001 2.900730e-05 0.0 2.900735e-05 0.001 2.900740e-05 0.0 2.900745e-05 0.001 2.900750e-05 0.0 2.900755e-05 0.001 2.900760e-05 0.0 2.900765e-05 0.001 2.900770e-05 0.0 2.900775e-05 0.001 2.900780e-05 0.0 2.900785e-05 0.001 2.900790e-05 0.0 2.900795e-05 0.001 2.900800e-05 0.0 2.900805e-05 0.001 2.900810e-05 0.0 2.900815e-05 0.001 2.900820e-05 0.0 2.900825e-05 0.001 2.900830e-05 0.0 2.900835e-05 0.001 2.900840e-05 0.0 2.900845e-05 0.001 2.900850e-05 0.0 2.900855e-05 0.001 2.900860e-05 0.0 2.900865e-05 0.001 2.900870e-05 0.0 2.900875e-05 0.001 2.900880e-05 0.0 2.900885e-05 0.001 2.900890e-05 0.0 2.900895e-05 0.001 2.900900e-05 0.0 2.900905e-05 0.001 2.900910e-05 0.0 2.900915e-05 0.001 2.900920e-05 0.0 2.900925e-05 0.001 2.900930e-05 0.0 2.900935e-05 0.001 2.900940e-05 0.0 2.900945e-05 0.001 2.900950e-05 0.0 2.900955e-05 0.001 2.900960e-05 0.0 2.900965e-05 0.001 2.900970e-05 0.0 2.900975e-05 0.001 2.900980e-05 0.0 2.900985e-05 0.001 2.900990e-05 0.0 2.900995e-05 0.001 2.901000e-05 0.0 2.901005e-05 0.001 2.901010e-05 0.0 2.901015e-05 0.001 2.901020e-05 0.0 2.901025e-05 0.001 2.901030e-05 0.0 2.901035e-05 0.001 2.901040e-05 0.0 2.901045e-05 0.001 2.901050e-05 0.0 2.901055e-05 0.001 2.901060e-05 0.0 2.901065e-05 0.001 2.901070e-05 0.0 2.901075e-05 0.001 2.901080e-05 0.0 2.901085e-05 0.001 2.901090e-05 0.0 2.901095e-05 0.001 2.901100e-05 0.0 2.901105e-05 0.001 2.901110e-05 0.0 2.901115e-05 0.001 2.901120e-05 0.0 2.901125e-05 0.001 2.901130e-05 0.0 2.901135e-05 0.001 2.901140e-05 0.0 2.901145e-05 0.001 2.901150e-05 0.0 2.901155e-05 0.001 2.901160e-05 0.0 2.901165e-05 0.001 2.901170e-05 0.0 2.901175e-05 0.001 2.901180e-05 0.0 2.901185e-05 0.001 2.901190e-05 0.0 2.901195e-05 0.001 2.901200e-05 0.0 2.901205e-05 0.001 2.901210e-05 0.0 2.901215e-05 0.001 2.901220e-05 0.0 2.901225e-05 0.001 2.901230e-05 0.0 2.901235e-05 0.001 2.901240e-05 0.0 2.901245e-05 0.001 2.901250e-05 0.0 2.901255e-05 0.001 2.901260e-05 0.0 2.901265e-05 0.001 2.901270e-05 0.0 2.901275e-05 0.001 2.901280e-05 0.0 2.901285e-05 0.001 2.901290e-05 0.0 2.901295e-05 0.001 2.901300e-05 0.0 2.901305e-05 0.001 2.901310e-05 0.0 2.901315e-05 0.001 2.901320e-05 0.0 2.901325e-05 0.001 2.901330e-05 0.0 2.901335e-05 0.001 2.901340e-05 0.0 2.901345e-05 0.001 2.901350e-05 0.0 2.901355e-05 0.001 2.901360e-05 0.0 2.901365e-05 0.001 2.901370e-05 0.0 2.901375e-05 0.001 2.901380e-05 0.0 2.901385e-05 0.001 2.901390e-05 0.0 2.901395e-05 0.001 2.901400e-05 0.0 2.901405e-05 0.001 2.901410e-05 0.0 2.901415e-05 0.001 2.901420e-05 0.0 2.901425e-05 0.001 2.901430e-05 0.0 2.901435e-05 0.001 2.901440e-05 0.0 2.901445e-05 0.001 2.901450e-05 0.0 2.901455e-05 0.001 2.901460e-05 0.0 2.901465e-05 0.001 2.901470e-05 0.0 2.901475e-05 0.001 2.901480e-05 0.0 2.901485e-05 0.001 2.901490e-05 0.0 2.901495e-05 0.001 2.901500e-05 0.0 2.901505e-05 0.001 2.901510e-05 0.0 2.901515e-05 0.001 2.901520e-05 0.0 2.901525e-05 0.001 2.901530e-05 0.0 2.901535e-05 0.001 2.901540e-05 0.0 2.901545e-05 0.001 2.901550e-05 0.0 2.901555e-05 0.001 2.901560e-05 0.0 2.901565e-05 0.001 2.901570e-05 0.0 2.901575e-05 0.001 2.901580e-05 0.0 2.901585e-05 0.001 2.901590e-05 0.0 2.901595e-05 0.001 2.901600e-05 0.0 2.901605e-05 0.001 2.901610e-05 0.0 2.901615e-05 0.001 2.901620e-05 0.0 2.901625e-05 0.001 2.901630e-05 0.0 2.901635e-05 0.001 2.901640e-05 0.0 2.901645e-05 0.001 2.901650e-05 0.0 2.901655e-05 0.001 2.901660e-05 0.0 2.901665e-05 0.001 2.901670e-05 0.0 2.901675e-05 0.001 2.901680e-05 0.0 2.901685e-05 0.001 2.901690e-05 0.0 2.901695e-05 0.001 2.901700e-05 0.0 2.901705e-05 0.001 2.901710e-05 0.0 2.901715e-05 0.001 2.901720e-05 0.0 2.901725e-05 0.001 2.901730e-05 0.0 2.901735e-05 0.001 2.901740e-05 0.0 2.901745e-05 0.001 2.901750e-05 0.0 2.901755e-05 0.001 2.901760e-05 0.0 2.901765e-05 0.001 2.901770e-05 0.0 2.901775e-05 0.001 2.901780e-05 0.0 2.901785e-05 0.001 2.901790e-05 0.0 2.901795e-05 0.001 2.901800e-05 0.0 2.901805e-05 0.001 2.901810e-05 0.0 2.901815e-05 0.001 2.901820e-05 0.0 2.901825e-05 0.001 2.901830e-05 0.0 2.901835e-05 0.001 2.901840e-05 0.0 2.901845e-05 0.001 2.901850e-05 0.0 2.901855e-05 0.001 2.901860e-05 0.0 2.901865e-05 0.001 2.901870e-05 0.0 2.901875e-05 0.001 2.901880e-05 0.0 2.901885e-05 0.001 2.901890e-05 0.0 2.901895e-05 0.001 2.901900e-05 0.0 2.901905e-05 0.001 2.901910e-05 0.0 2.901915e-05 0.001 2.901920e-05 0.0 2.901925e-05 0.001 2.901930e-05 0.0 2.901935e-05 0.001 2.901940e-05 0.0 2.901945e-05 0.001 2.901950e-05 0.0 2.901955e-05 0.001 2.901960e-05 0.0 2.901965e-05 0.001 2.901970e-05 0.0 2.901975e-05 0.001 2.901980e-05 0.0 2.901985e-05 0.001 2.901990e-05 0.0 2.901995e-05 0.001 2.902000e-05 0.0 2.902005e-05 0.001 2.902010e-05 0.0 2.902015e-05 0.001 2.902020e-05 0.0 2.902025e-05 0.001 2.902030e-05 0.0 2.902035e-05 0.001 2.902040e-05 0.0 2.902045e-05 0.001 2.902050e-05 0.0 2.902055e-05 0.001 2.902060e-05 0.0 2.902065e-05 0.001 2.902070e-05 0.0 2.902075e-05 0.001 2.902080e-05 0.0 2.902085e-05 0.001 2.902090e-05 0.0 2.902095e-05 0.001 2.902100e-05 0.0 2.902105e-05 0.001 2.902110e-05 0.0 2.902115e-05 0.001 2.902120e-05 0.0 2.902125e-05 0.001 2.902130e-05 0.0 2.902135e-05 0.001 2.902140e-05 0.0 2.902145e-05 0.001 2.902150e-05 0.0 2.902155e-05 0.001 2.902160e-05 0.0 2.902165e-05 0.001 2.902170e-05 0.0 2.902175e-05 0.001 2.902180e-05 0.0 2.902185e-05 0.001 2.902190e-05 0.0 2.902195e-05 0.001 2.902200e-05 0.0 2.902205e-05 0.001 2.902210e-05 0.0 2.902215e-05 0.001 2.902220e-05 0.0 2.902225e-05 0.001 2.902230e-05 0.0 2.902235e-05 0.001 2.902240e-05 0.0 2.902245e-05 0.001 2.902250e-05 0.0 2.902255e-05 0.001 2.902260e-05 0.0 2.902265e-05 0.001 2.902270e-05 0.0 2.902275e-05 0.001 2.902280e-05 0.0 2.902285e-05 0.001 2.902290e-05 0.0 2.902295e-05 0.001 2.902300e-05 0.0 2.902305e-05 0.001 2.902310e-05 0.0 2.902315e-05 0.001 2.902320e-05 0.0 2.902325e-05 0.001 2.902330e-05 0.0 2.902335e-05 0.001 2.902340e-05 0.0 2.902345e-05 0.001 2.902350e-05 0.0 2.902355e-05 0.001 2.902360e-05 0.0 2.902365e-05 0.001 2.902370e-05 0.0 2.902375e-05 0.001 2.902380e-05 0.0 2.902385e-05 0.001 2.902390e-05 0.0 2.902395e-05 0.001 2.902400e-05 0.0 2.902405e-05 0.001 2.902410e-05 0.0 2.902415e-05 0.001 2.902420e-05 0.0 2.902425e-05 0.001 2.902430e-05 0.0 2.902435e-05 0.001 2.902440e-05 0.0 2.902445e-05 0.001 2.902450e-05 0.0 2.902455e-05 0.001 2.902460e-05 0.0 2.902465e-05 0.001 2.902470e-05 0.0 2.902475e-05 0.001 2.902480e-05 0.0 2.902485e-05 0.001 2.902490e-05 0.0 2.902495e-05 0.001 2.902500e-05 0.0 2.902505e-05 0.001 2.902510e-05 0.0 2.902515e-05 0.001 2.902520e-05 0.0 2.902525e-05 0.001 2.902530e-05 0.0 2.902535e-05 0.001 2.902540e-05 0.0 2.902545e-05 0.001 2.902550e-05 0.0 2.902555e-05 0.001 2.902560e-05 0.0 2.902565e-05 0.001 2.902570e-05 0.0 2.902575e-05 0.001 2.902580e-05 0.0 2.902585e-05 0.001 2.902590e-05 0.0 2.902595e-05 0.001 2.902600e-05 0.0 2.902605e-05 0.001 2.902610e-05 0.0 2.902615e-05 0.001 2.902620e-05 0.0 2.902625e-05 0.001 2.902630e-05 0.0 2.902635e-05 0.001 2.902640e-05 0.0 2.902645e-05 0.001 2.902650e-05 0.0 2.902655e-05 0.001 2.902660e-05 0.0 2.902665e-05 0.001 2.902670e-05 0.0 2.902675e-05 0.001 2.902680e-05 0.0 2.902685e-05 0.001 2.902690e-05 0.0 2.902695e-05 0.001 2.902700e-05 0.0 2.902705e-05 0.001 2.902710e-05 0.0 2.902715e-05 0.001 2.902720e-05 0.0 2.902725e-05 0.001 2.902730e-05 0.0 2.902735e-05 0.001 2.902740e-05 0.0 2.902745e-05 0.001 2.902750e-05 0.0 2.902755e-05 0.001 2.902760e-05 0.0 2.902765e-05 0.001 2.902770e-05 0.0 2.902775e-05 0.001 2.902780e-05 0.0 2.902785e-05 0.001 2.902790e-05 0.0 2.902795e-05 0.001 2.902800e-05 0.0 2.902805e-05 0.001 2.902810e-05 0.0 2.902815e-05 0.001 2.902820e-05 0.0 2.902825e-05 0.001 2.902830e-05 0.0 2.902835e-05 0.001 2.902840e-05 0.0 2.902845e-05 0.001 2.902850e-05 0.0 2.902855e-05 0.001 2.902860e-05 0.0 2.902865e-05 0.001 2.902870e-05 0.0 2.902875e-05 0.001 2.902880e-05 0.0 2.902885e-05 0.001 2.902890e-05 0.0 2.902895e-05 0.001 2.902900e-05 0.0 2.902905e-05 0.001 2.902910e-05 0.0 2.902915e-05 0.001 2.902920e-05 0.0 2.902925e-05 0.001 2.902930e-05 0.0 2.902935e-05 0.001 2.902940e-05 0.0 2.902945e-05 0.001 2.902950e-05 0.0 2.902955e-05 0.001 2.902960e-05 0.0 2.902965e-05 0.001 2.902970e-05 0.0 2.902975e-05 0.001 2.902980e-05 0.0 2.902985e-05 0.001 2.902990e-05 0.0 2.902995e-05 0.001 2.903000e-05 0.0 2.903005e-05 0.001 2.903010e-05 0.0 2.903015e-05 0.001 2.903020e-05 0.0 2.903025e-05 0.001 2.903030e-05 0.0 2.903035e-05 0.001 2.903040e-05 0.0 2.903045e-05 0.001 2.903050e-05 0.0 2.903055e-05 0.001 2.903060e-05 0.0 2.903065e-05 0.001 2.903070e-05 0.0 2.903075e-05 0.001 2.903080e-05 0.0 2.903085e-05 0.001 2.903090e-05 0.0 2.903095e-05 0.001 2.903100e-05 0.0 2.903105e-05 0.001 2.903110e-05 0.0 2.903115e-05 0.001 2.903120e-05 0.0 2.903125e-05 0.001 2.903130e-05 0.0 2.903135e-05 0.001 2.903140e-05 0.0 2.903145e-05 0.001 2.903150e-05 0.0 2.903155e-05 0.001 2.903160e-05 0.0 2.903165e-05 0.001 2.903170e-05 0.0 2.903175e-05 0.001 2.903180e-05 0.0 2.903185e-05 0.001 2.903190e-05 0.0 2.903195e-05 0.001 2.903200e-05 0.0 2.903205e-05 0.001 2.903210e-05 0.0 2.903215e-05 0.001 2.903220e-05 0.0 2.903225e-05 0.001 2.903230e-05 0.0 2.903235e-05 0.001 2.903240e-05 0.0 2.903245e-05 0.001 2.903250e-05 0.0 2.903255e-05 0.001 2.903260e-05 0.0 2.903265e-05 0.001 2.903270e-05 0.0 2.903275e-05 0.001 2.903280e-05 0.0 2.903285e-05 0.001 2.903290e-05 0.0 2.903295e-05 0.001 2.903300e-05 0.0 2.903305e-05 0.001 2.903310e-05 0.0 2.903315e-05 0.001 2.903320e-05 0.0 2.903325e-05 0.001 2.903330e-05 0.0 2.903335e-05 0.001 2.903340e-05 0.0 2.903345e-05 0.001 2.903350e-05 0.0 2.903355e-05 0.001 2.903360e-05 0.0 2.903365e-05 0.001 2.903370e-05 0.0 2.903375e-05 0.001 2.903380e-05 0.0 2.903385e-05 0.001 2.903390e-05 0.0 2.903395e-05 0.001 2.903400e-05 0.0 2.903405e-05 0.001 2.903410e-05 0.0 2.903415e-05 0.001 2.903420e-05 0.0 2.903425e-05 0.001 2.903430e-05 0.0 2.903435e-05 0.001 2.903440e-05 0.0 2.903445e-05 0.001 2.903450e-05 0.0 2.903455e-05 0.001 2.903460e-05 0.0 2.903465e-05 0.001 2.903470e-05 0.0 2.903475e-05 0.001 2.903480e-05 0.0 2.903485e-05 0.001 2.903490e-05 0.0 2.903495e-05 0.001 2.903500e-05 0.0 2.903505e-05 0.001 2.903510e-05 0.0 2.903515e-05 0.001 2.903520e-05 0.0 2.903525e-05 0.001 2.903530e-05 0.0 2.903535e-05 0.001 2.903540e-05 0.0 2.903545e-05 0.001 2.903550e-05 0.0 2.903555e-05 0.001 2.903560e-05 0.0 2.903565e-05 0.001 2.903570e-05 0.0 2.903575e-05 0.001 2.903580e-05 0.0 2.903585e-05 0.001 2.903590e-05 0.0 2.903595e-05 0.001 2.903600e-05 0.0 2.903605e-05 0.001 2.903610e-05 0.0 2.903615e-05 0.001 2.903620e-05 0.0 2.903625e-05 0.001 2.903630e-05 0.0 2.903635e-05 0.001 2.903640e-05 0.0 2.903645e-05 0.001 2.903650e-05 0.0 2.903655e-05 0.001 2.903660e-05 0.0 2.903665e-05 0.001 2.903670e-05 0.0 2.903675e-05 0.001 2.903680e-05 0.0 2.903685e-05 0.001 2.903690e-05 0.0 2.903695e-05 0.001 2.903700e-05 0.0 2.903705e-05 0.001 2.903710e-05 0.0 2.903715e-05 0.001 2.903720e-05 0.0 2.903725e-05 0.001 2.903730e-05 0.0 2.903735e-05 0.001 2.903740e-05 0.0 2.903745e-05 0.001 2.903750e-05 0.0 2.903755e-05 0.001 2.903760e-05 0.0 2.903765e-05 0.001 2.903770e-05 0.0 2.903775e-05 0.001 2.903780e-05 0.0 2.903785e-05 0.001 2.903790e-05 0.0 2.903795e-05 0.001 2.903800e-05 0.0 2.903805e-05 0.001 2.903810e-05 0.0 2.903815e-05 0.001 2.903820e-05 0.0 2.903825e-05 0.001 2.903830e-05 0.0 2.903835e-05 0.001 2.903840e-05 0.0 2.903845e-05 0.001 2.903850e-05 0.0 2.903855e-05 0.001 2.903860e-05 0.0 2.903865e-05 0.001 2.903870e-05 0.0 2.903875e-05 0.001 2.903880e-05 0.0 2.903885e-05 0.001 2.903890e-05 0.0 2.903895e-05 0.001 2.903900e-05 0.0 2.903905e-05 0.001 2.903910e-05 0.0 2.903915e-05 0.001 2.903920e-05 0.0 2.903925e-05 0.001 2.903930e-05 0.0 2.903935e-05 0.001 2.903940e-05 0.0 2.903945e-05 0.001 2.903950e-05 0.0 2.903955e-05 0.001 2.903960e-05 0.0 2.903965e-05 0.001 2.903970e-05 0.0 2.903975e-05 0.001 2.903980e-05 0.0 2.903985e-05 0.001 2.903990e-05 0.0 2.903995e-05 0.001 2.904000e-05 0.0 2.904005e-05 0.001 2.904010e-05 0.0 2.904015e-05 0.001 2.904020e-05 0.0 2.904025e-05 0.001 2.904030e-05 0.0 2.904035e-05 0.001 2.904040e-05 0.0 2.904045e-05 0.001 2.904050e-05 0.0 2.904055e-05 0.001 2.904060e-05 0.0 2.904065e-05 0.001 2.904070e-05 0.0 2.904075e-05 0.001 2.904080e-05 0.0 2.904085e-05 0.001 2.904090e-05 0.0 2.904095e-05 0.001 2.904100e-05 0.0 2.904105e-05 0.001 2.904110e-05 0.0 2.904115e-05 0.001 2.904120e-05 0.0 2.904125e-05 0.001 2.904130e-05 0.0 2.904135e-05 0.001 2.904140e-05 0.0 2.904145e-05 0.001 2.904150e-05 0.0 2.904155e-05 0.001 2.904160e-05 0.0 2.904165e-05 0.001 2.904170e-05 0.0 2.904175e-05 0.001 2.904180e-05 0.0 2.904185e-05 0.001 2.904190e-05 0.0 2.904195e-05 0.001 2.904200e-05 0.0 2.904205e-05 0.001 2.904210e-05 0.0 2.904215e-05 0.001 2.904220e-05 0.0 2.904225e-05 0.001 2.904230e-05 0.0 2.904235e-05 0.001 2.904240e-05 0.0 2.904245e-05 0.001 2.904250e-05 0.0 2.904255e-05 0.001 2.904260e-05 0.0 2.904265e-05 0.001 2.904270e-05 0.0 2.904275e-05 0.001 2.904280e-05 0.0 2.904285e-05 0.001 2.904290e-05 0.0 2.904295e-05 0.001 2.904300e-05 0.0 2.904305e-05 0.001 2.904310e-05 0.0 2.904315e-05 0.001 2.904320e-05 0.0 2.904325e-05 0.001 2.904330e-05 0.0 2.904335e-05 0.001 2.904340e-05 0.0 2.904345e-05 0.001 2.904350e-05 0.0 2.904355e-05 0.001 2.904360e-05 0.0 2.904365e-05 0.001 2.904370e-05 0.0 2.904375e-05 0.001 2.904380e-05 0.0 2.904385e-05 0.001 2.904390e-05 0.0 2.904395e-05 0.001 2.904400e-05 0.0 2.904405e-05 0.001 2.904410e-05 0.0 2.904415e-05 0.001 2.904420e-05 0.0 2.904425e-05 0.001 2.904430e-05 0.0 2.904435e-05 0.001 2.904440e-05 0.0 2.904445e-05 0.001 2.904450e-05 0.0 2.904455e-05 0.001 2.904460e-05 0.0 2.904465e-05 0.001 2.904470e-05 0.0 2.904475e-05 0.001 2.904480e-05 0.0 2.904485e-05 0.001 2.904490e-05 0.0 2.904495e-05 0.001 2.904500e-05 0.0 2.904505e-05 0.001 2.904510e-05 0.0 2.904515e-05 0.001 2.904520e-05 0.0 2.904525e-05 0.001 2.904530e-05 0.0 2.904535e-05 0.001 2.904540e-05 0.0 2.904545e-05 0.001 2.904550e-05 0.0 2.904555e-05 0.001 2.904560e-05 0.0 2.904565e-05 0.001 2.904570e-05 0.0 2.904575e-05 0.001 2.904580e-05 0.0 2.904585e-05 0.001 2.904590e-05 0.0 2.904595e-05 0.001 2.904600e-05 0.0 2.904605e-05 0.001 2.904610e-05 0.0 2.904615e-05 0.001 2.904620e-05 0.0 2.904625e-05 0.001 2.904630e-05 0.0 2.904635e-05 0.001 2.904640e-05 0.0 2.904645e-05 0.001 2.904650e-05 0.0 2.904655e-05 0.001 2.904660e-05 0.0 2.904665e-05 0.001 2.904670e-05 0.0 2.904675e-05 0.001 2.904680e-05 0.0 2.904685e-05 0.001 2.904690e-05 0.0 2.904695e-05 0.001 2.904700e-05 0.0 2.904705e-05 0.001 2.904710e-05 0.0 2.904715e-05 0.001 2.904720e-05 0.0 2.904725e-05 0.001 2.904730e-05 0.0 2.904735e-05 0.001 2.904740e-05 0.0 2.904745e-05 0.001 2.904750e-05 0.0 2.904755e-05 0.001 2.904760e-05 0.0 2.904765e-05 0.001 2.904770e-05 0.0 2.904775e-05 0.001 2.904780e-05 0.0 2.904785e-05 0.001 2.904790e-05 0.0 2.904795e-05 0.001 2.904800e-05 0.0 2.904805e-05 0.001 2.904810e-05 0.0 2.904815e-05 0.001 2.904820e-05 0.0 2.904825e-05 0.001 2.904830e-05 0.0 2.904835e-05 0.001 2.904840e-05 0.0 2.904845e-05 0.001 2.904850e-05 0.0 2.904855e-05 0.001 2.904860e-05 0.0 2.904865e-05 0.001 2.904870e-05 0.0 2.904875e-05 0.001 2.904880e-05 0.0 2.904885e-05 0.001 2.904890e-05 0.0 2.904895e-05 0.001 2.904900e-05 0.0 2.904905e-05 0.001 2.904910e-05 0.0 2.904915e-05 0.001 2.904920e-05 0.0 2.904925e-05 0.001 2.904930e-05 0.0 2.904935e-05 0.001 2.904940e-05 0.0 2.904945e-05 0.001 2.904950e-05 0.0 2.904955e-05 0.001 2.904960e-05 0.0 2.904965e-05 0.001 2.904970e-05 0.0 2.904975e-05 0.001 2.904980e-05 0.0 2.904985e-05 0.001 2.904990e-05 0.0 2.904995e-05 0.001 2.905000e-05 0.0 2.905005e-05 0.001 2.905010e-05 0.0 2.905015e-05 0.001 2.905020e-05 0.0 2.905025e-05 0.001 2.905030e-05 0.0 2.905035e-05 0.001 2.905040e-05 0.0 2.905045e-05 0.001 2.905050e-05 0.0 2.905055e-05 0.001 2.905060e-05 0.0 2.905065e-05 0.001 2.905070e-05 0.0 2.905075e-05 0.001 2.905080e-05 0.0 2.905085e-05 0.001 2.905090e-05 0.0 2.905095e-05 0.001 2.905100e-05 0.0 2.905105e-05 0.001 2.905110e-05 0.0 2.905115e-05 0.001 2.905120e-05 0.0 2.905125e-05 0.001 2.905130e-05 0.0 2.905135e-05 0.001 2.905140e-05 0.0 2.905145e-05 0.001 2.905150e-05 0.0 2.905155e-05 0.001 2.905160e-05 0.0 2.905165e-05 0.001 2.905170e-05 0.0 2.905175e-05 0.001 2.905180e-05 0.0 2.905185e-05 0.001 2.905190e-05 0.0 2.905195e-05 0.001 2.905200e-05 0.0 2.905205e-05 0.001 2.905210e-05 0.0 2.905215e-05 0.001 2.905220e-05 0.0 2.905225e-05 0.001 2.905230e-05 0.0 2.905235e-05 0.001 2.905240e-05 0.0 2.905245e-05 0.001 2.905250e-05 0.0 2.905255e-05 0.001 2.905260e-05 0.0 2.905265e-05 0.001 2.905270e-05 0.0 2.905275e-05 0.001 2.905280e-05 0.0 2.905285e-05 0.001 2.905290e-05 0.0 2.905295e-05 0.001 2.905300e-05 0.0 2.905305e-05 0.001 2.905310e-05 0.0 2.905315e-05 0.001 2.905320e-05 0.0 2.905325e-05 0.001 2.905330e-05 0.0 2.905335e-05 0.001 2.905340e-05 0.0 2.905345e-05 0.001 2.905350e-05 0.0 2.905355e-05 0.001 2.905360e-05 0.0 2.905365e-05 0.001 2.905370e-05 0.0 2.905375e-05 0.001 2.905380e-05 0.0 2.905385e-05 0.001 2.905390e-05 0.0 2.905395e-05 0.001 2.905400e-05 0.0 2.905405e-05 0.001 2.905410e-05 0.0 2.905415e-05 0.001 2.905420e-05 0.0 2.905425e-05 0.001 2.905430e-05 0.0 2.905435e-05 0.001 2.905440e-05 0.0 2.905445e-05 0.001 2.905450e-05 0.0 2.905455e-05 0.001 2.905460e-05 0.0 2.905465e-05 0.001 2.905470e-05 0.0 2.905475e-05 0.001 2.905480e-05 0.0 2.905485e-05 0.001 2.905490e-05 0.0 2.905495e-05 0.001 2.905500e-05 0.0 2.905505e-05 0.001 2.905510e-05 0.0 2.905515e-05 0.001 2.905520e-05 0.0 2.905525e-05 0.001 2.905530e-05 0.0 2.905535e-05 0.001 2.905540e-05 0.0 2.905545e-05 0.001 2.905550e-05 0.0 2.905555e-05 0.001 2.905560e-05 0.0 2.905565e-05 0.001 2.905570e-05 0.0 2.905575e-05 0.001 2.905580e-05 0.0 2.905585e-05 0.001 2.905590e-05 0.0 2.905595e-05 0.001 2.905600e-05 0.0 2.905605e-05 0.001 2.905610e-05 0.0 2.905615e-05 0.001 2.905620e-05 0.0 2.905625e-05 0.001 2.905630e-05 0.0 2.905635e-05 0.001 2.905640e-05 0.0 2.905645e-05 0.001 2.905650e-05 0.0 2.905655e-05 0.001 2.905660e-05 0.0 2.905665e-05 0.001 2.905670e-05 0.0 2.905675e-05 0.001 2.905680e-05 0.0 2.905685e-05 0.001 2.905690e-05 0.0 2.905695e-05 0.001 2.905700e-05 0.0 2.905705e-05 0.001 2.905710e-05 0.0 2.905715e-05 0.001 2.905720e-05 0.0 2.905725e-05 0.001 2.905730e-05 0.0 2.905735e-05 0.001 2.905740e-05 0.0 2.905745e-05 0.001 2.905750e-05 0.0 2.905755e-05 0.001 2.905760e-05 0.0 2.905765e-05 0.001 2.905770e-05 0.0 2.905775e-05 0.001 2.905780e-05 0.0 2.905785e-05 0.001 2.905790e-05 0.0 2.905795e-05 0.001 2.905800e-05 0.0 2.905805e-05 0.001 2.905810e-05 0.0 2.905815e-05 0.001 2.905820e-05 0.0 2.905825e-05 0.001 2.905830e-05 0.0 2.905835e-05 0.001 2.905840e-05 0.0 2.905845e-05 0.001 2.905850e-05 0.0 2.905855e-05 0.001 2.905860e-05 0.0 2.905865e-05 0.001 2.905870e-05 0.0 2.905875e-05 0.001 2.905880e-05 0.0 2.905885e-05 0.001 2.905890e-05 0.0 2.905895e-05 0.001 2.905900e-05 0.0 2.905905e-05 0.001 2.905910e-05 0.0 2.905915e-05 0.001 2.905920e-05 0.0 2.905925e-05 0.001 2.905930e-05 0.0 2.905935e-05 0.001 2.905940e-05 0.0 2.905945e-05 0.001 2.905950e-05 0.0 2.905955e-05 0.001 2.905960e-05 0.0 2.905965e-05 0.001 2.905970e-05 0.0 2.905975e-05 0.001 2.905980e-05 0.0 2.905985e-05 0.001 2.905990e-05 0.0 2.905995e-05 0.001 2.906000e-05 0.0 2.906005e-05 0.001 2.906010e-05 0.0 2.906015e-05 0.001 2.906020e-05 0.0 2.906025e-05 0.001 2.906030e-05 0.0 2.906035e-05 0.001 2.906040e-05 0.0 2.906045e-05 0.001 2.906050e-05 0.0 2.906055e-05 0.001 2.906060e-05 0.0 2.906065e-05 0.001 2.906070e-05 0.0 2.906075e-05 0.001 2.906080e-05 0.0 2.906085e-05 0.001 2.906090e-05 0.0 2.906095e-05 0.001 2.906100e-05 0.0 2.906105e-05 0.001 2.906110e-05 0.0 2.906115e-05 0.001 2.906120e-05 0.0 2.906125e-05 0.001 2.906130e-05 0.0 2.906135e-05 0.001 2.906140e-05 0.0 2.906145e-05 0.001 2.906150e-05 0.0 2.906155e-05 0.001 2.906160e-05 0.0 2.906165e-05 0.001 2.906170e-05 0.0 2.906175e-05 0.001 2.906180e-05 0.0 2.906185e-05 0.001 2.906190e-05 0.0 2.906195e-05 0.001 2.906200e-05 0.0 2.906205e-05 0.001 2.906210e-05 0.0 2.906215e-05 0.001 2.906220e-05 0.0 2.906225e-05 0.001 2.906230e-05 0.0 2.906235e-05 0.001 2.906240e-05 0.0 2.906245e-05 0.001 2.906250e-05 0.0 2.906255e-05 0.001 2.906260e-05 0.0 2.906265e-05 0.001 2.906270e-05 0.0 2.906275e-05 0.001 2.906280e-05 0.0 2.906285e-05 0.001 2.906290e-05 0.0 2.906295e-05 0.001 2.906300e-05 0.0 2.906305e-05 0.001 2.906310e-05 0.0 2.906315e-05 0.001 2.906320e-05 0.0 2.906325e-05 0.001 2.906330e-05 0.0 2.906335e-05 0.001 2.906340e-05 0.0 2.906345e-05 0.001 2.906350e-05 0.0 2.906355e-05 0.001 2.906360e-05 0.0 2.906365e-05 0.001 2.906370e-05 0.0 2.906375e-05 0.001 2.906380e-05 0.0 2.906385e-05 0.001 2.906390e-05 0.0 2.906395e-05 0.001 2.906400e-05 0.0 2.906405e-05 0.001 2.906410e-05 0.0 2.906415e-05 0.001 2.906420e-05 0.0 2.906425e-05 0.001 2.906430e-05 0.0 2.906435e-05 0.001 2.906440e-05 0.0 2.906445e-05 0.001 2.906450e-05 0.0 2.906455e-05 0.001 2.906460e-05 0.0 2.906465e-05 0.001 2.906470e-05 0.0 2.906475e-05 0.001 2.906480e-05 0.0 2.906485e-05 0.001 2.906490e-05 0.0 2.906495e-05 0.001 2.906500e-05 0.0 2.906505e-05 0.001 2.906510e-05 0.0 2.906515e-05 0.001 2.906520e-05 0.0 2.906525e-05 0.001 2.906530e-05 0.0 2.906535e-05 0.001 2.906540e-05 0.0 2.906545e-05 0.001 2.906550e-05 0.0 2.906555e-05 0.001 2.906560e-05 0.0 2.906565e-05 0.001 2.906570e-05 0.0 2.906575e-05 0.001 2.906580e-05 0.0 2.906585e-05 0.001 2.906590e-05 0.0 2.906595e-05 0.001 2.906600e-05 0.0 2.906605e-05 0.001 2.906610e-05 0.0 2.906615e-05 0.001 2.906620e-05 0.0 2.906625e-05 0.001 2.906630e-05 0.0 2.906635e-05 0.001 2.906640e-05 0.0 2.906645e-05 0.001 2.906650e-05 0.0 2.906655e-05 0.001 2.906660e-05 0.0 2.906665e-05 0.001 2.906670e-05 0.0 2.906675e-05 0.001 2.906680e-05 0.0 2.906685e-05 0.001 2.906690e-05 0.0 2.906695e-05 0.001 2.906700e-05 0.0 2.906705e-05 0.001 2.906710e-05 0.0 2.906715e-05 0.001 2.906720e-05 0.0 2.906725e-05 0.001 2.906730e-05 0.0 2.906735e-05 0.001 2.906740e-05 0.0 2.906745e-05 0.001 2.906750e-05 0.0 2.906755e-05 0.001 2.906760e-05 0.0 2.906765e-05 0.001 2.906770e-05 0.0 2.906775e-05 0.001 2.906780e-05 0.0 2.906785e-05 0.001 2.906790e-05 0.0 2.906795e-05 0.001 2.906800e-05 0.0 2.906805e-05 0.001 2.906810e-05 0.0 2.906815e-05 0.001 2.906820e-05 0.0 2.906825e-05 0.001 2.906830e-05 0.0 2.906835e-05 0.001 2.906840e-05 0.0 2.906845e-05 0.001 2.906850e-05 0.0 2.906855e-05 0.001 2.906860e-05 0.0 2.906865e-05 0.001 2.906870e-05 0.0 2.906875e-05 0.001 2.906880e-05 0.0 2.906885e-05 0.001 2.906890e-05 0.0 2.906895e-05 0.001 2.906900e-05 0.0 2.906905e-05 0.001 2.906910e-05 0.0 2.906915e-05 0.001 2.906920e-05 0.0 2.906925e-05 0.001 2.906930e-05 0.0 2.906935e-05 0.001 2.906940e-05 0.0 2.906945e-05 0.001 2.906950e-05 0.0 2.906955e-05 0.001 2.906960e-05 0.0 2.906965e-05 0.001 2.906970e-05 0.0 2.906975e-05 0.001 2.906980e-05 0.0 2.906985e-05 0.001 2.906990e-05 0.0 2.906995e-05 0.001 2.907000e-05 0.0 2.907005e-05 0.001 2.907010e-05 0.0 2.907015e-05 0.001 2.907020e-05 0.0 2.907025e-05 0.001 2.907030e-05 0.0 2.907035e-05 0.001 2.907040e-05 0.0 2.907045e-05 0.001 2.907050e-05 0.0 2.907055e-05 0.001 2.907060e-05 0.0 2.907065e-05 0.001 2.907070e-05 0.0 2.907075e-05 0.001 2.907080e-05 0.0 2.907085e-05 0.001 2.907090e-05 0.0 2.907095e-05 0.001 2.907100e-05 0.0 2.907105e-05 0.001 2.907110e-05 0.0 2.907115e-05 0.001 2.907120e-05 0.0 2.907125e-05 0.001 2.907130e-05 0.0 2.907135e-05 0.001 2.907140e-05 0.0 2.907145e-05 0.001 2.907150e-05 0.0 2.907155e-05 0.001 2.907160e-05 0.0 2.907165e-05 0.001 2.907170e-05 0.0 2.907175e-05 0.001 2.907180e-05 0.0 2.907185e-05 0.001 2.907190e-05 0.0 2.907195e-05 0.001 2.907200e-05 0.0 2.907205e-05 0.001 2.907210e-05 0.0 2.907215e-05 0.001 2.907220e-05 0.0 2.907225e-05 0.001 2.907230e-05 0.0 2.907235e-05 0.001 2.907240e-05 0.0 2.907245e-05 0.001 2.907250e-05 0.0 2.907255e-05 0.001 2.907260e-05 0.0 2.907265e-05 0.001 2.907270e-05 0.0 2.907275e-05 0.001 2.907280e-05 0.0 2.907285e-05 0.001 2.907290e-05 0.0 2.907295e-05 0.001 2.907300e-05 0.0 2.907305e-05 0.001 2.907310e-05 0.0 2.907315e-05 0.001 2.907320e-05 0.0 2.907325e-05 0.001 2.907330e-05 0.0 2.907335e-05 0.001 2.907340e-05 0.0 2.907345e-05 0.001 2.907350e-05 0.0 2.907355e-05 0.001 2.907360e-05 0.0 2.907365e-05 0.001 2.907370e-05 0.0 2.907375e-05 0.001 2.907380e-05 0.0 2.907385e-05 0.001 2.907390e-05 0.0 2.907395e-05 0.001 2.907400e-05 0.0 2.907405e-05 0.001 2.907410e-05 0.0 2.907415e-05 0.001 2.907420e-05 0.0 2.907425e-05 0.001 2.907430e-05 0.0 2.907435e-05 0.001 2.907440e-05 0.0 2.907445e-05 0.001 2.907450e-05 0.0 2.907455e-05 0.001 2.907460e-05 0.0 2.907465e-05 0.001 2.907470e-05 0.0 2.907475e-05 0.001 2.907480e-05 0.0 2.907485e-05 0.001 2.907490e-05 0.0 2.907495e-05 0.001 2.907500e-05 0.0 2.907505e-05 0.001 2.907510e-05 0.0 2.907515e-05 0.001 2.907520e-05 0.0 2.907525e-05 0.001 2.907530e-05 0.0 2.907535e-05 0.001 2.907540e-05 0.0 2.907545e-05 0.001 2.907550e-05 0.0 2.907555e-05 0.001 2.907560e-05 0.0 2.907565e-05 0.001 2.907570e-05 0.0 2.907575e-05 0.001 2.907580e-05 0.0 2.907585e-05 0.001 2.907590e-05 0.0 2.907595e-05 0.001 2.907600e-05 0.0 2.907605e-05 0.001 2.907610e-05 0.0 2.907615e-05 0.001 2.907620e-05 0.0 2.907625e-05 0.001 2.907630e-05 0.0 2.907635e-05 0.001 2.907640e-05 0.0 2.907645e-05 0.001 2.907650e-05 0.0 2.907655e-05 0.001 2.907660e-05 0.0 2.907665e-05 0.001 2.907670e-05 0.0 2.907675e-05 0.001 2.907680e-05 0.0 2.907685e-05 0.001 2.907690e-05 0.0 2.907695e-05 0.001 2.907700e-05 0.0 2.907705e-05 0.001 2.907710e-05 0.0 2.907715e-05 0.001 2.907720e-05 0.0 2.907725e-05 0.001 2.907730e-05 0.0 2.907735e-05 0.001 2.907740e-05 0.0 2.907745e-05 0.001 2.907750e-05 0.0 2.907755e-05 0.001 2.907760e-05 0.0 2.907765e-05 0.001 2.907770e-05 0.0 2.907775e-05 0.001 2.907780e-05 0.0 2.907785e-05 0.001 2.907790e-05 0.0 2.907795e-05 0.001 2.907800e-05 0.0 2.907805e-05 0.001 2.907810e-05 0.0 2.907815e-05 0.001 2.907820e-05 0.0 2.907825e-05 0.001 2.907830e-05 0.0 2.907835e-05 0.001 2.907840e-05 0.0 2.907845e-05 0.001 2.907850e-05 0.0 2.907855e-05 0.001 2.907860e-05 0.0 2.907865e-05 0.001 2.907870e-05 0.0 2.907875e-05 0.001 2.907880e-05 0.0 2.907885e-05 0.001 2.907890e-05 0.0 2.907895e-05 0.001 2.907900e-05 0.0 2.907905e-05 0.001 2.907910e-05 0.0 2.907915e-05 0.001 2.907920e-05 0.0 2.907925e-05 0.001 2.907930e-05 0.0 2.907935e-05 0.001 2.907940e-05 0.0 2.907945e-05 0.001 2.907950e-05 0.0 2.907955e-05 0.001 2.907960e-05 0.0 2.907965e-05 0.001 2.907970e-05 0.0 2.907975e-05 0.001 2.907980e-05 0.0 2.907985e-05 0.001 2.907990e-05 0.0 2.907995e-05 0.001 2.908000e-05 0.0 2.908005e-05 0.001 2.908010e-05 0.0 2.908015e-05 0.001 2.908020e-05 0.0 2.908025e-05 0.001 2.908030e-05 0.0 2.908035e-05 0.001 2.908040e-05 0.0 2.908045e-05 0.001 2.908050e-05 0.0 2.908055e-05 0.001 2.908060e-05 0.0 2.908065e-05 0.001 2.908070e-05 0.0 2.908075e-05 0.001 2.908080e-05 0.0 2.908085e-05 0.001 2.908090e-05 0.0 2.908095e-05 0.001 2.908100e-05 0.0 2.908105e-05 0.001 2.908110e-05 0.0 2.908115e-05 0.001 2.908120e-05 0.0 2.908125e-05 0.001 2.908130e-05 0.0 2.908135e-05 0.001 2.908140e-05 0.0 2.908145e-05 0.001 2.908150e-05 0.0 2.908155e-05 0.001 2.908160e-05 0.0 2.908165e-05 0.001 2.908170e-05 0.0 2.908175e-05 0.001 2.908180e-05 0.0 2.908185e-05 0.001 2.908190e-05 0.0 2.908195e-05 0.001 2.908200e-05 0.0 2.908205e-05 0.001 2.908210e-05 0.0 2.908215e-05 0.001 2.908220e-05 0.0 2.908225e-05 0.001 2.908230e-05 0.0 2.908235e-05 0.001 2.908240e-05 0.0 2.908245e-05 0.001 2.908250e-05 0.0 2.908255e-05 0.001 2.908260e-05 0.0 2.908265e-05 0.001 2.908270e-05 0.0 2.908275e-05 0.001 2.908280e-05 0.0 2.908285e-05 0.001 2.908290e-05 0.0 2.908295e-05 0.001 2.908300e-05 0.0 2.908305e-05 0.001 2.908310e-05 0.0 2.908315e-05 0.001 2.908320e-05 0.0 2.908325e-05 0.001 2.908330e-05 0.0 2.908335e-05 0.001 2.908340e-05 0.0 2.908345e-05 0.001 2.908350e-05 0.0 2.908355e-05 0.001 2.908360e-05 0.0 2.908365e-05 0.001 2.908370e-05 0.0 2.908375e-05 0.001 2.908380e-05 0.0 2.908385e-05 0.001 2.908390e-05 0.0 2.908395e-05 0.001 2.908400e-05 0.0 2.908405e-05 0.001 2.908410e-05 0.0 2.908415e-05 0.001 2.908420e-05 0.0 2.908425e-05 0.001 2.908430e-05 0.0 2.908435e-05 0.001 2.908440e-05 0.0 2.908445e-05 0.001 2.908450e-05 0.0 2.908455e-05 0.001 2.908460e-05 0.0 2.908465e-05 0.001 2.908470e-05 0.0 2.908475e-05 0.001 2.908480e-05 0.0 2.908485e-05 0.001 2.908490e-05 0.0 2.908495e-05 0.001 2.908500e-05 0.0 2.908505e-05 0.001 2.908510e-05 0.0 2.908515e-05 0.001 2.908520e-05 0.0 2.908525e-05 0.001 2.908530e-05 0.0 2.908535e-05 0.001 2.908540e-05 0.0 2.908545e-05 0.001 2.908550e-05 0.0 2.908555e-05 0.001 2.908560e-05 0.0 2.908565e-05 0.001 2.908570e-05 0.0 2.908575e-05 0.001 2.908580e-05 0.0 2.908585e-05 0.001 2.908590e-05 0.0 2.908595e-05 0.001 2.908600e-05 0.0 2.908605e-05 0.001 2.908610e-05 0.0 2.908615e-05 0.001 2.908620e-05 0.0 2.908625e-05 0.001 2.908630e-05 0.0 2.908635e-05 0.001 2.908640e-05 0.0 2.908645e-05 0.001 2.908650e-05 0.0 2.908655e-05 0.001 2.908660e-05 0.0 2.908665e-05 0.001 2.908670e-05 0.0 2.908675e-05 0.001 2.908680e-05 0.0 2.908685e-05 0.001 2.908690e-05 0.0 2.908695e-05 0.001 2.908700e-05 0.0 2.908705e-05 0.001 2.908710e-05 0.0 2.908715e-05 0.001 2.908720e-05 0.0 2.908725e-05 0.001 2.908730e-05 0.0 2.908735e-05 0.001 2.908740e-05 0.0 2.908745e-05 0.001 2.908750e-05 0.0 2.908755e-05 0.001 2.908760e-05 0.0 2.908765e-05 0.001 2.908770e-05 0.0 2.908775e-05 0.001 2.908780e-05 0.0 2.908785e-05 0.001 2.908790e-05 0.0 2.908795e-05 0.001 2.908800e-05 0.0 2.908805e-05 0.001 2.908810e-05 0.0 2.908815e-05 0.001 2.908820e-05 0.0 2.908825e-05 0.001 2.908830e-05 0.0 2.908835e-05 0.001 2.908840e-05 0.0 2.908845e-05 0.001 2.908850e-05 0.0 2.908855e-05 0.001 2.908860e-05 0.0 2.908865e-05 0.001 2.908870e-05 0.0 2.908875e-05 0.001 2.908880e-05 0.0 2.908885e-05 0.001 2.908890e-05 0.0 2.908895e-05 0.001 2.908900e-05 0.0 2.908905e-05 0.001 2.908910e-05 0.0 2.908915e-05 0.001 2.908920e-05 0.0 2.908925e-05 0.001 2.908930e-05 0.0 2.908935e-05 0.001 2.908940e-05 0.0 2.908945e-05 0.001 2.908950e-05 0.0 2.908955e-05 0.001 2.908960e-05 0.0 2.908965e-05 0.001 2.908970e-05 0.0 2.908975e-05 0.001 2.908980e-05 0.0 2.908985e-05 0.001 2.908990e-05 0.0 2.908995e-05 0.001 2.909000e-05 0.0 2.909005e-05 0.001 2.909010e-05 0.0 2.909015e-05 0.001 2.909020e-05 0.0 2.909025e-05 0.001 2.909030e-05 0.0 2.909035e-05 0.001 2.909040e-05 0.0 2.909045e-05 0.001 2.909050e-05 0.0 2.909055e-05 0.001 2.909060e-05 0.0 2.909065e-05 0.001 2.909070e-05 0.0 2.909075e-05 0.001 2.909080e-05 0.0 2.909085e-05 0.001 2.909090e-05 0.0 2.909095e-05 0.001 2.909100e-05 0.0 2.909105e-05 0.001 2.909110e-05 0.0 2.909115e-05 0.001 2.909120e-05 0.0 2.909125e-05 0.001 2.909130e-05 0.0 2.909135e-05 0.001 2.909140e-05 0.0 2.909145e-05 0.001 2.909150e-05 0.0 2.909155e-05 0.001 2.909160e-05 0.0 2.909165e-05 0.001 2.909170e-05 0.0 2.909175e-05 0.001 2.909180e-05 0.0 2.909185e-05 0.001 2.909190e-05 0.0 2.909195e-05 0.001 2.909200e-05 0.0 2.909205e-05 0.001 2.909210e-05 0.0 2.909215e-05 0.001 2.909220e-05 0.0 2.909225e-05 0.001 2.909230e-05 0.0 2.909235e-05 0.001 2.909240e-05 0.0 2.909245e-05 0.001 2.909250e-05 0.0 2.909255e-05 0.001 2.909260e-05 0.0 2.909265e-05 0.001 2.909270e-05 0.0 2.909275e-05 0.001 2.909280e-05 0.0 2.909285e-05 0.001 2.909290e-05 0.0 2.909295e-05 0.001 2.909300e-05 0.0 2.909305e-05 0.001 2.909310e-05 0.0 2.909315e-05 0.001 2.909320e-05 0.0 2.909325e-05 0.001 2.909330e-05 0.0 2.909335e-05 0.001 2.909340e-05 0.0 2.909345e-05 0.001 2.909350e-05 0.0 2.909355e-05 0.001 2.909360e-05 0.0 2.909365e-05 0.001 2.909370e-05 0.0 2.909375e-05 0.001 2.909380e-05 0.0 2.909385e-05 0.001 2.909390e-05 0.0 2.909395e-05 0.001 2.909400e-05 0.0 2.909405e-05 0.001 2.909410e-05 0.0 2.909415e-05 0.001 2.909420e-05 0.0 2.909425e-05 0.001 2.909430e-05 0.0 2.909435e-05 0.001 2.909440e-05 0.0 2.909445e-05 0.001 2.909450e-05 0.0 2.909455e-05 0.001 2.909460e-05 0.0 2.909465e-05 0.001 2.909470e-05 0.0 2.909475e-05 0.001 2.909480e-05 0.0 2.909485e-05 0.001 2.909490e-05 0.0 2.909495e-05 0.001 2.909500e-05 0.0 2.909505e-05 0.001 2.909510e-05 0.0 2.909515e-05 0.001 2.909520e-05 0.0 2.909525e-05 0.001 2.909530e-05 0.0 2.909535e-05 0.001 2.909540e-05 0.0 2.909545e-05 0.001 2.909550e-05 0.0 2.909555e-05 0.001 2.909560e-05 0.0 2.909565e-05 0.001 2.909570e-05 0.0 2.909575e-05 0.001 2.909580e-05 0.0 2.909585e-05 0.001 2.909590e-05 0.0 2.909595e-05 0.001 2.909600e-05 0.0 2.909605e-05 0.001 2.909610e-05 0.0 2.909615e-05 0.001 2.909620e-05 0.0 2.909625e-05 0.001 2.909630e-05 0.0 2.909635e-05 0.001 2.909640e-05 0.0 2.909645e-05 0.001 2.909650e-05 0.0 2.909655e-05 0.001 2.909660e-05 0.0 2.909665e-05 0.001 2.909670e-05 0.0 2.909675e-05 0.001 2.909680e-05 0.0 2.909685e-05 0.001 2.909690e-05 0.0 2.909695e-05 0.001 2.909700e-05 0.0 2.909705e-05 0.001 2.909710e-05 0.0 2.909715e-05 0.001 2.909720e-05 0.0 2.909725e-05 0.001 2.909730e-05 0.0 2.909735e-05 0.001 2.909740e-05 0.0 2.909745e-05 0.001 2.909750e-05 0.0 2.909755e-05 0.001 2.909760e-05 0.0 2.909765e-05 0.001 2.909770e-05 0.0 2.909775e-05 0.001 2.909780e-05 0.0 2.909785e-05 0.001 2.909790e-05 0.0 2.909795e-05 0.001 2.909800e-05 0.0 2.909805e-05 0.001 2.909810e-05 0.0 2.909815e-05 0.001 2.909820e-05 0.0 2.909825e-05 0.001 2.909830e-05 0.0 2.909835e-05 0.001 2.909840e-05 0.0 2.909845e-05 0.001 2.909850e-05 0.0 2.909855e-05 0.001 2.909860e-05 0.0 2.909865e-05 0.001 2.909870e-05 0.0 2.909875e-05 0.001 2.909880e-05 0.0 2.909885e-05 0.001 2.909890e-05 0.0 2.909895e-05 0.001 2.909900e-05 0.0 2.909905e-05 0.001 2.909910e-05 0.0 2.909915e-05 0.001 2.909920e-05 0.0 2.909925e-05 0.001 2.909930e-05 0.0 2.909935e-05 0.001 2.909940e-05 0.0 2.909945e-05 0.001 2.909950e-05 0.0 2.909955e-05 0.001 2.909960e-05 0.0 2.909965e-05 0.001 2.909970e-05 0.0 2.909975e-05 0.001 2.909980e-05 0.0 2.909985e-05 0.001 2.909990e-05 0.0 2.909995e-05 0.001 2.910000e-05 0.0 2.910005e-05 0.001 2.910010e-05 0.0 2.910015e-05 0.001 2.910020e-05 0.0 2.910025e-05 0.001 2.910030e-05 0.0 2.910035e-05 0.001 2.910040e-05 0.0 2.910045e-05 0.001 2.910050e-05 0.0 2.910055e-05 0.001 2.910060e-05 0.0 2.910065e-05 0.001 2.910070e-05 0.0 2.910075e-05 0.001 2.910080e-05 0.0 2.910085e-05 0.001 2.910090e-05 0.0 2.910095e-05 0.001 2.910100e-05 0.0 2.910105e-05 0.001 2.910110e-05 0.0 2.910115e-05 0.001 2.910120e-05 0.0 2.910125e-05 0.001 2.910130e-05 0.0 2.910135e-05 0.001 2.910140e-05 0.0 2.910145e-05 0.001 2.910150e-05 0.0 2.910155e-05 0.001 2.910160e-05 0.0 2.910165e-05 0.001 2.910170e-05 0.0 2.910175e-05 0.001 2.910180e-05 0.0 2.910185e-05 0.001 2.910190e-05 0.0 2.910195e-05 0.001 2.910200e-05 0.0 2.910205e-05 0.001 2.910210e-05 0.0 2.910215e-05 0.001 2.910220e-05 0.0 2.910225e-05 0.001 2.910230e-05 0.0 2.910235e-05 0.001 2.910240e-05 0.0 2.910245e-05 0.001 2.910250e-05 0.0 2.910255e-05 0.001 2.910260e-05 0.0 2.910265e-05 0.001 2.910270e-05 0.0 2.910275e-05 0.001 2.910280e-05 0.0 2.910285e-05 0.001 2.910290e-05 0.0 2.910295e-05 0.001 2.910300e-05 0.0 2.910305e-05 0.001 2.910310e-05 0.0 2.910315e-05 0.001 2.910320e-05 0.0 2.910325e-05 0.001 2.910330e-05 0.0 2.910335e-05 0.001 2.910340e-05 0.0 2.910345e-05 0.001 2.910350e-05 0.0 2.910355e-05 0.001 2.910360e-05 0.0 2.910365e-05 0.001 2.910370e-05 0.0 2.910375e-05 0.001 2.910380e-05 0.0 2.910385e-05 0.001 2.910390e-05 0.0 2.910395e-05 0.001 2.910400e-05 0.0 2.910405e-05 0.001 2.910410e-05 0.0 2.910415e-05 0.001 2.910420e-05 0.0 2.910425e-05 0.001 2.910430e-05 0.0 2.910435e-05 0.001 2.910440e-05 0.0 2.910445e-05 0.001 2.910450e-05 0.0 2.910455e-05 0.001 2.910460e-05 0.0 2.910465e-05 0.001 2.910470e-05 0.0 2.910475e-05 0.001 2.910480e-05 0.0 2.910485e-05 0.001 2.910490e-05 0.0 2.910495e-05 0.001 2.910500e-05 0.0 2.910505e-05 0.001 2.910510e-05 0.0 2.910515e-05 0.001 2.910520e-05 0.0 2.910525e-05 0.001 2.910530e-05 0.0 2.910535e-05 0.001 2.910540e-05 0.0 2.910545e-05 0.001 2.910550e-05 0.0 2.910555e-05 0.001 2.910560e-05 0.0 2.910565e-05 0.001 2.910570e-05 0.0 2.910575e-05 0.001 2.910580e-05 0.0 2.910585e-05 0.001 2.910590e-05 0.0 2.910595e-05 0.001 2.910600e-05 0.0 2.910605e-05 0.001 2.910610e-05 0.0 2.910615e-05 0.001 2.910620e-05 0.0 2.910625e-05 0.001 2.910630e-05 0.0 2.910635e-05 0.001 2.910640e-05 0.0 2.910645e-05 0.001 2.910650e-05 0.0 2.910655e-05 0.001 2.910660e-05 0.0 2.910665e-05 0.001 2.910670e-05 0.0 2.910675e-05 0.001 2.910680e-05 0.0 2.910685e-05 0.001 2.910690e-05 0.0 2.910695e-05 0.001 2.910700e-05 0.0 2.910705e-05 0.001 2.910710e-05 0.0 2.910715e-05 0.001 2.910720e-05 0.0 2.910725e-05 0.001 2.910730e-05 0.0 2.910735e-05 0.001 2.910740e-05 0.0 2.910745e-05 0.001 2.910750e-05 0.0 2.910755e-05 0.001 2.910760e-05 0.0 2.910765e-05 0.001 2.910770e-05 0.0 2.910775e-05 0.001 2.910780e-05 0.0 2.910785e-05 0.001 2.910790e-05 0.0 2.910795e-05 0.001 2.910800e-05 0.0 2.910805e-05 0.001 2.910810e-05 0.0 2.910815e-05 0.001 2.910820e-05 0.0 2.910825e-05 0.001 2.910830e-05 0.0 2.910835e-05 0.001 2.910840e-05 0.0 2.910845e-05 0.001 2.910850e-05 0.0 2.910855e-05 0.001 2.910860e-05 0.0 2.910865e-05 0.001 2.910870e-05 0.0 2.910875e-05 0.001 2.910880e-05 0.0 2.910885e-05 0.001 2.910890e-05 0.0 2.910895e-05 0.001 2.910900e-05 0.0 2.910905e-05 0.001 2.910910e-05 0.0 2.910915e-05 0.001 2.910920e-05 0.0 2.910925e-05 0.001 2.910930e-05 0.0 2.910935e-05 0.001 2.910940e-05 0.0 2.910945e-05 0.001 2.910950e-05 0.0 2.910955e-05 0.001 2.910960e-05 0.0 2.910965e-05 0.001 2.910970e-05 0.0 2.910975e-05 0.001 2.910980e-05 0.0 2.910985e-05 0.001 2.910990e-05 0.0 2.910995e-05 0.001 2.911000e-05 0.0 2.911005e-05 0.001 2.911010e-05 0.0 2.911015e-05 0.001 2.911020e-05 0.0 2.911025e-05 0.001 2.911030e-05 0.0 2.911035e-05 0.001 2.911040e-05 0.0 2.911045e-05 0.001 2.911050e-05 0.0 2.911055e-05 0.001 2.911060e-05 0.0 2.911065e-05 0.001 2.911070e-05 0.0 2.911075e-05 0.001 2.911080e-05 0.0 2.911085e-05 0.001 2.911090e-05 0.0 2.911095e-05 0.001 2.911100e-05 0.0 2.911105e-05 0.001 2.911110e-05 0.0 2.911115e-05 0.001 2.911120e-05 0.0 2.911125e-05 0.001 2.911130e-05 0.0 2.911135e-05 0.001 2.911140e-05 0.0 2.911145e-05 0.001 2.911150e-05 0.0 2.911155e-05 0.001 2.911160e-05 0.0 2.911165e-05 0.001 2.911170e-05 0.0 2.911175e-05 0.001 2.911180e-05 0.0 2.911185e-05 0.001 2.911190e-05 0.0 2.911195e-05 0.001 2.911200e-05 0.0 2.911205e-05 0.001 2.911210e-05 0.0 2.911215e-05 0.001 2.911220e-05 0.0 2.911225e-05 0.001 2.911230e-05 0.0 2.911235e-05 0.001 2.911240e-05 0.0 2.911245e-05 0.001 2.911250e-05 0.0 2.911255e-05 0.001 2.911260e-05 0.0 2.911265e-05 0.001 2.911270e-05 0.0 2.911275e-05 0.001 2.911280e-05 0.0 2.911285e-05 0.001 2.911290e-05 0.0 2.911295e-05 0.001 2.911300e-05 0.0 2.911305e-05 0.001 2.911310e-05 0.0 2.911315e-05 0.001 2.911320e-05 0.0 2.911325e-05 0.001 2.911330e-05 0.0 2.911335e-05 0.001 2.911340e-05 0.0 2.911345e-05 0.001 2.911350e-05 0.0 2.911355e-05 0.001 2.911360e-05 0.0 2.911365e-05 0.001 2.911370e-05 0.0 2.911375e-05 0.001 2.911380e-05 0.0 2.911385e-05 0.001 2.911390e-05 0.0 2.911395e-05 0.001 2.911400e-05 0.0 2.911405e-05 0.001 2.911410e-05 0.0 2.911415e-05 0.001 2.911420e-05 0.0 2.911425e-05 0.001 2.911430e-05 0.0 2.911435e-05 0.001 2.911440e-05 0.0 2.911445e-05 0.001 2.911450e-05 0.0 2.911455e-05 0.001 2.911460e-05 0.0 2.911465e-05 0.001 2.911470e-05 0.0 2.911475e-05 0.001 2.911480e-05 0.0 2.911485e-05 0.001 2.911490e-05 0.0 2.911495e-05 0.001 2.911500e-05 0.0 2.911505e-05 0.001 2.911510e-05 0.0 2.911515e-05 0.001 2.911520e-05 0.0 2.911525e-05 0.001 2.911530e-05 0.0 2.911535e-05 0.001 2.911540e-05 0.0 2.911545e-05 0.001 2.911550e-05 0.0 2.911555e-05 0.001 2.911560e-05 0.0 2.911565e-05 0.001 2.911570e-05 0.0 2.911575e-05 0.001 2.911580e-05 0.0 2.911585e-05 0.001 2.911590e-05 0.0 2.911595e-05 0.001 2.911600e-05 0.0 2.911605e-05 0.001 2.911610e-05 0.0 2.911615e-05 0.001 2.911620e-05 0.0 2.911625e-05 0.001 2.911630e-05 0.0 2.911635e-05 0.001 2.911640e-05 0.0 2.911645e-05 0.001 2.911650e-05 0.0 2.911655e-05 0.001 2.911660e-05 0.0 2.911665e-05 0.001 2.911670e-05 0.0 2.911675e-05 0.001 2.911680e-05 0.0 2.911685e-05 0.001 2.911690e-05 0.0 2.911695e-05 0.001 2.911700e-05 0.0 2.911705e-05 0.001 2.911710e-05 0.0 2.911715e-05 0.001 2.911720e-05 0.0 2.911725e-05 0.001 2.911730e-05 0.0 2.911735e-05 0.001 2.911740e-05 0.0 2.911745e-05 0.001 2.911750e-05 0.0 2.911755e-05 0.001 2.911760e-05 0.0 2.911765e-05 0.001 2.911770e-05 0.0 2.911775e-05 0.001 2.911780e-05 0.0 2.911785e-05 0.001 2.911790e-05 0.0 2.911795e-05 0.001 2.911800e-05 0.0 2.911805e-05 0.001 2.911810e-05 0.0 2.911815e-05 0.001 2.911820e-05 0.0 2.911825e-05 0.001 2.911830e-05 0.0 2.911835e-05 0.001 2.911840e-05 0.0 2.911845e-05 0.001 2.911850e-05 0.0 2.911855e-05 0.001 2.911860e-05 0.0 2.911865e-05 0.001 2.911870e-05 0.0 2.911875e-05 0.001 2.911880e-05 0.0 2.911885e-05 0.001 2.911890e-05 0.0 2.911895e-05 0.001 2.911900e-05 0.0 2.911905e-05 0.001 2.911910e-05 0.0 2.911915e-05 0.001 2.911920e-05 0.0 2.911925e-05 0.001 2.911930e-05 0.0 2.911935e-05 0.001 2.911940e-05 0.0 2.911945e-05 0.001 2.911950e-05 0.0 2.911955e-05 0.001 2.911960e-05 0.0 2.911965e-05 0.001 2.911970e-05 0.0 2.911975e-05 0.001 2.911980e-05 0.0 2.911985e-05 0.001 2.911990e-05 0.0 2.911995e-05 0.001 2.912000e-05 0.0 2.912005e-05 0.001 2.912010e-05 0.0 2.912015e-05 0.001 2.912020e-05 0.0 2.912025e-05 0.001 2.912030e-05 0.0 2.912035e-05 0.001 2.912040e-05 0.0 2.912045e-05 0.001 2.912050e-05 0.0 2.912055e-05 0.001 2.912060e-05 0.0 2.912065e-05 0.001 2.912070e-05 0.0 2.912075e-05 0.001 2.912080e-05 0.0 2.912085e-05 0.001 2.912090e-05 0.0 2.912095e-05 0.001 2.912100e-05 0.0 2.912105e-05 0.001 2.912110e-05 0.0 2.912115e-05 0.001 2.912120e-05 0.0 2.912125e-05 0.001 2.912130e-05 0.0 2.912135e-05 0.001 2.912140e-05 0.0 2.912145e-05 0.001 2.912150e-05 0.0 2.912155e-05 0.001 2.912160e-05 0.0 2.912165e-05 0.001 2.912170e-05 0.0 2.912175e-05 0.001 2.912180e-05 0.0 2.912185e-05 0.001 2.912190e-05 0.0 2.912195e-05 0.001 2.912200e-05 0.0 2.912205e-05 0.001 2.912210e-05 0.0 2.912215e-05 0.001 2.912220e-05 0.0 2.912225e-05 0.001 2.912230e-05 0.0 2.912235e-05 0.001 2.912240e-05 0.0 2.912245e-05 0.001 2.912250e-05 0.0 2.912255e-05 0.001 2.912260e-05 0.0 2.912265e-05 0.001 2.912270e-05 0.0 2.912275e-05 0.001 2.912280e-05 0.0 2.912285e-05 0.001 2.912290e-05 0.0 2.912295e-05 0.001 2.912300e-05 0.0 2.912305e-05 0.001 2.912310e-05 0.0 2.912315e-05 0.001 2.912320e-05 0.0 2.912325e-05 0.001 2.912330e-05 0.0 2.912335e-05 0.001 2.912340e-05 0.0 2.912345e-05 0.001 2.912350e-05 0.0 2.912355e-05 0.001 2.912360e-05 0.0 2.912365e-05 0.001 2.912370e-05 0.0 2.912375e-05 0.001 2.912380e-05 0.0 2.912385e-05 0.001 2.912390e-05 0.0 2.912395e-05 0.001 2.912400e-05 0.0 2.912405e-05 0.001 2.912410e-05 0.0 2.912415e-05 0.001 2.912420e-05 0.0 2.912425e-05 0.001 2.912430e-05 0.0 2.912435e-05 0.001 2.912440e-05 0.0 2.912445e-05 0.001 2.912450e-05 0.0 2.912455e-05 0.001 2.912460e-05 0.0 2.912465e-05 0.001 2.912470e-05 0.0 2.912475e-05 0.001 2.912480e-05 0.0 2.912485e-05 0.001 2.912490e-05 0.0 2.912495e-05 0.001 2.912500e-05 0.0 2.912505e-05 0.001 2.912510e-05 0.0 2.912515e-05 0.001 2.912520e-05 0.0 2.912525e-05 0.001 2.912530e-05 0.0 2.912535e-05 0.001 2.912540e-05 0.0 2.912545e-05 0.001 2.912550e-05 0.0 2.912555e-05 0.001 2.912560e-05 0.0 2.912565e-05 0.001 2.912570e-05 0.0 2.912575e-05 0.001 2.912580e-05 0.0 2.912585e-05 0.001 2.912590e-05 0.0 2.912595e-05 0.001 2.912600e-05 0.0 2.912605e-05 0.001 2.912610e-05 0.0 2.912615e-05 0.001 2.912620e-05 0.0 2.912625e-05 0.001 2.912630e-05 0.0 2.912635e-05 0.001 2.912640e-05 0.0 2.912645e-05 0.001 2.912650e-05 0.0 2.912655e-05 0.001 2.912660e-05 0.0 2.912665e-05 0.001 2.912670e-05 0.0 2.912675e-05 0.001 2.912680e-05 0.0 2.912685e-05 0.001 2.912690e-05 0.0 2.912695e-05 0.001 2.912700e-05 0.0 2.912705e-05 0.001 2.912710e-05 0.0 2.912715e-05 0.001 2.912720e-05 0.0 2.912725e-05 0.001 2.912730e-05 0.0 2.912735e-05 0.001 2.912740e-05 0.0 2.912745e-05 0.001 2.912750e-05 0.0 2.912755e-05 0.001 2.912760e-05 0.0 2.912765e-05 0.001 2.912770e-05 0.0 2.912775e-05 0.001 2.912780e-05 0.0 2.912785e-05 0.001 2.912790e-05 0.0 2.912795e-05 0.001 2.912800e-05 0.0 2.912805e-05 0.001 2.912810e-05 0.0 2.912815e-05 0.001 2.912820e-05 0.0 2.912825e-05 0.001 2.912830e-05 0.0 2.912835e-05 0.001 2.912840e-05 0.0 2.912845e-05 0.001 2.912850e-05 0.0 2.912855e-05 0.001 2.912860e-05 0.0 2.912865e-05 0.001 2.912870e-05 0.0 2.912875e-05 0.001 2.912880e-05 0.0 2.912885e-05 0.001 2.912890e-05 0.0 2.912895e-05 0.001 2.912900e-05 0.0 2.912905e-05 0.001 2.912910e-05 0.0 2.912915e-05 0.001 2.912920e-05 0.0 2.912925e-05 0.001 2.912930e-05 0.0 2.912935e-05 0.001 2.912940e-05 0.0 2.912945e-05 0.001 2.912950e-05 0.0 2.912955e-05 0.001 2.912960e-05 0.0 2.912965e-05 0.001 2.912970e-05 0.0 2.912975e-05 0.001 2.912980e-05 0.0 2.912985e-05 0.001 2.912990e-05 0.0 2.912995e-05 0.001 2.913000e-05 0.0 2.913005e-05 0.001 2.913010e-05 0.0 2.913015e-05 0.001 2.913020e-05 0.0 2.913025e-05 0.001 2.913030e-05 0.0 2.913035e-05 0.001 2.913040e-05 0.0 2.913045e-05 0.001 2.913050e-05 0.0 2.913055e-05 0.001 2.913060e-05 0.0 2.913065e-05 0.001 2.913070e-05 0.0 2.913075e-05 0.001 2.913080e-05 0.0 2.913085e-05 0.001 2.913090e-05 0.0 2.913095e-05 0.001 2.913100e-05 0.0 2.913105e-05 0.001 2.913110e-05 0.0 2.913115e-05 0.001 2.913120e-05 0.0 2.913125e-05 0.001 2.913130e-05 0.0 2.913135e-05 0.001 2.913140e-05 0.0 2.913145e-05 0.001 2.913150e-05 0.0 2.913155e-05 0.001 2.913160e-05 0.0 2.913165e-05 0.001 2.913170e-05 0.0 2.913175e-05 0.001 2.913180e-05 0.0 2.913185e-05 0.001 2.913190e-05 0.0 2.913195e-05 0.001 2.913200e-05 0.0 2.913205e-05 0.001 2.913210e-05 0.0 2.913215e-05 0.001 2.913220e-05 0.0 2.913225e-05 0.001 2.913230e-05 0.0 2.913235e-05 0.001 2.913240e-05 0.0 2.913245e-05 0.001 2.913250e-05 0.0 2.913255e-05 0.001 2.913260e-05 0.0 2.913265e-05 0.001 2.913270e-05 0.0 2.913275e-05 0.001 2.913280e-05 0.0 2.913285e-05 0.001 2.913290e-05 0.0 2.913295e-05 0.001 2.913300e-05 0.0 2.913305e-05 0.001 2.913310e-05 0.0 2.913315e-05 0.001 2.913320e-05 0.0 2.913325e-05 0.001 2.913330e-05 0.0 2.913335e-05 0.001 2.913340e-05 0.0 2.913345e-05 0.001 2.913350e-05 0.0 2.913355e-05 0.001 2.913360e-05 0.0 2.913365e-05 0.001 2.913370e-05 0.0 2.913375e-05 0.001 2.913380e-05 0.0 2.913385e-05 0.001 2.913390e-05 0.0 2.913395e-05 0.001 2.913400e-05 0.0 2.913405e-05 0.001 2.913410e-05 0.0 2.913415e-05 0.001 2.913420e-05 0.0 2.913425e-05 0.001 2.913430e-05 0.0 2.913435e-05 0.001 2.913440e-05 0.0 2.913445e-05 0.001 2.913450e-05 0.0 2.913455e-05 0.001 2.913460e-05 0.0 2.913465e-05 0.001 2.913470e-05 0.0 2.913475e-05 0.001 2.913480e-05 0.0 2.913485e-05 0.001 2.913490e-05 0.0 2.913495e-05 0.001 2.913500e-05 0.0 2.913505e-05 0.001 2.913510e-05 0.0 2.913515e-05 0.001 2.913520e-05 0.0 2.913525e-05 0.001 2.913530e-05 0.0 2.913535e-05 0.001 2.913540e-05 0.0 2.913545e-05 0.001 2.913550e-05 0.0 2.913555e-05 0.001 2.913560e-05 0.0 2.913565e-05 0.001 2.913570e-05 0.0 2.913575e-05 0.001 2.913580e-05 0.0 2.913585e-05 0.001 2.913590e-05 0.0 2.913595e-05 0.001 2.913600e-05 0.0 2.913605e-05 0.001 2.913610e-05 0.0 2.913615e-05 0.001 2.913620e-05 0.0 2.913625e-05 0.001 2.913630e-05 0.0 2.913635e-05 0.001 2.913640e-05 0.0 2.913645e-05 0.001 2.913650e-05 0.0 2.913655e-05 0.001 2.913660e-05 0.0 2.913665e-05 0.001 2.913670e-05 0.0 2.913675e-05 0.001 2.913680e-05 0.0 2.913685e-05 0.001 2.913690e-05 0.0 2.913695e-05 0.001 2.913700e-05 0.0 2.913705e-05 0.001 2.913710e-05 0.0 2.913715e-05 0.001 2.913720e-05 0.0 2.913725e-05 0.001 2.913730e-05 0.0 2.913735e-05 0.001 2.913740e-05 0.0 2.913745e-05 0.001 2.913750e-05 0.0 2.913755e-05 0.001 2.913760e-05 0.0 2.913765e-05 0.001 2.913770e-05 0.0 2.913775e-05 0.001 2.913780e-05 0.0 2.913785e-05 0.001 2.913790e-05 0.0 2.913795e-05 0.001 2.913800e-05 0.0 2.913805e-05 0.001 2.913810e-05 0.0 2.913815e-05 0.001 2.913820e-05 0.0 2.913825e-05 0.001 2.913830e-05 0.0 2.913835e-05 0.001 2.913840e-05 0.0 2.913845e-05 0.001 2.913850e-05 0.0 2.913855e-05 0.001 2.913860e-05 0.0 2.913865e-05 0.001 2.913870e-05 0.0 2.913875e-05 0.001 2.913880e-05 0.0 2.913885e-05 0.001 2.913890e-05 0.0 2.913895e-05 0.001 2.913900e-05 0.0 2.913905e-05 0.001 2.913910e-05 0.0 2.913915e-05 0.001 2.913920e-05 0.0 2.913925e-05 0.001 2.913930e-05 0.0 2.913935e-05 0.001 2.913940e-05 0.0 2.913945e-05 0.001 2.913950e-05 0.0 2.913955e-05 0.001 2.913960e-05 0.0 2.913965e-05 0.001 2.913970e-05 0.0 2.913975e-05 0.001 2.913980e-05 0.0 2.913985e-05 0.001 2.913990e-05 0.0 2.913995e-05 0.001 2.914000e-05 0.0 2.914005e-05 0.001 2.914010e-05 0.0 2.914015e-05 0.001 2.914020e-05 0.0 2.914025e-05 0.001 2.914030e-05 0.0 2.914035e-05 0.001 2.914040e-05 0.0 2.914045e-05 0.001 2.914050e-05 0.0 2.914055e-05 0.001 2.914060e-05 0.0 2.914065e-05 0.001 2.914070e-05 0.0 2.914075e-05 0.001 2.914080e-05 0.0 2.914085e-05 0.001 2.914090e-05 0.0 2.914095e-05 0.001 2.914100e-05 0.0 2.914105e-05 0.001 2.914110e-05 0.0 2.914115e-05 0.001 2.914120e-05 0.0 2.914125e-05 0.001 2.914130e-05 0.0 2.914135e-05 0.001 2.914140e-05 0.0 2.914145e-05 0.001 2.914150e-05 0.0 2.914155e-05 0.001 2.914160e-05 0.0 2.914165e-05 0.001 2.914170e-05 0.0 2.914175e-05 0.001 2.914180e-05 0.0 2.914185e-05 0.001 2.914190e-05 0.0 2.914195e-05 0.001 2.914200e-05 0.0 2.914205e-05 0.001 2.914210e-05 0.0 2.914215e-05 0.001 2.914220e-05 0.0 2.914225e-05 0.001 2.914230e-05 0.0 2.914235e-05 0.001 2.914240e-05 0.0 2.914245e-05 0.001 2.914250e-05 0.0 2.914255e-05 0.001 2.914260e-05 0.0 2.914265e-05 0.001 2.914270e-05 0.0 2.914275e-05 0.001 2.914280e-05 0.0 2.914285e-05 0.001 2.914290e-05 0.0 2.914295e-05 0.001 2.914300e-05 0.0 2.914305e-05 0.001 2.914310e-05 0.0 2.914315e-05 0.001 2.914320e-05 0.0 2.914325e-05 0.001 2.914330e-05 0.0 2.914335e-05 0.001 2.914340e-05 0.0 2.914345e-05 0.001 2.914350e-05 0.0 2.914355e-05 0.001 2.914360e-05 0.0 2.914365e-05 0.001 2.914370e-05 0.0 2.914375e-05 0.001 2.914380e-05 0.0 2.914385e-05 0.001 2.914390e-05 0.0 2.914395e-05 0.001 2.914400e-05 0.0 2.914405e-05 0.001 2.914410e-05 0.0 2.914415e-05 0.001 2.914420e-05 0.0 2.914425e-05 0.001 2.914430e-05 0.0 2.914435e-05 0.001 2.914440e-05 0.0 2.914445e-05 0.001 2.914450e-05 0.0 2.914455e-05 0.001 2.914460e-05 0.0 2.914465e-05 0.001 2.914470e-05 0.0 2.914475e-05 0.001 2.914480e-05 0.0 2.914485e-05 0.001 2.914490e-05 0.0 2.914495e-05 0.001 2.914500e-05 0.0 2.914505e-05 0.001 2.914510e-05 0.0 2.914515e-05 0.001 2.914520e-05 0.0 2.914525e-05 0.001 2.914530e-05 0.0 2.914535e-05 0.001 2.914540e-05 0.0 2.914545e-05 0.001 2.914550e-05 0.0 2.914555e-05 0.001 2.914560e-05 0.0 2.914565e-05 0.001 2.914570e-05 0.0 2.914575e-05 0.001 2.914580e-05 0.0 2.914585e-05 0.001 2.914590e-05 0.0 2.914595e-05 0.001 2.914600e-05 0.0 2.914605e-05 0.001 2.914610e-05 0.0 2.914615e-05 0.001 2.914620e-05 0.0 2.914625e-05 0.001 2.914630e-05 0.0 2.914635e-05 0.001 2.914640e-05 0.0 2.914645e-05 0.001 2.914650e-05 0.0 2.914655e-05 0.001 2.914660e-05 0.0 2.914665e-05 0.001 2.914670e-05 0.0 2.914675e-05 0.001 2.914680e-05 0.0 2.914685e-05 0.001 2.914690e-05 0.0 2.914695e-05 0.001 2.914700e-05 0.0 2.914705e-05 0.001 2.914710e-05 0.0 2.914715e-05 0.001 2.914720e-05 0.0 2.914725e-05 0.001 2.914730e-05 0.0 2.914735e-05 0.001 2.914740e-05 0.0 2.914745e-05 0.001 2.914750e-05 0.0 2.914755e-05 0.001 2.914760e-05 0.0 2.914765e-05 0.001 2.914770e-05 0.0 2.914775e-05 0.001 2.914780e-05 0.0 2.914785e-05 0.001 2.914790e-05 0.0 2.914795e-05 0.001 2.914800e-05 0.0 2.914805e-05 0.001 2.914810e-05 0.0 2.914815e-05 0.001 2.914820e-05 0.0 2.914825e-05 0.001 2.914830e-05 0.0 2.914835e-05 0.001 2.914840e-05 0.0 2.914845e-05 0.001 2.914850e-05 0.0 2.914855e-05 0.001 2.914860e-05 0.0 2.914865e-05 0.001 2.914870e-05 0.0 2.914875e-05 0.001 2.914880e-05 0.0 2.914885e-05 0.001 2.914890e-05 0.0 2.914895e-05 0.001 2.914900e-05 0.0 2.914905e-05 0.001 2.914910e-05 0.0 2.914915e-05 0.001 2.914920e-05 0.0 2.914925e-05 0.001 2.914930e-05 0.0 2.914935e-05 0.001 2.914940e-05 0.0 2.914945e-05 0.001 2.914950e-05 0.0 2.914955e-05 0.001 2.914960e-05 0.0 2.914965e-05 0.001 2.914970e-05 0.0 2.914975e-05 0.001 2.914980e-05 0.0 2.914985e-05 0.001 2.914990e-05 0.0 2.914995e-05 0.001 2.915000e-05 0.0 2.915005e-05 0.001 2.915010e-05 0.0 2.915015e-05 0.001 2.915020e-05 0.0 2.915025e-05 0.001 2.915030e-05 0.0 2.915035e-05 0.001 2.915040e-05 0.0 2.915045e-05 0.001 2.915050e-05 0.0 2.915055e-05 0.001 2.915060e-05 0.0 2.915065e-05 0.001 2.915070e-05 0.0 2.915075e-05 0.001 2.915080e-05 0.0 2.915085e-05 0.001 2.915090e-05 0.0 2.915095e-05 0.001 2.915100e-05 0.0 2.915105e-05 0.001 2.915110e-05 0.0 2.915115e-05 0.001 2.915120e-05 0.0 2.915125e-05 0.001 2.915130e-05 0.0 2.915135e-05 0.001 2.915140e-05 0.0 2.915145e-05 0.001 2.915150e-05 0.0 2.915155e-05 0.001 2.915160e-05 0.0 2.915165e-05 0.001 2.915170e-05 0.0 2.915175e-05 0.001 2.915180e-05 0.0 2.915185e-05 0.001 2.915190e-05 0.0 2.915195e-05 0.001 2.915200e-05 0.0 2.915205e-05 0.001 2.915210e-05 0.0 2.915215e-05 0.001 2.915220e-05 0.0 2.915225e-05 0.001 2.915230e-05 0.0 2.915235e-05 0.001 2.915240e-05 0.0 2.915245e-05 0.001 2.915250e-05 0.0 2.915255e-05 0.001 2.915260e-05 0.0 2.915265e-05 0.001 2.915270e-05 0.0 2.915275e-05 0.001 2.915280e-05 0.0 2.915285e-05 0.001 2.915290e-05 0.0 2.915295e-05 0.001 2.915300e-05 0.0 2.915305e-05 0.001 2.915310e-05 0.0 2.915315e-05 0.001 2.915320e-05 0.0 2.915325e-05 0.001 2.915330e-05 0.0 2.915335e-05 0.001 2.915340e-05 0.0 2.915345e-05 0.001 2.915350e-05 0.0 2.915355e-05 0.001 2.915360e-05 0.0 2.915365e-05 0.001 2.915370e-05 0.0 2.915375e-05 0.001 2.915380e-05 0.0 2.915385e-05 0.001 2.915390e-05 0.0 2.915395e-05 0.001 2.915400e-05 0.0 2.915405e-05 0.001 2.915410e-05 0.0 2.915415e-05 0.001 2.915420e-05 0.0 2.915425e-05 0.001 2.915430e-05 0.0 2.915435e-05 0.001 2.915440e-05 0.0 2.915445e-05 0.001 2.915450e-05 0.0 2.915455e-05 0.001 2.915460e-05 0.0 2.915465e-05 0.001 2.915470e-05 0.0 2.915475e-05 0.001 2.915480e-05 0.0 2.915485e-05 0.001 2.915490e-05 0.0 2.915495e-05 0.001 2.915500e-05 0.0 2.915505e-05 0.001 2.915510e-05 0.0 2.915515e-05 0.001 2.915520e-05 0.0 2.915525e-05 0.001 2.915530e-05 0.0 2.915535e-05 0.001 2.915540e-05 0.0 2.915545e-05 0.001 2.915550e-05 0.0 2.915555e-05 0.001 2.915560e-05 0.0 2.915565e-05 0.001 2.915570e-05 0.0 2.915575e-05 0.001 2.915580e-05 0.0 2.915585e-05 0.001 2.915590e-05 0.0 2.915595e-05 0.001 2.915600e-05 0.0 2.915605e-05 0.001 2.915610e-05 0.0 2.915615e-05 0.001 2.915620e-05 0.0 2.915625e-05 0.001 2.915630e-05 0.0 2.915635e-05 0.001 2.915640e-05 0.0 2.915645e-05 0.001 2.915650e-05 0.0 2.915655e-05 0.001 2.915660e-05 0.0 2.915665e-05 0.001 2.915670e-05 0.0 2.915675e-05 0.001 2.915680e-05 0.0 2.915685e-05 0.001 2.915690e-05 0.0 2.915695e-05 0.001 2.915700e-05 0.0 2.915705e-05 0.001 2.915710e-05 0.0 2.915715e-05 0.001 2.915720e-05 0.0 2.915725e-05 0.001 2.915730e-05 0.0 2.915735e-05 0.001 2.915740e-05 0.0 2.915745e-05 0.001 2.915750e-05 0.0 2.915755e-05 0.001 2.915760e-05 0.0 2.915765e-05 0.001 2.915770e-05 0.0 2.915775e-05 0.001 2.915780e-05 0.0 2.915785e-05 0.001 2.915790e-05 0.0 2.915795e-05 0.001 2.915800e-05 0.0 2.915805e-05 0.001 2.915810e-05 0.0 2.915815e-05 0.001 2.915820e-05 0.0 2.915825e-05 0.001)
Rgrid grid 0 1G
.control
set noaskquit
save v(c_oa) v(c_ob) v(q_oa) v(q_ob) v(l80f14_oa) v(l80f14_ob) v(l80f16_oa) v(l80f16_ob) v(l80f18_oa) v(l80f18_ob) v(l40f0_oa) v(l40f0_ob) v(l40f2_oa) v(l40f2_ob) v(l40f4_oa) v(l40f4_ob) v(l40f6_oa) v(l40f6_ob) v(l40f8_oa) v(l40f8_ob) v(l40f10_oa) v(l40f10_ob)
tran 1n 2.9958e-05 0 2n
meas tran c_oa when v(c_oa)=0.9 rise=1
meas tran c_ob when v(c_ob)=0.9 rise=1
meas tran q_oa when v(q_oa)=0.9 rise=1
meas tran q_ob when v(q_ob)=0.9 rise=1
meas tran l80f14_oa when v(l80f14_oa)=0.9 rise=1
meas tran l80f14_ob when v(l80f14_ob)=0.9 rise=1
meas tran l80f16_oa when v(l80f16_oa)=0.9 rise=1
meas tran l80f16_ob when v(l80f16_ob)=0.9 rise=1
meas tran l80f18_oa when v(l80f18_oa)=0.9 rise=1
meas tran l80f18_ob when v(l80f18_ob)=0.9 rise=1
meas tran l40f0_oa when v(l40f0_oa)=0.9 rise=1
meas tran l40f0_ob when v(l40f0_ob)=0.9 rise=1
meas tran l40f2_oa when v(l40f2_oa)=0.9 rise=1
meas tran l40f2_ob when v(l40f2_ob)=0.9 rise=1
meas tran l40f4_oa when v(l40f4_oa)=0.9 rise=1
meas tran l40f4_ob when v(l40f4_ob)=0.9 rise=1
meas tran l40f6_oa when v(l40f6_oa)=0.9 rise=1
meas tran l40f6_ob when v(l40f6_ob)=0.9 rise=1
meas tran l40f8_oa when v(l40f8_oa)=0.9 rise=1
meas tran l40f8_ob when v(l40f8_ob)=0.9 rise=1
meas tran l40f10_oa when v(l40f10_oa)=0.9 rise=1
meas tran l40f10_ob when v(l40f10_ob)=0.9 rise=1
echo RES tt 27 c_oa=$&c_oa
echo RES tt 27 c_ob=$&c_ob
echo RES tt 27 q_oa=$&q_oa
echo RES tt 27 q_ob=$&q_ob
echo RES tt 27 l80f14_oa=$&l80f14_oa
echo RES tt 27 l80f14_ob=$&l80f14_ob
echo RES tt 27 l80f16_oa=$&l80f16_oa
echo RES tt 27 l80f16_ob=$&l80f16_ob
echo RES tt 27 l80f18_oa=$&l80f18_oa
echo RES tt 27 l80f18_ob=$&l80f18_ob
echo RES tt 27 l40f0_oa=$&l40f0_oa
echo RES tt 27 l40f0_ob=$&l40f0_ob
echo RES tt 27 l40f2_oa=$&l40f2_oa
echo RES tt 27 l40f2_ob=$&l40f2_ob
echo RES tt 27 l40f4_oa=$&l40f4_oa
echo RES tt 27 l40f4_ob=$&l40f4_ob
echo RES tt 27 l40f6_oa=$&l40f6_oa
echo RES tt 27 l40f6_ob=$&l40f6_ob
echo RES tt 27 l40f8_oa=$&l40f8_oa
echo RES tt 27 l40f8_ob=$&l40f8_ob
echo RES tt 27 l40f10_oa=$&l40f10_oa
echo RES tt 27 l40f10_ob=$&l40f10_ob
quit
.endc
.end
