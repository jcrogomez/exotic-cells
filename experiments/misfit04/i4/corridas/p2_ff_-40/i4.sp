* MISFIT-03 etapa a · MISFIT-04 I4 pasada 2 · esquina ff -40 C. Generado por gen_contrato.py (no editar a mano).
* Macro: cells/xc19_slot_core/xc19_slot_core_lod.inc (Magic, extraccion con capacidades, LOD anotado por Residual).
* Decodificador: celdas sky130_fd_sc_hd en SPICE (E7). El contador es aritmetico: cuentas = (t_xa - t_pre) * 50 MHz.
.lib /pdk/libs.tech/ngspice/sky130.lib.spice ff
.include /pdk/libs.ref/sky130_fd_sc_hd/spice/sky130_fd_sc_hd.spice
.options gmin=1e-18 abstol=1e-15 reltol=1e-5
.temp -40
.subckt core XB_OUT SB0B SB1B REFB XA_OUT SA0B SA1B SA2B REFA VDD GND VBIAS C1 PREA XA DUTA PREB XB DUTB VB CALA CALB
X5 GND VB GND GND sky130_fd_pr__nfet_01v8 ad=1.65 pd=6.1 as=117.474 ps=596.35999 w=5.5 l=10
X6 GND VB GND GND sky130_fd_pr__nfet_01v8 ad=1.65 pd=6.1 as=0 ps=0 w=5.5 l=10
X7 GND XB GND GND sky130_fd_pr__nfet_01v8 ad=1.29 pd=9.2 as=0 ps=0 w=4.3 l=4
X12 GND VB GND GND sky130_fd_pr__nfet_01v8 ad=1.65 pd=6.1 as=0 ps=0 w=5.5 l=10
X13 GND VB GND GND sky130_fd_pr__nfet_01v8 ad=1.65 pd=11.6 as=0 ps=0 w=5.5 l=10
X16 GND VB GND GND sky130_fd_pr__nfet_01v8 ad=1.65 pd=11.6 as=0 ps=0 w=5.5 l=10
X17 GND VB GND GND sky130_fd_pr__nfet_01v8 ad=1.65 pd=6.1 as=0 ps=0 w=5.5 l=10
X19 GND XA GND GND sky130_fd_pr__nfet_01v8 ad=1.29 pd=9.2 as=0 ps=0 w=4.3 l=4
X23 GND VB GND GND sky130_fd_pr__nfet_01v8 ad=1.65 pd=6.1 as=0 ps=0 w=5.5 l=10
X24 GND VB GND GND sky130_fd_pr__nfet_01v8 ad=1.65 pd=6.1 as=0 ps=0 w=5.5 l=10
X25 GND VB GND GND sky130_fd_pr__nfet_01v8 ad=1.65 pd=11.6 as=0 ps=0 w=5.5 l=10
X27 GND VB GND GND sky130_fd_pr__nfet_01v8 ad=1.65 pd=6.1 as=0 ps=0 w=5.5 l=10
X32 GND VB GND GND sky130_fd_pr__nfet_01v8 ad=1.65 pd=6.1 as=0 ps=0 w=5.5 l=10
X34 GND VB GND GND sky130_fd_pr__nfet_01v8 ad=1.65 pd=11.6 as=0 ps=0 w=5.5 l=10
X42 GND VB GND GND sky130_fd_pr__nfet_01v8 ad=1.65 pd=6.1 as=0 ps=0 w=5.5 l=10
X43 GND VB GND GND sky130_fd_pr__nfet_01v8 ad=1.65 pd=6.1 as=0 ps=0 w=5.5 l=10
X50 GND VB GND GND sky130_fd_pr__nfet_01v8 ad=1.65 pd=11.6 as=0 ps=0 w=5.5 l=10
X53 GND VB GND GND sky130_fd_pr__nfet_01v8 ad=1.65 pd=6.1 as=0 ps=0 w=5.5 l=10
X54 GND VB GND GND sky130_fd_pr__nfet_01v8 ad=1.65 pd=6.1 as=0 ps=0 w=5.5 l=10
X55 GND VB GND GND sky130_fd_pr__nfet_01v8 ad=1.65 pd=6.1 as=0 ps=0 w=5.5 l=10
X58 GND VB GND GND sky130_fd_pr__nfet_01v8 ad=1.65 pd=6.1 as=0 ps=0 w=5.5 l=10
X59 GND VB GND GND sky130_fd_pr__nfet_01v8 ad=1.65 pd=11.6 as=0 ps=0 w=5.5 l=10
X62 GND VB GND GND sky130_fd_pr__nfet_01v8 ad=1.65 pd=11.6 as=0 ps=0 w=5.5 l=10
X63 GND VB GND GND sky130_fd_pr__nfet_01v8 ad=1.65 pd=6.1 as=0 ps=0 w=5.5 l=10
X64 GND VB GND GND sky130_fd_pr__nfet_01v8 ad=1.65 pd=6.1 as=0 ps=0 w=5.5 l=10
X68 GND VB GND GND sky130_fd_pr__nfet_01v8 ad=1.65 pd=11.6 as=0 ps=0 w=5.5 l=10
X72 GND VB GND GND sky130_fd_pr__nfet_01v8 ad=1.65 pd=11.6 as=0 ps=0 w=5.5 l=10
X73 GND VB GND GND sky130_fd_pr__nfet_01v8 ad=1.65 pd=6.1 as=0 ps=0 w=5.5 l=10
X74 GND VB GND GND sky130_fd_pr__nfet_01v8 ad=1.65 pd=6.1 as=0 ps=0 w=5.5 l=10
X80 GND VB GND GND sky130_fd_pr__nfet_01v8 ad=1.65 pd=6.1 as=0 ps=0 w=5.5 l=10
X81 GND VB GND GND sky130_fd_pr__nfet_01v8 ad=1.65 pd=11.6 as=0 ps=0 w=5.5 l=10
X85 GND VB GND GND sky130_fd_pr__nfet_01v8 ad=1.65 pd=6.1 as=0 ps=0 w=5.5 l=10
X90 GND VB GND GND sky130_fd_pr__nfet_01v8 ad=1.65 pd=6.1 as=0 ps=0 w=5.5 l=10
X92 GND VB GND GND sky130_fd_pr__nfet_01v8 ad=1.65 pd=6.1 as=0 ps=0 w=5.5 l=10
X95 GND VB GND GND sky130_fd_pr__nfet_01v8 ad=1.65 pd=11.6 as=0 ps=0 w=5.5 l=10
X0 XB PREB VDD VDD sky130_fd_pr__pfet_01v8_hvt ad=0.126 pd=1.44 as=0.126 ps=1.44 w=0.42 l=0.5 sa=0.3 sb=0.3
X1 VB VB GND GND sky130_fd_pr__nfet_01v8 ad=0.126 pd=1.44 as=0.126 ps=1.44 w=0.42 l=0.15 sa=0.3 sb=0.3
X2 a_n2000_n1632# VB a_n2090_n1632# GND sky130_fd_pr__nfet_01v8 ad=0.126 pd=1.44 as=0.126 ps=1.44 w=0.42 l=0.15 sa=0.3 sb=0.3
X3 a_7130_n1632# VB a_7040_n2004# GND sky130_fd_pr__nfet_01v8 ad=0.126 pd=1.44 as=0.126 ps=1.44 w=0.42 l=0.15 sa=0.3 sb=0.3
X4 a_7130_n1632# VB a_7040_n2004# GND sky130_fd_pr__nfet_01v8 ad=0.126 pd=1.44 as=0.126 ps=1.44 w=0.42 l=0.15 sa=0.3 sb=0.3
X8 XA PREA VDD VDD sky130_fd_pr__pfet_01v8_hvt ad=0.126 pd=1.44 as=0.126 ps=1.44 w=0.42 l=0.5 sa=0.3 sb=0.3
X9 VB VB GND GND sky130_fd_pr__nfet_01v8 ad=0.126 pd=1.44 as=0.126 ps=1.44 w=0.42 l=0.15 sa=0.3 sb=0.3
X10 VB VB GND GND sky130_fd_pr__nfet_01v8 ad=0.126 pd=1.44 as=0.126 ps=1.44 w=0.42 l=0.15 sa=0.3 sb=0.3
X11 XA VB a_n2090_n1632# GND sky130_fd_pr__nfet_01v8 ad=0.126 pd=1.44 as=0.126 ps=1.44 w=0.42 l=0.15 sa=0.3 sb=0.3
X14 XA VB a_n2090_n1632# GND sky130_fd_pr__nfet_01v8 ad=0.126 pd=1.44 as=0.126 ps=1.44 w=0.42 l=0.15 sa=0.3 sb=0.3
X15 GND REFB a_7040_n2004# GND sky130_fd_pr__nfet_01v8 ad=0.252 pd=2.28 as=0.252 ps=2.28 w=0.84 l=0.15 sa=0.3 sb=0.3
X18 XB_OUT XB VDD VDD sky130_fd_pr__pfet_01v8 ad=0.3 pd=2.6 as=0.3 ps=2.6 w=1 l=0.15 sa=0.3 sb=0.3
X20 a_7650_n924# VDD XB VDD sky130_fd_pr__pfet_01v8 ad=0.126 pd=1.44 as=0.126 ps=1.44 w=0.42 l=0.15 sa=0.3 sb=0.3
X21 a_7130_n1632# VB XB GND sky130_fd_pr__nfet_01v8 ad=0.126 pd=1.44 as=0.126 ps=1.44 w=0.42 l=0.15 sa=0.3 sb=0.3
X22 a_7130_n1632# VB XB GND sky130_fd_pr__nfet_01v8 ad=0.126 pd=1.44 as=0.126 ps=1.44 w=0.42 l=0.15 sa=0.3 sb=0.3
X26 VB VB GND GND sky130_fd_pr__nfet_01v8 ad=0.126 pd=1.44 as=0.126 ps=1.44 w=0.42 l=0.15 sa=0.3 sb=0.3
X28 XB_OUT XB GND GND sky130_fd_pr__nfet_01v8 ad=0.195 pd=1.9 as=0.195 ps=1.9 w=0.65 l=0.15 sa=0.3 sb=0.3
X29 VB VB GND GND sky130_fd_pr__nfet_01v8 ad=0.126 pd=1.44 as=0.126 ps=1.44 w=0.42 l=0.15 sa=0.3 sb=0.3
X30 XA SA2B a_n1510_n924# VDD sky130_fd_pr__pfet_01v8 ad=0.126 pd=1.44 as=0.126 ps=1.44 w=0.42 l=0.15 sa=0.3 sb=0.3
X31 a_7370_n924# SB1B XB VDD sky130_fd_pr__pfet_01v8 ad=0.126 pd=1.44 as=0.126 ps=1.44 w=0.42 l=0.15 sa=0.3 sb=0.3
X33 VB VB GND GND sky130_fd_pr__nfet_01v8 ad=0.126 pd=1.44 as=0.126 ps=1.44 w=0.42 l=0.15 sa=0.3 sb=0.3
X35 a_n2000_n1632# VB a_n2090_n1632# GND sky130_fd_pr__nfet_01v8 ad=0.126 pd=1.44 as=0.126 ps=1.44 w=0.42 l=0.15 sa=0.3 sb=0.3
X36 VB VB GND GND sky130_fd_pr__nfet_01v8 ad=0.126 pd=1.44 as=0.126 ps=1.44 w=0.42 l=0.15 sa=0.3 sb=0.3
X37 XA VB a_3900_n392# GND sky130_fd_pr__nfet_01v8 ad=0.126 pd=1.44 as=0.126 ps=1.44 w=0.42 l=0.15 sa=0.3 sb=0.3
X38 a_7130_n1632# VB a_7040_n2004# GND sky130_fd_pr__nfet_01v8 ad=0.126 pd=1.44 as=0.126 ps=1.44 w=0.42 l=0.15 sa=0.3 sb=0.3
X39 XB VB a_4500_n392# GND sky130_fd_pr__nfet_01v8 ad=0.126 pd=1.44 as=0.126 ps=1.44 w=0.42 l=0.15 sa=0.3 sb=0.3
X40 XA SA1B a_n1230_n924# VDD sky130_fd_pr__pfet_01v8 ad=0.126 pd=1.44 as=0.126 ps=1.44 w=0.42 l=0.15 sa=0.3 sb=0.3
X41 a_7090_n924# SB0B XB VDD sky130_fd_pr__pfet_01v8 ad=0.126 pd=1.44 as=0.126 ps=1.44 w=0.42 l=0.15 sa=0.3 sb=0.3
X44 XA VB a_n2090_n1632# GND sky130_fd_pr__nfet_01v8 ad=0.126 pd=1.44 as=0.126 ps=1.44 w=0.42 l=0.15 sa=0.3 sb=0.3
X45 a_n2000_n1632# REFA GND GND sky130_fd_pr__nfet_01v8 ad=0.252 pd=2.28 as=0.252 ps=2.28 w=0.84 l=0.15 sa=0.3 sb=0.3
X46 VDD XA XA_OUT VDD sky130_fd_pr__pfet_01v8 ad=0.3 pd=2.6 as=0.3 ps=2.6 w=1 l=0.15 sa=0.3 sb=0.3
X47 VB VB GND GND sky130_fd_pr__nfet_01v8 ad=0.126 pd=1.44 as=0.126 ps=1.44 w=0.42 l=0.15 sa=0.3 sb=0.3
X48 XA SA0B a_n950_n924# VDD sky130_fd_pr__pfet_01v8 ad=0.126 pd=1.44 as=0.126 ps=1.44 w=0.42 l=0.15 sa=0.3 sb=0.3
X49 a_7130_n1632# VB XB GND sky130_fd_pr__nfet_01v8 ad=0.126 pd=1.44 as=0.126 ps=1.44 w=0.42 l=0.15 sa=0.3 sb=0.3
X51 VB VB GND GND sky130_fd_pr__nfet_01v8 ad=0.126 pd=1.44 as=0.126 ps=1.44 w=0.42 l=0.15 sa=0.3 sb=0.3
X52 VB VB GND GND sky130_fd_pr__nfet_01v8 ad=0.126 pd=1.44 as=0.126 ps=1.44 w=0.42 l=0.15 sa=0.3 sb=0.3
X56 GND XA XA_OUT GND sky130_fd_pr__nfet_01v8 ad=0.195 pd=1.9 as=0.195 ps=1.9 w=0.65 l=0.15 sa=0.3 sb=0.3
X57 VB VB GND GND sky130_fd_pr__nfet_01v8 ad=0.126 pd=1.44 as=0.126 ps=1.44 w=0.42 l=0.15 sa=0.3 sb=0.3
X60 a_n48_382# a_n48_382# VB GND sky130_fd_pr__nfet_01v8 ad=0.3 pd=2.6 as=0.3 ps=2.6 w=1 l=1 sa=0.3 sb=0.3
X61 a_7130_n1632# VB a_7040_n2004# GND sky130_fd_pr__nfet_01v8 ad=0.126 pd=1.44 as=0.126 ps=1.44 w=0.42 l=0.15 sa=0.3 sb=0.3
X65 VB VB GND GND sky130_fd_pr__nfet_01v8 ad=0.126 pd=1.44 as=0.126 ps=1.44 w=0.42 l=0.15 sa=0.3 sb=0.3
X66 a_n2000_n1632# VB a_n2090_n1632# GND sky130_fd_pr__nfet_01v8 ad=0.126 pd=1.44 as=0.126 ps=1.44 w=0.42 l=0.15 sa=0.3 sb=0.3
X67 a_n2000_n1632# VB a_n2090_n1632# GND sky130_fd_pr__nfet_01v8 ad=0.126 pd=1.44 as=0.126 ps=1.44 w=0.42 l=0.15 sa=0.3 sb=0.3
X69 GND DUTB a_4500_n392# GND sky130_fd_pr__nfet_01v8 ad=0.252 pd=2.28 as=0.252 ps=2.28 w=0.84 l=0.15 sa=0.3 sb=0.3
X70 a_7130_n1632# VB XB GND sky130_fd_pr__nfet_01v8 ad=0.126 pd=1.44 as=0.126 ps=1.44 w=0.42 l=0.15 sa=0.3 sb=0.3
X71 a_7130_n1632# VB a_7040_n2004# GND sky130_fd_pr__nfet_01v8 ad=0.126 pd=1.44 as=0.126 ps=1.44 w=0.42 l=0.15 sa=0.3 sb=0.3
X75 a_7130_n1632# VB a_7040_n2004# GND sky130_fd_pr__nfet_01v8 ad=0.126 pd=1.44 as=0.126 ps=1.44 w=0.42 l=0.15 sa=0.3 sb=0.3
X76 VB VB GND GND sky130_fd_pr__nfet_01v8 ad=0.126 pd=1.44 as=0.126 ps=1.44 w=0.42 l=0.15 sa=0.3 sb=0.3
X77 VB VB GND GND sky130_fd_pr__nfet_01v8 ad=0.126 pd=1.44 as=0.126 ps=1.44 w=0.42 l=0.15 sa=0.3 sb=0.3
X78 XA VB a_n2090_n1632# GND sky130_fd_pr__nfet_01v8 ad=0.126 pd=1.44 as=0.126 ps=1.44 w=0.42 l=0.15 sa=0.3 sb=0.3
X79 XA VB a_n2090_n1632# GND sky130_fd_pr__nfet_01v8 ad=0.126 pd=1.44 as=0.126 ps=1.44 w=0.42 l=0.15 sa=0.3 sb=0.3
X82 GND DUTA a_3900_n392# GND sky130_fd_pr__nfet_01v8 ad=0.252 pd=2.28 as=0.252 ps=2.28 w=0.84 l=0.15 sa=0.3 sb=0.3
X83 a_7130_n1632# VB XB GND sky130_fd_pr__nfet_01v8 ad=0.126 pd=1.44 as=0.126 ps=1.44 w=0.42 l=0.15 sa=0.3 sb=0.3
X84 a_7130_n1632# VB XB GND sky130_fd_pr__nfet_01v8 ad=0.126 pd=1.44 as=0.126 ps=1.44 w=0.42 l=0.15 sa=0.3 sb=0.3
X86 C1 C1 a_n48_382# GND sky130_fd_pr__nfet_01v8 ad=0.3 pd=2.6 as=0.3 ps=2.6 w=1 l=1 sa=0.3 sb=0.3
X87 VB VB GND GND sky130_fd_pr__nfet_01v8 ad=0.126 pd=1.44 as=0.126 ps=1.44 w=0.42 l=0.15 sa=0.3 sb=0.3
X88 VBIAS VBIAS C1 GND sky130_fd_pr__nfet_01v8 ad=0.3 pd=2.6 as=0.3 ps=2.6 w=1 l=1 sa=0.3 sb=0.3
X89 a_n2000_n1632# VB a_n2090_n1632# GND sky130_fd_pr__nfet_01v8 ad=0.126 pd=1.44 as=0.126 ps=1.44 w=0.42 l=0.15 sa=0.3 sb=0.3
X91 VB VB GND GND sky130_fd_pr__nfet_01v8 ad=0.126 pd=1.44 as=0.126 ps=1.44 w=0.42 l=0.15 sa=0.3 sb=0.3
X93 XA VB a_n2090_n1632# GND sky130_fd_pr__nfet_01v8 ad=0.126 pd=1.44 as=0.126 ps=1.44 w=0.42 l=0.15 sa=0.3 sb=0.3
X94 a_n2000_n1632# VB a_n2090_n1632# GND sky130_fd_pr__nfet_01v8 ad=0.126 pd=1.44 as=0.126 ps=1.44 w=0.42 l=0.15 sa=0.3 sb=0.3
C0 a_n950_n924# SA0B 0.00164f
C1 a_n950_n924# a_n1230_n924# 0.00251f
C2 VB PREA 0.00674f
C3 SA1B VDD 0.05165f
C4 VB SA2B 0
C5 a_n950_n924# XA 0.05363f
C6 CALA XA 0.59636f
C7 XB DUTA 0
C8 VDD SA0B 0.04538f
C9 SA1B SA0B 0.01827f
C10 VDD a_n1230_n924# 0.02524f
C11 VB DUTA 0.01701f
C12 XB CALB 0.60923f
C13 VDD PREB 0.17673f
C14 SA1B a_n1230_n924# 0.00999f
C15 a_n2000_n1632# REFA 0.00982f
C16 a_3900_n392# DUTA 0.00298f
C17 VDD XA 0.42588f
C18 SA1B XA 0.01535f
C19 CALB VB 0.01176f
C20 DUTB DUTA 0.00465f
C21 XB SB0B 0.01894f
C22 SA0B a_n1230_n924# 0.00126f
C23 SB0B a_7090_n924# 0.00164f
C24 VB REFA 0.00473f
C25 VDD PREA 0.17043f
C26 SA0B XA 0.01894f
C27 VB SB0B 0.00204f
C28 CALB DUTB 0
C29 VDD SA2B 0.05775f
C30 XA a_n1230_n924# 0.14938f
C31 SB0B a_7370_n924# 0.00126f
C32 SA1B SA2B 0.01827f
C33 PREB XA 0
C34 CALB CALA 0.00657f
C35 a_7040_n2004# SB0B 0
C36 VDD DUTA 0
C37 PREB PREA 0.00413f
C38 a_n1230_n924# SA2B 0.00165f
C39 XA PREA 0.02146f
C40 VDD CALB 0
C41 XA SA2B 0.01399f
C42 XB SB1B 0.01535f
C43 SB1B a_7090_n924# 0
C44 SB1B VB 0.00327f
C45 C1 a_n48_382# 0.05143f
C46 VDD SB0B 0.04538f
C47 SB1B a_7370_n924# 0.00999f
C48 XA DUTA 0.00921f
C49 a_n48_382# VB 0.06216f
C50 PREB CALB 0
C51 SB1B a_7130_n1632# 0
C52 CALB XA 0
C53 XA_OUT VB 0
C54 a_n1510_n924# a_n2090_n1632# 0.04223f
C55 VB REFB 0.00642f
C56 a_7130_n1632# REFB 0
C57 a_7040_n2004# REFB 0.00982f
C58 VDD SB1B 0.06992f
C59 VDD a_n48_382# 0.04849f
C60 XB a_7650_n924# 0.08426f
C61 XB a_4500_n392# 0.05778f
C62 VDD XA_OUT 0.11304f
C63 a_7650_n924# VB 0.02473f
C64 XB_OUT XB 0.02746f
C65 VB a_4500_n392# 0.0654f
C66 a_7650_n924# a_7370_n924# 0.11048f
C67 a_n2090_n1632# a_n2000_n1632# 0.44072f
C68 XB_OUT VB 0
C69 a_7650_n924# a_7130_n1632# 0.04223f
C70 a_4500_n392# DUTB 0.00298f
C71 a_n48_382# XA 0.0082f
C72 a_7040_n2004# a_7650_n924# 0.00146f
C73 a_n1510_n924# a_n2000_n1632# 0.00146f
C74 a_n2090_n1632# VB 0.41781f
C75 XA_OUT XA 0.02816f
C76 a_n1510_n924# VB 0.0246f
C77 VDD a_7650_n924# 0.07321f
C78 a_n2090_n1632# a_n950_n924# 0
C79 VDD a_4500_n392# 0.00496f
C80 XB_OUT VDD 0.1139f
C81 a_n2090_n1632# VDD 0.02312f
C82 SB1B SB0B 0.01827f
C83 SA1B a_n2090_n1632# 0
C84 C1 VBIAS 0.05143f
C85 a_n1510_n924# VDD 0.04424f
C86 VB VBIAS 0.00565f
C87 VB a_n2000_n1632# 0.14597f
C88 XB a_7090_n924# 0.05363f
C89 a_n2090_n1632# a_n1230_n924# 0.04617f
C90 XB VB 0.97066f
C91 C1 VB 0.00902f
C92 a_n2090_n1632# XA 0.42116f
C93 VB a_7090_n924# 0
C94 XB a_7370_n924# 0.14938f
C95 a_n1510_n924# a_n1230_n924# 0.11048f
C96 a_7370_n924# a_7090_n924# 0.00251f
C97 XB a_7130_n1632# 0.42116f
C98 VB a_7370_n924# 0.01419f
C99 a_n1510_n924# XA 0.08427f
C100 VB a_3900_n392# 0.07228f
C101 XB DUTB 0.01922f
C102 a_7130_n1632# a_7090_n924# 0
C103 a_4500_n392# DUTA 0
C104 a_7040_n2004# XB 0.00524f
C105 VB a_7130_n1632# 0.42696f
C106 a_n2090_n1632# SA2B 0
C107 XB CALA 0
C108 VB DUTB 0.01701f
C109 a_7130_n1632# a_7370_n924# 0.04617f
C110 a_7040_n2004# VB 0.14965f
C111 a_n950_n924# VB 0
C112 a_7040_n2004# a_7370_n924# 0.00104f
C113 VB CALA 0.01075f
C114 a_n1510_n924# SA2B 0.00999f
C115 VDD VBIAS 0.03241f
C116 a_3900_n392# CALA 0
C117 VDD a_n2000_n1632# 0
C118 a_7040_n2004# a_7130_n1632# 0.44072f
C119 VDD XB 0.47837f
C120 C1 VDD 0.04849f
C121 VDD a_7090_n924# 0.00372f
C122 VDD VB 0.37803f
C123 SA0B a_n2000_n1632# 0
C124 SA1B VB 0.00283f
C125 VDD a_7370_n924# 0.0269f
C126 a_n2000_n1632# a_n1230_n924# 0.00104f
C127 VDD a_3900_n392# 0.00496f
C128 a_n2090_n1632# REFA 0
C129 XA VBIAS 0.00599f
C130 VDD a_7130_n1632# 0.02379f
C131 XA a_n2000_n1632# 0.00524f
C132 XB PREB 0.0233f
C133 VDD DUTB 0
C134 VB SA0B 0
C135 VDD a_7040_n2004# 0
C136 XB XA 0.02337f
C137 C1 XA 0.00739f
C138 VB a_n1230_n924# 0.00964f
C139 VDD a_n950_n924# 0.00372f
C140 PREB VB 0.00674f
C141 SA1B a_n950_n924# 0
C142 VB XA 0.8449f
C143 a_n2000_n1632# SA2B 0
C144 a_3900_n392# XA 0.05981f
C145 CALB GND 0.28251f
C146 CALA GND 0.29501f
C147 REFB GND 0.20655f
C148 REFA GND 0.20801f
C149 SB1B GND 0.12644f
C150 SB0B GND 0.15202f
C151 SA0B GND 0.15406f
C152 SA1B GND 0.12684f
C153 SA2B GND 0.14679f
C154 DUTB GND 0.21831f
C155 DUTA GND 0.21794f
C156 XB_OUT GND 0.13753f
C157 PREB GND 0.10876f
C158 PREA GND 0.11529f
C159 VB GND 0.15539p
C160 XA_OUT GND 0.13768f
C161 XB GND 6.78211f
C162 VBIAS GND 0.5422f
C163 C1 GND 0.59586f
C164 XA GND 6.96986f
C165 VDD GND 10.8423f
C166 a_7040_n2004# GND 0.72315f
C167 a_7130_n1632# GND 1.04447f
C168 a_7650_n924# GND 0.28817f
C169 a_7370_n924# GND 0.23703f
C170 a_7090_n924# GND 0.01563f
C171 a_n2000_n1632# GND 0.72677f
C172 a_n2090_n1632# GND 1.05417f
C173 a_n950_n924# GND 0.01598f
C174 a_n1230_n924# GND 0.24157f
C175 a_n1510_n924# GND 0.297f
C176 a_4500_n392# GND 0.20468f
C177 a_3900_n392# GND 0.19922f
C178 a_n48_382# GND 0.59697f
.ends
Vd vdd 0 1.8
Vh hi 0 1.8
Vpre pre 0 pwl(0 1.8 1e-06 1.8 1.001e-06 0)
* --- c: core
Xc_ienn hi 0 0 vdd vdd c_enn sky130_fd_sc_hd__inv_1
Xc_is1n 0 0 0 vdd vdd c_s1n sky130_fd_sc_hd__inv_1
Xc_is0n hi 0 0 vdd vdd c_s0n sky130_fd_sc_hd__inv_1
Xc_PREA pre c_enn 0 0 vdd vdd c_PREA sky130_fd_sc_hd__nor2_1
Xc_PREB pre c_enn 0 0 vdd vdd c_PREB sky130_fd_sc_hd__nor2_1
Xc_VBIAS hi 0 0 vdd vdd c_VBIAS sky130_fd_sc_hd__buf_2
Xc_C1 hi 0 0 vdd vdd c_C1 sky130_fd_sc_hd__buf_2
Xc_DUTA hi c_s1n hi 0 0 vdd vdd c_DUTA sky130_fd_sc_hd__and3_1
Xc_DUTB hi c_s1n hi 0 0 vdd vdd c_DUTB sky130_fd_sc_hd__and3_1
Xc_REFA hi 0 0 0 vdd vdd c_REFA sky130_fd_sc_hd__and2_1
Xc_REFB hi 0 0 0 vdd vdd c_REFB sky130_fd_sc_hd__and2_1
Xc_SA0B hi 0 hi 0 0 vdd vdd c_SA0B sky130_fd_sc_hd__nand3_1
Xc_SA1B hi 0 0 0 vdd vdd c_SA1B sky130_fd_sc_hd__nand2_1
Xc_SA2B hi 0 c_s0n 0 0 vdd vdd c_SA2B sky130_fd_sc_hd__nand3_1
Xc_SB0B hi 0 0 0 vdd vdd c_SB0B sky130_fd_sc_hd__nand2_1
Xc_SB1B hi 0 0 0 vdd vdd c_SB1B sky130_fd_sc_hd__nand2_1
Xc_M c_ob c_SB0B c_SB1B c_REFB c_oa c_SA0B c_SA1B c_SA2B c_REFA vdd 0 c_VBIAS c_C1 c_PREA c_XA c_DUTA c_PREB c_XB c_DUTB c_VB 0 0 core

* --- q: core
Xq_ienn hi 0 0 vdd vdd q_enn sky130_fd_sc_hd__inv_1
Xq_is1n 0 0 0 vdd vdd q_s1n sky130_fd_sc_hd__inv_1
Xq_is0n hi 0 0 vdd vdd q_s0n sky130_fd_sc_hd__inv_1
Xq_PREA pre q_enn 0 0 vdd vdd q_PREA sky130_fd_sc_hd__nor2_1
Xq_PREB pre q_enn 0 0 vdd vdd q_PREB sky130_fd_sc_hd__nor2_1
Xq_VBIAS hi 0 0 vdd vdd q_VBIAS sky130_fd_sc_hd__buf_2
Xq_C1 hi 0 0 vdd vdd q_C1 sky130_fd_sc_hd__buf_2
Xq_DUTA hi q_s1n hi 0 0 vdd vdd q_DUTA sky130_fd_sc_hd__and3_1
Xq_DUTB hi q_s1n hi 0 0 vdd vdd q_DUTB sky130_fd_sc_hd__and3_1
Xq_REFA hi 0 0 0 vdd vdd q_REFA sky130_fd_sc_hd__and2_1
Xq_REFB hi 0 0 0 vdd vdd q_REFB sky130_fd_sc_hd__and2_1
Xq_SA0B hi 0 hi 0 0 vdd vdd q_SA0B sky130_fd_sc_hd__nand3_1
Xq_SA1B hi 0 0 0 vdd vdd q_SA1B sky130_fd_sc_hd__nand2_1
Xq_SA2B hi 0 q_s0n 0 0 vdd vdd q_SA2B sky130_fd_sc_hd__nand3_1
Xq_SB0B hi 0 0 0 vdd vdd q_SB0B sky130_fd_sc_hd__nand2_1
Xq_SB1B hi 0 0 0 vdd vdd q_SB1B sky130_fd_sc_hd__nand2_1
Xq_M q_ob q_SB0B q_SB1B q_REFB q_oa q_SA0B q_SA1B q_SA2B q_REFA vdd 0 q_VBIAS q_C1 q_PREA q_XA q_DUTA q_PREB q_XB q_DUTB q_VB 0 0 core

Cq_XAoa q_XA q_oa 3.4540e-17
Cq_XBob q_XB q_ob 3.3840e-17
Cq_XAXB q_XA q_XB 2.3370e-17
Vq_ag685 q_ag685 0 1.8
Vq_agin2 q_agin2 0 0
Vq_agin3 q_agin3 0 0
Cq_ag685ob q_ag685 q_ob 6.9200e-18
Cq_agin3oa q_agin3 q_oa 6.1390e-17
Cq_agin3ob q_agin3 q_ob 5.5900e-17
Cq_agin2oa q_agin2 q_oa 4.1100e-18
* --- a0: core
Xa0_ienn hi 0 0 vdd vdd a0_enn sky130_fd_sc_hd__inv_1
Xa0_is1n 0 0 0 vdd vdd a0_s1n sky130_fd_sc_hd__inv_1
Xa0_is0n hi 0 0 vdd vdd a0_s0n sky130_fd_sc_hd__inv_1
Xa0_PREA pre a0_enn 0 0 vdd vdd a0_PREA sky130_fd_sc_hd__nor2_1
Xa0_PREB pre a0_enn 0 0 vdd vdd a0_PREB sky130_fd_sc_hd__nor2_1
Xa0_VBIAS hi 0 0 vdd vdd a0_VBIAS sky130_fd_sc_hd__buf_2
Xa0_C1 hi 0 0 vdd vdd a0_C1 sky130_fd_sc_hd__buf_2
Xa0_DUTA hi a0_s1n hi 0 0 vdd vdd a0_DUTA sky130_fd_sc_hd__and3_1
Xa0_DUTB hi a0_s1n hi 0 0 vdd vdd a0_DUTB sky130_fd_sc_hd__and3_1
Xa0_REFA hi 0 0 0 vdd vdd a0_REFA sky130_fd_sc_hd__and2_1
Xa0_REFB hi 0 0 0 vdd vdd a0_REFB sky130_fd_sc_hd__and2_1
Xa0_SA0B hi 0 hi 0 0 vdd vdd a0_SA0B sky130_fd_sc_hd__nand3_1
Xa0_SA1B hi 0 0 0 vdd vdd a0_SA1B sky130_fd_sc_hd__nand2_1
Xa0_SA2B hi 0 a0_s0n 0 0 vdd vdd a0_SA2B sky130_fd_sc_hd__nand3_1
Xa0_SB0B hi 0 0 0 vdd vdd a0_SB0B sky130_fd_sc_hd__nand2_1
Xa0_SB1B hi 0 0 0 vdd vdd a0_SB1B sky130_fd_sc_hd__nand2_1
Xa0_M a0_ob a0_SB0B a0_SB1B a0_REFB a0_oa a0_SA0B a0_SA1B a0_SA2B a0_REFA vdd 0 a0_VBIAS a0_C1 a0_PREA a0_XA a0_DUTA a0_PREB a0_XB a0_DUTB a0_VB 0 0 core

Ca0_XAoa a0_XA a0_oa 3.4540e-17
Ca0_XBob a0_XB a0_ob 3.3840e-17
Ca0_XAXB a0_XA a0_XB 2.3370e-17
Va0_ag685 a0_ag685 0 pwl(0.000000e+00 1.8 1.140000e-06 1.8 1.140100e-06 0 1.300000e-06 0 1.300100e-06 1.8 1.460000e-06 1.8 1.460100e-06 0 1.620000e-06 0 1.620100e-06 1.8 1.780000e-06 1.8 1.780100e-06 0 1.940000e-06 0 1.940100e-06 1.8 2.100000e-06 1.8 2.100100e-06 0 2.260000e-06 0 2.260100e-06 1.8 2.420000e-06 1.8 2.420100e-06 0 2.580000e-06 0 2.580100e-06 1.8 2.740000e-06 1.8 2.740100e-06 0 2.900000e-06 0 2.900100e-06 1.8 3.060000e-06 1.8 3.060100e-06 0 3.220000e-06 0 3.220100e-06 1.8 3.380000e-06 1.8 3.380100e-06 0 3.540000e-06 0 3.540100e-06 1.8 3.700000e-06 1.8 3.700100e-06 0 3.860000e-06 0 3.860100e-06 1.8 4.020000e-06 1.8 4.020100e-06 0 4.180000e-06 0 4.180100e-06 1.8 4.340000e-06 1.8 4.340100e-06 0 4.500000e-06 0 4.500100e-06 1.8 4.660000e-06 1.8 4.660100e-06 0 4.820000e-06 0 4.820100e-06 1.8 4.980000e-06 1.8 4.980100e-06 0 5.140000e-06 0 5.140100e-06 1.8 5.300000e-06 1.8 5.300100e-06 0 5.460000e-06 0 5.460100e-06 1.8 5.620000e-06 1.8 5.620100e-06 0 5.780000e-06 0 5.780100e-06 1.8 5.940000e-06 1.8 5.940100e-06 0 6.100000e-06 0 6.100100e-06 1.8 6.260000e-06 1.8 6.260100e-06 0 6.420000e-06 0 6.420100e-06 1.8 6.580000e-06 1.8 6.580100e-06 0 6.740000e-06 0 6.740100e-06 1.8 6.900000e-06 1.8 6.900100e-06 0 7.060000e-06 0 7.060100e-06 1.8 7.220000e-06 1.8 7.220100e-06 0 7.380000e-06 0 7.380100e-06 1.8 7.540000e-06 1.8 7.540100e-06 0 7.700000e-06 0 7.700100e-06 1.8 7.860000e-06 1.8 7.860100e-06 0 8.020000e-06 0 8.020100e-06 1.8 8.180000e-06 1.8 8.180100e-06 0 8.340000e-06 0 8.340100e-06 1.8 8.500000e-06 1.8 8.500100e-06 0 8.660000e-06 0 8.660100e-06 1.8 8.820000e-06 1.8 8.820100e-06 0 8.980000e-06 0 8.980100e-06 1.8 9.140000e-06 1.8 9.140100e-06 0 9.300000e-06 0 9.300100e-06 1.8 9.460000e-06 1.8 9.460100e-06 0 9.620000e-06 0 9.620100e-06 1.8 9.780000e-06 1.8 9.780100e-06 0 9.940000e-06 0 9.940100e-06 1.8 1.010000e-05 1.8 1.010010e-05 0 1.026000e-05 0 1.026010e-05 1.8 1.042000e-05 1.8 1.042010e-05 0 1.058000e-05 0 1.058010e-05 1.8 1.074000e-05 1.8 1.074010e-05 0 1.090000e-05 0 1.090010e-05 1.8 1.106000e-05 1.8 1.106010e-05 0 1.122000e-05 0 1.122010e-05 1.8 1.138000e-05 1.8 1.138010e-05 0 1.154000e-05 0 1.154010e-05 1.8 1.170000e-05 1.8 1.170010e-05 0 1.186000e-05 0 1.186010e-05 1.8 1.202000e-05 1.8 1.202010e-05 0 1.218000e-05 0 1.218010e-05 1.8 1.234000e-05 1.8 1.234010e-05 0 1.250000e-05 0 1.250010e-05 1.8 1.266000e-05 1.8 1.266010e-05 0 1.282000e-05 0 1.282010e-05 1.8 1.298000e-05 1.8 1.298010e-05 0 1.314000e-05 0 1.314010e-05 1.8 1.330000e-05 1.8 1.330010e-05 0 1.346000e-05 0 1.346010e-05 1.8 1.362000e-05 1.8 1.362010e-05 0 1.378000e-05 0 1.378010e-05 1.8 1.394000e-05 1.8 1.394010e-05 0 1.410000e-05 0 1.410010e-05 1.8 1.426000e-05 1.8 1.426010e-05 0 1.442000e-05 0 1.442010e-05 1.8 1.458000e-05 1.8 1.458010e-05 0 1.474000e-05 0 1.474010e-05 1.8 1.490000e-05 1.8 1.490010e-05 0 1.506000e-05 0 1.506010e-05 1.8 1.522000e-05 1.8 1.522010e-05 0 1.538000e-05 0 1.538010e-05 1.8 1.554000e-05 1.8 1.554010e-05 0 1.570000e-05 0 1.570010e-05 1.8 1.586000e-05 1.8 1.586010e-05 0 1.602000e-05 0 1.602010e-05 1.8 1.618000e-05 1.8 1.618010e-05 0 1.634000e-05 0 1.634010e-05 1.8 1.650000e-05 1.8 1.650010e-05 0 1.666000e-05 0 1.666010e-05 1.8 1.682000e-05 1.8 1.682010e-05 0 1.698000e-05 0 1.698010e-05 1.8 1.714000e-05 1.8 1.714010e-05 0 1.730000e-05 0 1.730010e-05 1.8 1.746000e-05 1.8 1.746010e-05 0 1.762000e-05 0 1.762010e-05 1.8 1.778000e-05 1.8 1.778010e-05 0 1.794000e-05 0 1.794010e-05 1.8 1.810000e-05 1.8 1.810010e-05 0 1.826000e-05 0 1.826010e-05 1.8 1.842000e-05 1.8 1.842010e-05 0 1.858000e-05 0 1.858010e-05 1.8 1.874000e-05 1.8 1.874010e-05 0 1.890000e-05 0 1.890010e-05 1.8 1.906000e-05 1.8 1.906010e-05 0 1.922000e-05 0 1.922010e-05 1.8 1.938000e-05 1.8 1.938010e-05 0 1.954000e-05 0 1.954010e-05 1.8 1.970000e-05 1.8 1.970010e-05 0 1.986000e-05 0 1.986010e-05 1.8 2.002000e-05 1.8 2.002010e-05 0 2.018000e-05 0 2.018010e-05 1.8 2.034000e-05 1.8 2.034010e-05 0 2.050000e-05 0 2.050010e-05 1.8 2.066000e-05 1.8 2.066010e-05 0 2.082000e-05 0 2.082010e-05 1.8 2.098000e-05 1.8 2.098010e-05 0 2.114000e-05 0 2.114010e-05 1.8 2.130000e-05 1.8 2.130010e-05 0 2.146000e-05 0 2.146010e-05 1.8 2.162000e-05 1.8 2.162010e-05 0 2.178000e-05 0 2.178010e-05 1.8 2.194000e-05 1.8 2.194010e-05 0 2.210000e-05 0 2.210010e-05 1.8 2.226000e-05 1.8 2.226010e-05 0 2.242000e-05 0 2.242010e-05 1.8 2.258000e-05 1.8 2.258010e-05 0 2.274000e-05 0 2.274010e-05 1.8 2.290000e-05 1.8 2.290010e-05 0 2.306000e-05 0 2.306010e-05 1.8 2.322000e-05 1.8 2.322010e-05 0 2.338000e-05 0 2.338010e-05 1.8 2.354000e-05 1.8 2.354010e-05 0 2.370000e-05 0 2.370010e-05 1.8 2.386000e-05 1.8 2.386010e-05 0 2.402000e-05 0 2.402010e-05 1.8 2.418000e-05 1.8 2.418010e-05 0 2.434000e-05 0 2.434010e-05 1.8 2.450000e-05 1.8 2.450010e-05 0 2.466000e-05 0 2.466010e-05 1.8 2.482000e-05 1.8 2.482010e-05 0 2.498000e-05 0 2.498010e-05 1.8 2.514000e-05 1.8 2.514010e-05 0 2.530000e-05 0 2.530010e-05 1.8 2.546000e-05 1.8 2.546010e-05 0 2.562000e-05 0 2.562010e-05 1.8 2.578000e-05 1.8 2.578010e-05 0 2.594000e-05 0 2.594010e-05 1.8 2.610000e-05 1.8 2.610010e-05 0 2.626000e-05 0 2.626010e-05 1.8 2.642000e-05 1.8 2.642010e-05 0 2.658000e-05 0 2.658010e-05 1.8 2.674000e-05 1.8 2.674010e-05 0 2.690000e-05 0 2.690010e-05 1.8 2.706000e-05 1.8 2.706010e-05 0 2.722000e-05 0 2.722010e-05 1.8 2.738000e-05 1.8 2.738010e-05 0 2.754000e-05 0 2.754010e-05 1.8 2.770000e-05 1.8 2.770010e-05 0 2.786000e-05 0 2.786010e-05 1.8 2.802000e-05 1.8 2.802010e-05 0 2.818000e-05 0 2.818010e-05 1.8 2.834000e-05 1.8 2.834010e-05 0 2.850000e-05 0 2.850010e-05 1.8 2.866000e-05 1.8 2.866010e-05 0 2.882000e-05 0 2.882010e-05 1.8 2.898000e-05 1.8 2.898010e-05 0)
Va0_agin2 a0_agin2 0 pwl(0 0 4.317570000e-05 0 4.317580000e-05 1.8)
Va0_agin3 a0_agin3 0 pwl(0 0 4.316950000e-05 0 4.316960000e-05 1.8)
Ca0_ag685ob a0_ag685 a0_ob 6.9200e-18
Ca0_agin3oa a0_agin3 a0_oa 6.1390e-17
Ca0_agin3ob a0_agin3 a0_ob 5.5900e-17
Ca0_agin2oa a0_agin2 a0_oa 4.1100e-18
* --- a1: core
Xa1_ienn hi 0 0 vdd vdd a1_enn sky130_fd_sc_hd__inv_1
Xa1_is1n 0 0 0 vdd vdd a1_s1n sky130_fd_sc_hd__inv_1
Xa1_is0n hi 0 0 vdd vdd a1_s0n sky130_fd_sc_hd__inv_1
Xa1_PREA pre a1_enn 0 0 vdd vdd a1_PREA sky130_fd_sc_hd__nor2_1
Xa1_PREB pre a1_enn 0 0 vdd vdd a1_PREB sky130_fd_sc_hd__nor2_1
Xa1_VBIAS hi 0 0 vdd vdd a1_VBIAS sky130_fd_sc_hd__buf_2
Xa1_C1 hi 0 0 vdd vdd a1_C1 sky130_fd_sc_hd__buf_2
Xa1_DUTA hi a1_s1n hi 0 0 vdd vdd a1_DUTA sky130_fd_sc_hd__and3_1
Xa1_DUTB hi a1_s1n hi 0 0 vdd vdd a1_DUTB sky130_fd_sc_hd__and3_1
Xa1_REFA hi 0 0 0 vdd vdd a1_REFA sky130_fd_sc_hd__and2_1
Xa1_REFB hi 0 0 0 vdd vdd a1_REFB sky130_fd_sc_hd__and2_1
Xa1_SA0B hi 0 hi 0 0 vdd vdd a1_SA0B sky130_fd_sc_hd__nand3_1
Xa1_SA1B hi 0 0 0 vdd vdd a1_SA1B sky130_fd_sc_hd__nand2_1
Xa1_SA2B hi 0 a1_s0n 0 0 vdd vdd a1_SA2B sky130_fd_sc_hd__nand3_1
Xa1_SB0B hi 0 0 0 vdd vdd a1_SB0B sky130_fd_sc_hd__nand2_1
Xa1_SB1B hi 0 0 0 vdd vdd a1_SB1B sky130_fd_sc_hd__nand2_1
Xa1_M a1_ob a1_SB0B a1_SB1B a1_REFB a1_oa a1_SA0B a1_SA1B a1_SA2B a1_REFA vdd 0 a1_VBIAS a1_C1 a1_PREA a1_XA a1_DUTA a1_PREB a1_XB a1_DUTB a1_VB 0 0 core

Ca1_XAoa a1_XA a1_oa 3.4540e-17
Ca1_XBob a1_XB a1_ob 3.3840e-17
Ca1_XAXB a1_XA a1_XB 2.3370e-17
Va1_ag685 a1_ag685 0 pwl(0.000000e+00 1.8 1.144000e-06 1.8 1.144100e-06 0 1.304000e-06 0 1.304100e-06 1.8 1.464000e-06 1.8 1.464100e-06 0 1.624000e-06 0 1.624100e-06 1.8 1.784000e-06 1.8 1.784100e-06 0 1.944000e-06 0 1.944100e-06 1.8 2.104000e-06 1.8 2.104100e-06 0 2.264000e-06 0 2.264100e-06 1.8 2.424000e-06 1.8 2.424100e-06 0 2.584000e-06 0 2.584100e-06 1.8 2.744000e-06 1.8 2.744100e-06 0 2.904000e-06 0 2.904100e-06 1.8 3.064000e-06 1.8 3.064100e-06 0 3.224000e-06 0 3.224100e-06 1.8 3.384000e-06 1.8 3.384100e-06 0 3.544000e-06 0 3.544100e-06 1.8 3.704000e-06 1.8 3.704100e-06 0 3.864000e-06 0 3.864100e-06 1.8 4.024000e-06 1.8 4.024100e-06 0 4.184000e-06 0 4.184100e-06 1.8 4.344000e-06 1.8 4.344100e-06 0 4.504000e-06 0 4.504100e-06 1.8 4.664000e-06 1.8 4.664100e-06 0 4.824000e-06 0 4.824100e-06 1.8 4.984000e-06 1.8 4.984100e-06 0 5.144000e-06 0 5.144100e-06 1.8 5.304000e-06 1.8 5.304100e-06 0 5.464000e-06 0 5.464100e-06 1.8 5.624000e-06 1.8 5.624100e-06 0 5.784000e-06 0 5.784100e-06 1.8 5.944000e-06 1.8 5.944100e-06 0 6.104000e-06 0 6.104100e-06 1.8 6.264000e-06 1.8 6.264100e-06 0 6.424000e-06 0 6.424100e-06 1.8 6.584000e-06 1.8 6.584100e-06 0 6.744000e-06 0 6.744100e-06 1.8 6.904000e-06 1.8 6.904100e-06 0 7.064000e-06 0 7.064100e-06 1.8 7.224000e-06 1.8 7.224100e-06 0 7.384000e-06 0 7.384100e-06 1.8 7.544000e-06 1.8 7.544100e-06 0 7.704000e-06 0 7.704100e-06 1.8 7.864000e-06 1.8 7.864100e-06 0 8.024000e-06 0 8.024100e-06 1.8 8.184000e-06 1.8 8.184100e-06 0 8.344000e-06 0 8.344100e-06 1.8 8.504000e-06 1.8 8.504100e-06 0 8.664000e-06 0 8.664100e-06 1.8 8.824000e-06 1.8 8.824100e-06 0 8.984000e-06 0 8.984100e-06 1.8 9.144000e-06 1.8 9.144100e-06 0 9.304000e-06 0 9.304100e-06 1.8 9.464000e-06 1.8 9.464100e-06 0 9.624000e-06 0 9.624100e-06 1.8 9.784000e-06 1.8 9.784100e-06 0 9.944000e-06 0 9.944100e-06 1.8 1.010400e-05 1.8 1.010410e-05 0 1.026400e-05 0 1.026410e-05 1.8 1.042400e-05 1.8 1.042410e-05 0 1.058400e-05 0 1.058410e-05 1.8 1.074400e-05 1.8 1.074410e-05 0 1.090400e-05 0 1.090410e-05 1.8 1.106400e-05 1.8 1.106410e-05 0 1.122400e-05 0 1.122410e-05 1.8 1.138400e-05 1.8 1.138410e-05 0 1.154400e-05 0 1.154410e-05 1.8 1.170400e-05 1.8 1.170410e-05 0 1.186400e-05 0 1.186410e-05 1.8 1.202400e-05 1.8 1.202410e-05 0 1.218400e-05 0 1.218410e-05 1.8 1.234400e-05 1.8 1.234410e-05 0 1.250400e-05 0 1.250410e-05 1.8 1.266400e-05 1.8 1.266410e-05 0 1.282400e-05 0 1.282410e-05 1.8 1.298400e-05 1.8 1.298410e-05 0 1.314400e-05 0 1.314410e-05 1.8 1.330400e-05 1.8 1.330410e-05 0 1.346400e-05 0 1.346410e-05 1.8 1.362400e-05 1.8 1.362410e-05 0 1.378400e-05 0 1.378410e-05 1.8 1.394400e-05 1.8 1.394410e-05 0 1.410400e-05 0 1.410410e-05 1.8 1.426400e-05 1.8 1.426410e-05 0 1.442400e-05 0 1.442410e-05 1.8 1.458400e-05 1.8 1.458410e-05 0 1.474400e-05 0 1.474410e-05 1.8 1.490400e-05 1.8 1.490410e-05 0 1.506400e-05 0 1.506410e-05 1.8 1.522400e-05 1.8 1.522410e-05 0 1.538400e-05 0 1.538410e-05 1.8 1.554400e-05 1.8 1.554410e-05 0 1.570400e-05 0 1.570410e-05 1.8 1.586400e-05 1.8 1.586410e-05 0 1.602400e-05 0 1.602410e-05 1.8 1.618400e-05 1.8 1.618410e-05 0 1.634400e-05 0 1.634410e-05 1.8 1.650400e-05 1.8 1.650410e-05 0 1.666400e-05 0 1.666410e-05 1.8 1.682400e-05 1.8 1.682410e-05 0 1.698400e-05 0 1.698410e-05 1.8 1.714400e-05 1.8 1.714410e-05 0 1.730400e-05 0 1.730410e-05 1.8 1.746400e-05 1.8 1.746410e-05 0 1.762400e-05 0 1.762410e-05 1.8 1.778400e-05 1.8 1.778410e-05 0 1.794400e-05 0 1.794410e-05 1.8 1.810400e-05 1.8 1.810410e-05 0 1.826400e-05 0 1.826410e-05 1.8 1.842400e-05 1.8 1.842410e-05 0 1.858400e-05 0 1.858410e-05 1.8 1.874400e-05 1.8 1.874410e-05 0 1.890400e-05 0 1.890410e-05 1.8 1.906400e-05 1.8 1.906410e-05 0 1.922400e-05 0 1.922410e-05 1.8 1.938400e-05 1.8 1.938410e-05 0 1.954400e-05 0 1.954410e-05 1.8 1.970400e-05 1.8 1.970410e-05 0 1.986400e-05 0 1.986410e-05 1.8 2.002400e-05 1.8 2.002410e-05 0 2.018400e-05 0 2.018410e-05 1.8 2.034400e-05 1.8 2.034410e-05 0 2.050400e-05 0 2.050410e-05 1.8 2.066400e-05 1.8 2.066410e-05 0 2.082400e-05 0 2.082410e-05 1.8 2.098400e-05 1.8 2.098410e-05 0 2.114400e-05 0 2.114410e-05 1.8 2.130400e-05 1.8 2.130410e-05 0 2.146400e-05 0 2.146410e-05 1.8 2.162400e-05 1.8 2.162410e-05 0 2.178400e-05 0 2.178410e-05 1.8 2.194400e-05 1.8 2.194410e-05 0 2.210400e-05 0 2.210410e-05 1.8 2.226400e-05 1.8 2.226410e-05 0 2.242400e-05 0 2.242410e-05 1.8 2.258400e-05 1.8 2.258410e-05 0 2.274400e-05 0 2.274410e-05 1.8 2.290400e-05 1.8 2.290410e-05 0 2.306400e-05 0 2.306410e-05 1.8 2.322400e-05 1.8 2.322410e-05 0 2.338400e-05 0 2.338410e-05 1.8 2.354400e-05 1.8 2.354410e-05 0 2.370400e-05 0 2.370410e-05 1.8 2.386400e-05 1.8 2.386410e-05 0 2.402400e-05 0 2.402410e-05 1.8 2.418400e-05 1.8 2.418410e-05 0 2.434400e-05 0 2.434410e-05 1.8 2.450400e-05 1.8 2.450410e-05 0 2.466400e-05 0 2.466410e-05 1.8 2.482400e-05 1.8 2.482410e-05 0 2.498400e-05 0 2.498410e-05 1.8 2.514400e-05 1.8 2.514410e-05 0 2.530400e-05 0 2.530410e-05 1.8 2.546400e-05 1.8 2.546410e-05 0 2.562400e-05 0 2.562410e-05 1.8 2.578400e-05 1.8 2.578410e-05 0 2.594400e-05 0 2.594410e-05 1.8 2.610400e-05 1.8 2.610410e-05 0 2.626400e-05 0 2.626410e-05 1.8 2.642400e-05 1.8 2.642410e-05 0 2.658400e-05 0 2.658410e-05 1.8 2.674400e-05 1.8 2.674410e-05 0 2.690400e-05 0 2.690410e-05 1.8 2.706400e-05 1.8 2.706410e-05 0 2.722400e-05 0 2.722410e-05 1.8 2.738400e-05 1.8 2.738410e-05 0 2.754400e-05 0 2.754410e-05 1.8 2.770400e-05 1.8 2.770410e-05 0 2.786400e-05 0 2.786410e-05 1.8 2.802400e-05 1.8 2.802410e-05 0 2.818400e-05 0 2.818410e-05 1.8 2.834400e-05 1.8 2.834410e-05 0 2.850400e-05 0 2.850410e-05 1.8 2.866400e-05 1.8 2.866410e-05 0 2.882400e-05 0 2.882410e-05 1.8 2.898400e-05 1.8 2.898410e-05 0)
Va1_agin2 a1_agin2 0 pwl(0 0 4.317570000e-05 0 4.317580000e-05 1.8)
Va1_agin3 a1_agin3 0 pwl(0 0 4.316950000e-05 0 4.316960000e-05 1.8)
Ca1_ag685ob a1_ag685 a1_ob 6.9200e-18
Ca1_agin3oa a1_agin3 a1_oa 6.1390e-17
Ca1_agin3ob a1_agin3 a1_ob 5.5900e-17
Ca1_agin2oa a1_agin2 a1_oa 4.1100e-18
* --- a2: core
Xa2_ienn hi 0 0 vdd vdd a2_enn sky130_fd_sc_hd__inv_1
Xa2_is1n 0 0 0 vdd vdd a2_s1n sky130_fd_sc_hd__inv_1
Xa2_is0n hi 0 0 vdd vdd a2_s0n sky130_fd_sc_hd__inv_1
Xa2_PREA pre a2_enn 0 0 vdd vdd a2_PREA sky130_fd_sc_hd__nor2_1
Xa2_PREB pre a2_enn 0 0 vdd vdd a2_PREB sky130_fd_sc_hd__nor2_1
Xa2_VBIAS hi 0 0 vdd vdd a2_VBIAS sky130_fd_sc_hd__buf_2
Xa2_C1 hi 0 0 vdd vdd a2_C1 sky130_fd_sc_hd__buf_2
Xa2_DUTA hi a2_s1n hi 0 0 vdd vdd a2_DUTA sky130_fd_sc_hd__and3_1
Xa2_DUTB hi a2_s1n hi 0 0 vdd vdd a2_DUTB sky130_fd_sc_hd__and3_1
Xa2_REFA hi 0 0 0 vdd vdd a2_REFA sky130_fd_sc_hd__and2_1
Xa2_REFB hi 0 0 0 vdd vdd a2_REFB sky130_fd_sc_hd__and2_1
Xa2_SA0B hi 0 hi 0 0 vdd vdd a2_SA0B sky130_fd_sc_hd__nand3_1
Xa2_SA1B hi 0 0 0 vdd vdd a2_SA1B sky130_fd_sc_hd__nand2_1
Xa2_SA2B hi 0 a2_s0n 0 0 vdd vdd a2_SA2B sky130_fd_sc_hd__nand3_1
Xa2_SB0B hi 0 0 0 vdd vdd a2_SB0B sky130_fd_sc_hd__nand2_1
Xa2_SB1B hi 0 0 0 vdd vdd a2_SB1B sky130_fd_sc_hd__nand2_1
Xa2_M a2_ob a2_SB0B a2_SB1B a2_REFB a2_oa a2_SA0B a2_SA1B a2_SA2B a2_REFA vdd 0 a2_VBIAS a2_C1 a2_PREA a2_XA a2_DUTA a2_PREB a2_XB a2_DUTB a2_VB 0 0 core

Ca2_XAoa a2_XA a2_oa 3.4540e-17
Ca2_XBob a2_XB a2_ob 3.3840e-17
Ca2_XAXB a2_XA a2_XB 2.3370e-17
Va2_ag685 a2_ag685 0 pwl(0.000000e+00 1.8 1.148000e-06 1.8 1.148100e-06 0 1.308000e-06 0 1.308100e-06 1.8 1.468000e-06 1.8 1.468100e-06 0 1.628000e-06 0 1.628100e-06 1.8 1.788000e-06 1.8 1.788100e-06 0 1.948000e-06 0 1.948100e-06 1.8 2.108000e-06 1.8 2.108100e-06 0 2.268000e-06 0 2.268100e-06 1.8 2.428000e-06 1.8 2.428100e-06 0 2.588000e-06 0 2.588100e-06 1.8 2.748000e-06 1.8 2.748100e-06 0 2.908000e-06 0 2.908100e-06 1.8 3.068000e-06 1.8 3.068100e-06 0 3.228000e-06 0 3.228100e-06 1.8 3.388000e-06 1.8 3.388100e-06 0 3.548000e-06 0 3.548100e-06 1.8 3.708000e-06 1.8 3.708100e-06 0 3.868000e-06 0 3.868100e-06 1.8 4.028000e-06 1.8 4.028100e-06 0 4.188000e-06 0 4.188100e-06 1.8 4.348000e-06 1.8 4.348100e-06 0 4.508000e-06 0 4.508100e-06 1.8 4.668000e-06 1.8 4.668100e-06 0 4.828000e-06 0 4.828100e-06 1.8 4.988000e-06 1.8 4.988100e-06 0 5.148000e-06 0 5.148100e-06 1.8 5.308000e-06 1.8 5.308100e-06 0 5.468000e-06 0 5.468100e-06 1.8 5.628000e-06 1.8 5.628100e-06 0 5.788000e-06 0 5.788100e-06 1.8 5.948000e-06 1.8 5.948100e-06 0 6.108000e-06 0 6.108100e-06 1.8 6.268000e-06 1.8 6.268100e-06 0 6.428000e-06 0 6.428100e-06 1.8 6.588000e-06 1.8 6.588100e-06 0 6.748000e-06 0 6.748100e-06 1.8 6.908000e-06 1.8 6.908100e-06 0 7.068000e-06 0 7.068100e-06 1.8 7.228000e-06 1.8 7.228100e-06 0 7.388000e-06 0 7.388100e-06 1.8 7.548000e-06 1.8 7.548100e-06 0 7.708000e-06 0 7.708100e-06 1.8 7.868000e-06 1.8 7.868100e-06 0 8.028000e-06 0 8.028100e-06 1.8 8.188000e-06 1.8 8.188100e-06 0 8.348000e-06 0 8.348100e-06 1.8 8.508000e-06 1.8 8.508100e-06 0 8.668000e-06 0 8.668100e-06 1.8 8.828000e-06 1.8 8.828100e-06 0 8.988000e-06 0 8.988100e-06 1.8 9.148000e-06 1.8 9.148100e-06 0 9.308000e-06 0 9.308100e-06 1.8 9.468000e-06 1.8 9.468100e-06 0 9.628000e-06 0 9.628100e-06 1.8 9.788000e-06 1.8 9.788100e-06 0 9.948000e-06 0 9.948100e-06 1.8 1.010800e-05 1.8 1.010810e-05 0 1.026800e-05 0 1.026810e-05 1.8 1.042800e-05 1.8 1.042810e-05 0 1.058800e-05 0 1.058810e-05 1.8 1.074800e-05 1.8 1.074810e-05 0 1.090800e-05 0 1.090810e-05 1.8 1.106800e-05 1.8 1.106810e-05 0 1.122800e-05 0 1.122810e-05 1.8 1.138800e-05 1.8 1.138810e-05 0 1.154800e-05 0 1.154810e-05 1.8 1.170800e-05 1.8 1.170810e-05 0 1.186800e-05 0 1.186810e-05 1.8 1.202800e-05 1.8 1.202810e-05 0 1.218800e-05 0 1.218810e-05 1.8 1.234800e-05 1.8 1.234810e-05 0 1.250800e-05 0 1.250810e-05 1.8 1.266800e-05 1.8 1.266810e-05 0 1.282800e-05 0 1.282810e-05 1.8 1.298800e-05 1.8 1.298810e-05 0 1.314800e-05 0 1.314810e-05 1.8 1.330800e-05 1.8 1.330810e-05 0 1.346800e-05 0 1.346810e-05 1.8 1.362800e-05 1.8 1.362810e-05 0 1.378800e-05 0 1.378810e-05 1.8 1.394800e-05 1.8 1.394810e-05 0 1.410800e-05 0 1.410810e-05 1.8 1.426800e-05 1.8 1.426810e-05 0 1.442800e-05 0 1.442810e-05 1.8 1.458800e-05 1.8 1.458810e-05 0 1.474800e-05 0 1.474810e-05 1.8 1.490800e-05 1.8 1.490810e-05 0 1.506800e-05 0 1.506810e-05 1.8 1.522800e-05 1.8 1.522810e-05 0 1.538800e-05 0 1.538810e-05 1.8 1.554800e-05 1.8 1.554810e-05 0 1.570800e-05 0 1.570810e-05 1.8 1.586800e-05 1.8 1.586810e-05 0 1.602800e-05 0 1.602810e-05 1.8 1.618800e-05 1.8 1.618810e-05 0 1.634800e-05 0 1.634810e-05 1.8 1.650800e-05 1.8 1.650810e-05 0 1.666800e-05 0 1.666810e-05 1.8 1.682800e-05 1.8 1.682810e-05 0 1.698800e-05 0 1.698810e-05 1.8 1.714800e-05 1.8 1.714810e-05 0 1.730800e-05 0 1.730810e-05 1.8 1.746800e-05 1.8 1.746810e-05 0 1.762800e-05 0 1.762810e-05 1.8 1.778800e-05 1.8 1.778810e-05 0 1.794800e-05 0 1.794810e-05 1.8 1.810800e-05 1.8 1.810810e-05 0 1.826800e-05 0 1.826810e-05 1.8 1.842800e-05 1.8 1.842810e-05 0 1.858800e-05 0 1.858810e-05 1.8 1.874800e-05 1.8 1.874810e-05 0 1.890800e-05 0 1.890810e-05 1.8 1.906800e-05 1.8 1.906810e-05 0 1.922800e-05 0 1.922810e-05 1.8 1.938800e-05 1.8 1.938810e-05 0 1.954800e-05 0 1.954810e-05 1.8 1.970800e-05 1.8 1.970810e-05 0 1.986800e-05 0 1.986810e-05 1.8 2.002800e-05 1.8 2.002810e-05 0 2.018800e-05 0 2.018810e-05 1.8 2.034800e-05 1.8 2.034810e-05 0 2.050800e-05 0 2.050810e-05 1.8 2.066800e-05 1.8 2.066810e-05 0 2.082800e-05 0 2.082810e-05 1.8 2.098800e-05 1.8 2.098810e-05 0 2.114800e-05 0 2.114810e-05 1.8 2.130800e-05 1.8 2.130810e-05 0 2.146800e-05 0 2.146810e-05 1.8 2.162800e-05 1.8 2.162810e-05 0 2.178800e-05 0 2.178810e-05 1.8 2.194800e-05 1.8 2.194810e-05 0 2.210800e-05 0 2.210810e-05 1.8 2.226800e-05 1.8 2.226810e-05 0 2.242800e-05 0 2.242810e-05 1.8 2.258800e-05 1.8 2.258810e-05 0 2.274800e-05 0 2.274810e-05 1.8 2.290800e-05 1.8 2.290810e-05 0 2.306800e-05 0 2.306810e-05 1.8 2.322800e-05 1.8 2.322810e-05 0 2.338800e-05 0 2.338810e-05 1.8 2.354800e-05 1.8 2.354810e-05 0 2.370800e-05 0 2.370810e-05 1.8 2.386800e-05 1.8 2.386810e-05 0 2.402800e-05 0 2.402810e-05 1.8 2.418800e-05 1.8 2.418810e-05 0 2.434800e-05 0 2.434810e-05 1.8 2.450800e-05 1.8 2.450810e-05 0 2.466800e-05 0 2.466810e-05 1.8 2.482800e-05 1.8 2.482810e-05 0 2.498800e-05 0 2.498810e-05 1.8 2.514800e-05 1.8 2.514810e-05 0 2.530800e-05 0 2.530810e-05 1.8 2.546800e-05 1.8 2.546810e-05 0 2.562800e-05 0 2.562810e-05 1.8 2.578800e-05 1.8 2.578810e-05 0 2.594800e-05 0 2.594810e-05 1.8 2.610800e-05 1.8 2.610810e-05 0 2.626800e-05 0 2.626810e-05 1.8 2.642800e-05 1.8 2.642810e-05 0 2.658800e-05 0 2.658810e-05 1.8 2.674800e-05 1.8 2.674810e-05 0 2.690800e-05 0 2.690810e-05 1.8 2.706800e-05 1.8 2.706810e-05 0 2.722800e-05 0 2.722810e-05 1.8 2.738800e-05 1.8 2.738810e-05 0 2.754800e-05 0 2.754810e-05 1.8 2.770800e-05 1.8 2.770810e-05 0 2.786800e-05 0 2.786810e-05 1.8 2.802800e-05 1.8 2.802810e-05 0 2.818800e-05 0 2.818810e-05 1.8 2.834800e-05 1.8 2.834810e-05 0 2.850800e-05 0 2.850810e-05 1.8 2.866800e-05 1.8 2.866810e-05 0 2.882800e-05 0 2.882810e-05 1.8 2.898800e-05 1.8 2.898810e-05 0)
Va2_agin2 a2_agin2 0 pwl(0 0 4.317570000e-05 0 4.317580000e-05 1.8)
Va2_agin3 a2_agin3 0 pwl(0 0 4.316950000e-05 0 4.316960000e-05 1.8)
Ca2_ag685ob a2_ag685 a2_ob 6.9200e-18
Ca2_agin3oa a2_agin3 a2_oa 6.1390e-17
Ca2_agin3ob a2_agin3 a2_ob 5.5900e-17
Ca2_agin2oa a2_agin2 a2_oa 4.1100e-18
* --- a3: core
Xa3_ienn hi 0 0 vdd vdd a3_enn sky130_fd_sc_hd__inv_1
Xa3_is1n 0 0 0 vdd vdd a3_s1n sky130_fd_sc_hd__inv_1
Xa3_is0n hi 0 0 vdd vdd a3_s0n sky130_fd_sc_hd__inv_1
Xa3_PREA pre a3_enn 0 0 vdd vdd a3_PREA sky130_fd_sc_hd__nor2_1
Xa3_PREB pre a3_enn 0 0 vdd vdd a3_PREB sky130_fd_sc_hd__nor2_1
Xa3_VBIAS hi 0 0 vdd vdd a3_VBIAS sky130_fd_sc_hd__buf_2
Xa3_C1 hi 0 0 vdd vdd a3_C1 sky130_fd_sc_hd__buf_2
Xa3_DUTA hi a3_s1n hi 0 0 vdd vdd a3_DUTA sky130_fd_sc_hd__and3_1
Xa3_DUTB hi a3_s1n hi 0 0 vdd vdd a3_DUTB sky130_fd_sc_hd__and3_1
Xa3_REFA hi 0 0 0 vdd vdd a3_REFA sky130_fd_sc_hd__and2_1
Xa3_REFB hi 0 0 0 vdd vdd a3_REFB sky130_fd_sc_hd__and2_1
Xa3_SA0B hi 0 hi 0 0 vdd vdd a3_SA0B sky130_fd_sc_hd__nand3_1
Xa3_SA1B hi 0 0 0 vdd vdd a3_SA1B sky130_fd_sc_hd__nand2_1
Xa3_SA2B hi 0 a3_s0n 0 0 vdd vdd a3_SA2B sky130_fd_sc_hd__nand3_1
Xa3_SB0B hi 0 0 0 vdd vdd a3_SB0B sky130_fd_sc_hd__nand2_1
Xa3_SB1B hi 0 0 0 vdd vdd a3_SB1B sky130_fd_sc_hd__nand2_1
Xa3_M a3_ob a3_SB0B a3_SB1B a3_REFB a3_oa a3_SA0B a3_SA1B a3_SA2B a3_REFA vdd 0 a3_VBIAS a3_C1 a3_PREA a3_XA a3_DUTA a3_PREB a3_XB a3_DUTB a3_VB 0 0 core

Ca3_XAoa a3_XA a3_oa 3.4540e-17
Ca3_XBob a3_XB a3_ob 3.3840e-17
Ca3_XAXB a3_XA a3_XB 2.3370e-17
Va3_ag685 a3_ag685 0 pwl(0.000000e+00 1.8 1.152000e-06 1.8 1.152100e-06 0 1.312000e-06 0 1.312100e-06 1.8 1.472000e-06 1.8 1.472100e-06 0 1.632000e-06 0 1.632100e-06 1.8 1.792000e-06 1.8 1.792100e-06 0 1.952000e-06 0 1.952100e-06 1.8 2.112000e-06 1.8 2.112100e-06 0 2.272000e-06 0 2.272100e-06 1.8 2.432000e-06 1.8 2.432100e-06 0 2.592000e-06 0 2.592100e-06 1.8 2.752000e-06 1.8 2.752100e-06 0 2.912000e-06 0 2.912100e-06 1.8 3.072000e-06 1.8 3.072100e-06 0 3.232000e-06 0 3.232100e-06 1.8 3.392000e-06 1.8 3.392100e-06 0 3.552000e-06 0 3.552100e-06 1.8 3.712000e-06 1.8 3.712100e-06 0 3.872000e-06 0 3.872100e-06 1.8 4.032000e-06 1.8 4.032100e-06 0 4.192000e-06 0 4.192100e-06 1.8 4.352000e-06 1.8 4.352100e-06 0 4.512000e-06 0 4.512100e-06 1.8 4.672000e-06 1.8 4.672100e-06 0 4.832000e-06 0 4.832100e-06 1.8 4.992000e-06 1.8 4.992100e-06 0 5.152000e-06 0 5.152100e-06 1.8 5.312000e-06 1.8 5.312100e-06 0 5.472000e-06 0 5.472100e-06 1.8 5.632000e-06 1.8 5.632100e-06 0 5.792000e-06 0 5.792100e-06 1.8 5.952000e-06 1.8 5.952100e-06 0 6.112000e-06 0 6.112100e-06 1.8 6.272000e-06 1.8 6.272100e-06 0 6.432000e-06 0 6.432100e-06 1.8 6.592000e-06 1.8 6.592100e-06 0 6.752000e-06 0 6.752100e-06 1.8 6.912000e-06 1.8 6.912100e-06 0 7.072000e-06 0 7.072100e-06 1.8 7.232000e-06 1.8 7.232100e-06 0 7.392000e-06 0 7.392100e-06 1.8 7.552000e-06 1.8 7.552100e-06 0 7.712000e-06 0 7.712100e-06 1.8 7.872000e-06 1.8 7.872100e-06 0 8.032000e-06 0 8.032100e-06 1.8 8.192000e-06 1.8 8.192100e-06 0 8.352000e-06 0 8.352100e-06 1.8 8.512000e-06 1.8 8.512100e-06 0 8.672000e-06 0 8.672100e-06 1.8 8.832000e-06 1.8 8.832100e-06 0 8.992000e-06 0 8.992100e-06 1.8 9.152000e-06 1.8 9.152100e-06 0 9.312000e-06 0 9.312100e-06 1.8 9.472000e-06 1.8 9.472100e-06 0 9.632000e-06 0 9.632100e-06 1.8 9.792000e-06 1.8 9.792100e-06 0 9.952000e-06 0 9.952100e-06 1.8 1.011200e-05 1.8 1.011210e-05 0 1.027200e-05 0 1.027210e-05 1.8 1.043200e-05 1.8 1.043210e-05 0 1.059200e-05 0 1.059210e-05 1.8 1.075200e-05 1.8 1.075210e-05 0 1.091200e-05 0 1.091210e-05 1.8 1.107200e-05 1.8 1.107210e-05 0 1.123200e-05 0 1.123210e-05 1.8 1.139200e-05 1.8 1.139210e-05 0 1.155200e-05 0 1.155210e-05 1.8 1.171200e-05 1.8 1.171210e-05 0 1.187200e-05 0 1.187210e-05 1.8 1.203200e-05 1.8 1.203210e-05 0 1.219200e-05 0 1.219210e-05 1.8 1.235200e-05 1.8 1.235210e-05 0 1.251200e-05 0 1.251210e-05 1.8 1.267200e-05 1.8 1.267210e-05 0 1.283200e-05 0 1.283210e-05 1.8 1.299200e-05 1.8 1.299210e-05 0 1.315200e-05 0 1.315210e-05 1.8 1.331200e-05 1.8 1.331210e-05 0 1.347200e-05 0 1.347210e-05 1.8 1.363200e-05 1.8 1.363210e-05 0 1.379200e-05 0 1.379210e-05 1.8 1.395200e-05 1.8 1.395210e-05 0 1.411200e-05 0 1.411210e-05 1.8 1.427200e-05 1.8 1.427210e-05 0 1.443200e-05 0 1.443210e-05 1.8 1.459200e-05 1.8 1.459210e-05 0 1.475200e-05 0 1.475210e-05 1.8 1.491200e-05 1.8 1.491210e-05 0 1.507200e-05 0 1.507210e-05 1.8 1.523200e-05 1.8 1.523210e-05 0 1.539200e-05 0 1.539210e-05 1.8 1.555200e-05 1.8 1.555210e-05 0 1.571200e-05 0 1.571210e-05 1.8 1.587200e-05 1.8 1.587210e-05 0 1.603200e-05 0 1.603210e-05 1.8 1.619200e-05 1.8 1.619210e-05 0 1.635200e-05 0 1.635210e-05 1.8 1.651200e-05 1.8 1.651210e-05 0 1.667200e-05 0 1.667210e-05 1.8 1.683200e-05 1.8 1.683210e-05 0 1.699200e-05 0 1.699210e-05 1.8 1.715200e-05 1.8 1.715210e-05 0 1.731200e-05 0 1.731210e-05 1.8 1.747200e-05 1.8 1.747210e-05 0 1.763200e-05 0 1.763210e-05 1.8 1.779200e-05 1.8 1.779210e-05 0 1.795200e-05 0 1.795210e-05 1.8 1.811200e-05 1.8 1.811210e-05 0 1.827200e-05 0 1.827210e-05 1.8 1.843200e-05 1.8 1.843210e-05 0 1.859200e-05 0 1.859210e-05 1.8 1.875200e-05 1.8 1.875210e-05 0 1.891200e-05 0 1.891210e-05 1.8 1.907200e-05 1.8 1.907210e-05 0 1.923200e-05 0 1.923210e-05 1.8 1.939200e-05 1.8 1.939210e-05 0 1.955200e-05 0 1.955210e-05 1.8 1.971200e-05 1.8 1.971210e-05 0 1.987200e-05 0 1.987210e-05 1.8 2.003200e-05 1.8 2.003210e-05 0 2.019200e-05 0 2.019210e-05 1.8 2.035200e-05 1.8 2.035210e-05 0 2.051200e-05 0 2.051210e-05 1.8 2.067200e-05 1.8 2.067210e-05 0 2.083200e-05 0 2.083210e-05 1.8 2.099200e-05 1.8 2.099210e-05 0 2.115200e-05 0 2.115210e-05 1.8 2.131200e-05 1.8 2.131210e-05 0 2.147200e-05 0 2.147210e-05 1.8 2.163200e-05 1.8 2.163210e-05 0 2.179200e-05 0 2.179210e-05 1.8 2.195200e-05 1.8 2.195210e-05 0 2.211200e-05 0 2.211210e-05 1.8 2.227200e-05 1.8 2.227210e-05 0 2.243200e-05 0 2.243210e-05 1.8 2.259200e-05 1.8 2.259210e-05 0 2.275200e-05 0 2.275210e-05 1.8 2.291200e-05 1.8 2.291210e-05 0 2.307200e-05 0 2.307210e-05 1.8 2.323200e-05 1.8 2.323210e-05 0 2.339200e-05 0 2.339210e-05 1.8 2.355200e-05 1.8 2.355210e-05 0 2.371200e-05 0 2.371210e-05 1.8 2.387200e-05 1.8 2.387210e-05 0 2.403200e-05 0 2.403210e-05 1.8 2.419200e-05 1.8 2.419210e-05 0 2.435200e-05 0 2.435210e-05 1.8 2.451200e-05 1.8 2.451210e-05 0 2.467200e-05 0 2.467210e-05 1.8 2.483200e-05 1.8 2.483210e-05 0 2.499200e-05 0 2.499210e-05 1.8 2.515200e-05 1.8 2.515210e-05 0 2.531200e-05 0 2.531210e-05 1.8 2.547200e-05 1.8 2.547210e-05 0 2.563200e-05 0 2.563210e-05 1.8 2.579200e-05 1.8 2.579210e-05 0 2.595200e-05 0 2.595210e-05 1.8 2.611200e-05 1.8 2.611210e-05 0 2.627200e-05 0 2.627210e-05 1.8 2.643200e-05 1.8 2.643210e-05 0 2.659200e-05 0 2.659210e-05 1.8 2.675200e-05 1.8 2.675210e-05 0 2.691200e-05 0 2.691210e-05 1.8 2.707200e-05 1.8 2.707210e-05 0 2.723200e-05 0 2.723210e-05 1.8 2.739200e-05 1.8 2.739210e-05 0 2.755200e-05 0 2.755210e-05 1.8 2.771200e-05 1.8 2.771210e-05 0 2.787200e-05 0 2.787210e-05 1.8 2.803200e-05 1.8 2.803210e-05 0 2.819200e-05 0 2.819210e-05 1.8 2.835200e-05 1.8 2.835210e-05 0 2.851200e-05 0 2.851210e-05 1.8 2.867200e-05 1.8 2.867210e-05 0 2.883200e-05 0 2.883210e-05 1.8 2.899200e-05 1.8 2.899210e-05 0)
Va3_agin2 a3_agin2 0 pwl(0 0 4.317570000e-05 0 4.317580000e-05 1.8)
Va3_agin3 a3_agin3 0 pwl(0 0 4.316950000e-05 0 4.316960000e-05 1.8)
Ca3_ag685ob a3_ag685 a3_ob 6.9200e-18
Ca3_agin3oa a3_agin3 a3_oa 6.1390e-17
Ca3_agin3ob a3_agin3 a3_ob 5.5900e-17
Ca3_agin2oa a3_agin2 a3_oa 4.1100e-18
* --- a4: core
Xa4_ienn hi 0 0 vdd vdd a4_enn sky130_fd_sc_hd__inv_1
Xa4_is1n 0 0 0 vdd vdd a4_s1n sky130_fd_sc_hd__inv_1
Xa4_is0n hi 0 0 vdd vdd a4_s0n sky130_fd_sc_hd__inv_1
Xa4_PREA pre a4_enn 0 0 vdd vdd a4_PREA sky130_fd_sc_hd__nor2_1
Xa4_PREB pre a4_enn 0 0 vdd vdd a4_PREB sky130_fd_sc_hd__nor2_1
Xa4_VBIAS hi 0 0 vdd vdd a4_VBIAS sky130_fd_sc_hd__buf_2
Xa4_C1 hi 0 0 vdd vdd a4_C1 sky130_fd_sc_hd__buf_2
Xa4_DUTA hi a4_s1n hi 0 0 vdd vdd a4_DUTA sky130_fd_sc_hd__and3_1
Xa4_DUTB hi a4_s1n hi 0 0 vdd vdd a4_DUTB sky130_fd_sc_hd__and3_1
Xa4_REFA hi 0 0 0 vdd vdd a4_REFA sky130_fd_sc_hd__and2_1
Xa4_REFB hi 0 0 0 vdd vdd a4_REFB sky130_fd_sc_hd__and2_1
Xa4_SA0B hi 0 hi 0 0 vdd vdd a4_SA0B sky130_fd_sc_hd__nand3_1
Xa4_SA1B hi 0 0 0 vdd vdd a4_SA1B sky130_fd_sc_hd__nand2_1
Xa4_SA2B hi 0 a4_s0n 0 0 vdd vdd a4_SA2B sky130_fd_sc_hd__nand3_1
Xa4_SB0B hi 0 0 0 vdd vdd a4_SB0B sky130_fd_sc_hd__nand2_1
Xa4_SB1B hi 0 0 0 vdd vdd a4_SB1B sky130_fd_sc_hd__nand2_1
Xa4_M a4_ob a4_SB0B a4_SB1B a4_REFB a4_oa a4_SA0B a4_SA1B a4_SA2B a4_REFA vdd 0 a4_VBIAS a4_C1 a4_PREA a4_XA a4_DUTA a4_PREB a4_XB a4_DUTB a4_VB 0 0 core

Ca4_XAoa a4_XA a4_oa 3.4540e-17
Ca4_XBob a4_XB a4_ob 3.3840e-17
Ca4_XAXB a4_XA a4_XB 2.3370e-17
Va4_ag685 a4_ag685 0 pwl(0.000000e+00 1.8 1.156000e-06 1.8 1.156100e-06 0 1.316000e-06 0 1.316100e-06 1.8 1.476000e-06 1.8 1.476100e-06 0 1.636000e-06 0 1.636100e-06 1.8 1.796000e-06 1.8 1.796100e-06 0 1.956000e-06 0 1.956100e-06 1.8 2.116000e-06 1.8 2.116100e-06 0 2.276000e-06 0 2.276100e-06 1.8 2.436000e-06 1.8 2.436100e-06 0 2.596000e-06 0 2.596100e-06 1.8 2.756000e-06 1.8 2.756100e-06 0 2.916000e-06 0 2.916100e-06 1.8 3.076000e-06 1.8 3.076100e-06 0 3.236000e-06 0 3.236100e-06 1.8 3.396000e-06 1.8 3.396100e-06 0 3.556000e-06 0 3.556100e-06 1.8 3.716000e-06 1.8 3.716100e-06 0 3.876000e-06 0 3.876100e-06 1.8 4.036000e-06 1.8 4.036100e-06 0 4.196000e-06 0 4.196100e-06 1.8 4.356000e-06 1.8 4.356100e-06 0 4.516000e-06 0 4.516100e-06 1.8 4.676000e-06 1.8 4.676100e-06 0 4.836000e-06 0 4.836100e-06 1.8 4.996000e-06 1.8 4.996100e-06 0 5.156000e-06 0 5.156100e-06 1.8 5.316000e-06 1.8 5.316100e-06 0 5.476000e-06 0 5.476100e-06 1.8 5.636000e-06 1.8 5.636100e-06 0 5.796000e-06 0 5.796100e-06 1.8 5.956000e-06 1.8 5.956100e-06 0 6.116000e-06 0 6.116100e-06 1.8 6.276000e-06 1.8 6.276100e-06 0 6.436000e-06 0 6.436100e-06 1.8 6.596000e-06 1.8 6.596100e-06 0 6.756000e-06 0 6.756100e-06 1.8 6.916000e-06 1.8 6.916100e-06 0 7.076000e-06 0 7.076100e-06 1.8 7.236000e-06 1.8 7.236100e-06 0 7.396000e-06 0 7.396100e-06 1.8 7.556000e-06 1.8 7.556100e-06 0 7.716000e-06 0 7.716100e-06 1.8 7.876000e-06 1.8 7.876100e-06 0 8.036000e-06 0 8.036100e-06 1.8 8.196000e-06 1.8 8.196100e-06 0 8.356000e-06 0 8.356100e-06 1.8 8.516000e-06 1.8 8.516100e-06 0 8.676000e-06 0 8.676100e-06 1.8 8.836000e-06 1.8 8.836100e-06 0 8.996000e-06 0 8.996100e-06 1.8 9.156000e-06 1.8 9.156100e-06 0 9.316000e-06 0 9.316100e-06 1.8 9.476000e-06 1.8 9.476100e-06 0 9.636000e-06 0 9.636100e-06 1.8 9.796000e-06 1.8 9.796100e-06 0 9.956000e-06 0 9.956100e-06 1.8 1.011600e-05 1.8 1.011610e-05 0 1.027600e-05 0 1.027610e-05 1.8 1.043600e-05 1.8 1.043610e-05 0 1.059600e-05 0 1.059610e-05 1.8 1.075600e-05 1.8 1.075610e-05 0 1.091600e-05 0 1.091610e-05 1.8 1.107600e-05 1.8 1.107610e-05 0 1.123600e-05 0 1.123610e-05 1.8 1.139600e-05 1.8 1.139610e-05 0 1.155600e-05 0 1.155610e-05 1.8 1.171600e-05 1.8 1.171610e-05 0 1.187600e-05 0 1.187610e-05 1.8 1.203600e-05 1.8 1.203610e-05 0 1.219600e-05 0 1.219610e-05 1.8 1.235600e-05 1.8 1.235610e-05 0 1.251600e-05 0 1.251610e-05 1.8 1.267600e-05 1.8 1.267610e-05 0 1.283600e-05 0 1.283610e-05 1.8 1.299600e-05 1.8 1.299610e-05 0 1.315600e-05 0 1.315610e-05 1.8 1.331600e-05 1.8 1.331610e-05 0 1.347600e-05 0 1.347610e-05 1.8 1.363600e-05 1.8 1.363610e-05 0 1.379600e-05 0 1.379610e-05 1.8 1.395600e-05 1.8 1.395610e-05 0 1.411600e-05 0 1.411610e-05 1.8 1.427600e-05 1.8 1.427610e-05 0 1.443600e-05 0 1.443610e-05 1.8 1.459600e-05 1.8 1.459610e-05 0 1.475600e-05 0 1.475610e-05 1.8 1.491600e-05 1.8 1.491610e-05 0 1.507600e-05 0 1.507610e-05 1.8 1.523600e-05 1.8 1.523610e-05 0 1.539600e-05 0 1.539610e-05 1.8 1.555600e-05 1.8 1.555610e-05 0 1.571600e-05 0 1.571610e-05 1.8 1.587600e-05 1.8 1.587610e-05 0 1.603600e-05 0 1.603610e-05 1.8 1.619600e-05 1.8 1.619610e-05 0 1.635600e-05 0 1.635610e-05 1.8 1.651600e-05 1.8 1.651610e-05 0 1.667600e-05 0 1.667610e-05 1.8 1.683600e-05 1.8 1.683610e-05 0 1.699600e-05 0 1.699610e-05 1.8 1.715600e-05 1.8 1.715610e-05 0 1.731600e-05 0 1.731610e-05 1.8 1.747600e-05 1.8 1.747610e-05 0 1.763600e-05 0 1.763610e-05 1.8 1.779600e-05 1.8 1.779610e-05 0 1.795600e-05 0 1.795610e-05 1.8 1.811600e-05 1.8 1.811610e-05 0 1.827600e-05 0 1.827610e-05 1.8 1.843600e-05 1.8 1.843610e-05 0 1.859600e-05 0 1.859610e-05 1.8 1.875600e-05 1.8 1.875610e-05 0 1.891600e-05 0 1.891610e-05 1.8 1.907600e-05 1.8 1.907610e-05 0 1.923600e-05 0 1.923610e-05 1.8 1.939600e-05 1.8 1.939610e-05 0 1.955600e-05 0 1.955610e-05 1.8 1.971600e-05 1.8 1.971610e-05 0 1.987600e-05 0 1.987610e-05 1.8 2.003600e-05 1.8 2.003610e-05 0 2.019600e-05 0 2.019610e-05 1.8 2.035600e-05 1.8 2.035610e-05 0 2.051600e-05 0 2.051610e-05 1.8 2.067600e-05 1.8 2.067610e-05 0 2.083600e-05 0 2.083610e-05 1.8 2.099600e-05 1.8 2.099610e-05 0 2.115600e-05 0 2.115610e-05 1.8 2.131600e-05 1.8 2.131610e-05 0 2.147600e-05 0 2.147610e-05 1.8 2.163600e-05 1.8 2.163610e-05 0 2.179600e-05 0 2.179610e-05 1.8 2.195600e-05 1.8 2.195610e-05 0 2.211600e-05 0 2.211610e-05 1.8 2.227600e-05 1.8 2.227610e-05 0 2.243600e-05 0 2.243610e-05 1.8 2.259600e-05 1.8 2.259610e-05 0 2.275600e-05 0 2.275610e-05 1.8 2.291600e-05 1.8 2.291610e-05 0 2.307600e-05 0 2.307610e-05 1.8 2.323600e-05 1.8 2.323610e-05 0 2.339600e-05 0 2.339610e-05 1.8 2.355600e-05 1.8 2.355610e-05 0 2.371600e-05 0 2.371610e-05 1.8 2.387600e-05 1.8 2.387610e-05 0 2.403600e-05 0 2.403610e-05 1.8 2.419600e-05 1.8 2.419610e-05 0 2.435600e-05 0 2.435610e-05 1.8 2.451600e-05 1.8 2.451610e-05 0 2.467600e-05 0 2.467610e-05 1.8 2.483600e-05 1.8 2.483610e-05 0 2.499600e-05 0 2.499610e-05 1.8 2.515600e-05 1.8 2.515610e-05 0 2.531600e-05 0 2.531610e-05 1.8 2.547600e-05 1.8 2.547610e-05 0 2.563600e-05 0 2.563610e-05 1.8 2.579600e-05 1.8 2.579610e-05 0 2.595600e-05 0 2.595610e-05 1.8 2.611600e-05 1.8 2.611610e-05 0 2.627600e-05 0 2.627610e-05 1.8 2.643600e-05 1.8 2.643610e-05 0 2.659600e-05 0 2.659610e-05 1.8 2.675600e-05 1.8 2.675610e-05 0 2.691600e-05 0 2.691610e-05 1.8 2.707600e-05 1.8 2.707610e-05 0 2.723600e-05 0 2.723610e-05 1.8 2.739600e-05 1.8 2.739610e-05 0 2.755600e-05 0 2.755610e-05 1.8 2.771600e-05 1.8 2.771610e-05 0 2.787600e-05 0 2.787610e-05 1.8 2.803600e-05 1.8 2.803610e-05 0 2.819600e-05 0 2.819610e-05 1.8 2.835600e-05 1.8 2.835610e-05 0 2.851600e-05 0 2.851610e-05 1.8 2.867600e-05 1.8 2.867610e-05 0 2.883600e-05 0 2.883610e-05 1.8 2.899600e-05 1.8 2.899610e-05 0)
Va4_agin2 a4_agin2 0 pwl(0 0 4.317570000e-05 0 4.317580000e-05 1.8)
Va4_agin3 a4_agin3 0 pwl(0 0 4.316950000e-05 0 4.316960000e-05 1.8)
Ca4_ag685ob a4_ag685 a4_ob 6.9200e-18
Ca4_agin3oa a4_agin3 a4_oa 6.1390e-17
Ca4_agin3ob a4_agin3 a4_ob 5.5900e-17
Ca4_agin2oa a4_agin2 a4_oa 4.1100e-18
Vgrid grid 0 pwl(0 0 4.296900e-05 0.0 4.296905e-05 0.001 4.296910e-05 0.0 4.296915e-05 0.001 4.296920e-05 0.0 4.296925e-05 0.001 4.296930e-05 0.0 4.296935e-05 0.001 4.296940e-05 0.0 4.296945e-05 0.001 4.296950e-05 0.0 4.296955e-05 0.001 4.296960e-05 0.0 4.296965e-05 0.001 4.296970e-05 0.0 4.296975e-05 0.001 4.296980e-05 0.0 4.296985e-05 0.001 4.296990e-05 0.0 4.296995e-05 0.001 4.297000e-05 0.0 4.297005e-05 0.001 4.297010e-05 0.0 4.297015e-05 0.001 4.297020e-05 0.0 4.297025e-05 0.001 4.297030e-05 0.0 4.297035e-05 0.001 4.297040e-05 0.0 4.297045e-05 0.001 4.297050e-05 0.0 4.297055e-05 0.001 4.297060e-05 0.0 4.297065e-05 0.001 4.297070e-05 0.0 4.297075e-05 0.001 4.297080e-05 0.0 4.297085e-05 0.001 4.297090e-05 0.0 4.297095e-05 0.001 4.297100e-05 0.0 4.297105e-05 0.001 4.297110e-05 0.0 4.297115e-05 0.001 4.297120e-05 0.0 4.297125e-05 0.001 4.297130e-05 0.0 4.297135e-05 0.001 4.297140e-05 0.0 4.297145e-05 0.001 4.297150e-05 0.0 4.297155e-05 0.001 4.297160e-05 0.0 4.297165e-05 0.001 4.297170e-05 0.0 4.297175e-05 0.001 4.297180e-05 0.0 4.297185e-05 0.001 4.297190e-05 0.0 4.297195e-05 0.001 4.297200e-05 0.0 4.297205e-05 0.001 4.297210e-05 0.0 4.297215e-05 0.001 4.297220e-05 0.0 4.297225e-05 0.001 4.297230e-05 0.0 4.297235e-05 0.001 4.297240e-05 0.0 4.297245e-05 0.001 4.297250e-05 0.0 4.297255e-05 0.001 4.297260e-05 0.0 4.297265e-05 0.001 4.297270e-05 0.0 4.297275e-05 0.001 4.297280e-05 0.0 4.297285e-05 0.001 4.297290e-05 0.0 4.297295e-05 0.001 4.297300e-05 0.0 4.297305e-05 0.001 4.297310e-05 0.0 4.297315e-05 0.001 4.297320e-05 0.0 4.297325e-05 0.001 4.297330e-05 0.0 4.297335e-05 0.001 4.297340e-05 0.0 4.297345e-05 0.001 4.297350e-05 0.0 4.297355e-05 0.001 4.297360e-05 0.0 4.297365e-05 0.001 4.297370e-05 0.0 4.297375e-05 0.001 4.297380e-05 0.0 4.297385e-05 0.001 4.297390e-05 0.0 4.297395e-05 0.001 4.297400e-05 0.0 4.297405e-05 0.001 4.297410e-05 0.0 4.297415e-05 0.001 4.297420e-05 0.0 4.297425e-05 0.001 4.297430e-05 0.0 4.297435e-05 0.001 4.297440e-05 0.0 4.297445e-05 0.001 4.297450e-05 0.0 4.297455e-05 0.001 4.297460e-05 0.0 4.297465e-05 0.001 4.297470e-05 0.0 4.297475e-05 0.001 4.297480e-05 0.0 4.297485e-05 0.001 4.297490e-05 0.0 4.297495e-05 0.001 4.297500e-05 0.0 4.297505e-05 0.001 4.297510e-05 0.0 4.297515e-05 0.001 4.297520e-05 0.0 4.297525e-05 0.001 4.297530e-05 0.0 4.297535e-05 0.001 4.297540e-05 0.0 4.297545e-05 0.001 4.297550e-05 0.0 4.297555e-05 0.001 4.297560e-05 0.0 4.297565e-05 0.001 4.297570e-05 0.0 4.297575e-05 0.001 4.297580e-05 0.0 4.297585e-05 0.001 4.297590e-05 0.0 4.297595e-05 0.001 4.297600e-05 0.0 4.297605e-05 0.001 4.297610e-05 0.0 4.297615e-05 0.001 4.297620e-05 0.0 4.297625e-05 0.001 4.297630e-05 0.0 4.297635e-05 0.001 4.297640e-05 0.0 4.297645e-05 0.001 4.297650e-05 0.0 4.297655e-05 0.001 4.297660e-05 0.0 4.297665e-05 0.001 4.297670e-05 0.0 4.297675e-05 0.001 4.297680e-05 0.0 4.297685e-05 0.001 4.297690e-05 0.0 4.297695e-05 0.001 4.297700e-05 0.0 4.297705e-05 0.001 4.297710e-05 0.0 4.297715e-05 0.001 4.297720e-05 0.0 4.297725e-05 0.001 4.297730e-05 0.0 4.297735e-05 0.001 4.297740e-05 0.0 4.297745e-05 0.001 4.297750e-05 0.0 4.297755e-05 0.001 4.297760e-05 0.0 4.297765e-05 0.001 4.297770e-05 0.0 4.297775e-05 0.001 4.297780e-05 0.0 4.297785e-05 0.001 4.297790e-05 0.0 4.297795e-05 0.001 4.297800e-05 0.0 4.297805e-05 0.001 4.297810e-05 0.0 4.297815e-05 0.001 4.297820e-05 0.0 4.297825e-05 0.001 4.297830e-05 0.0 4.297835e-05 0.001 4.297840e-05 0.0 4.297845e-05 0.001 4.297850e-05 0.0 4.297855e-05 0.001 4.297860e-05 0.0 4.297865e-05 0.001 4.297870e-05 0.0 4.297875e-05 0.001 4.297880e-05 0.0 4.297885e-05 0.001 4.297890e-05 0.0 4.297895e-05 0.001 4.297900e-05 0.0 4.297905e-05 0.001 4.297910e-05 0.0 4.297915e-05 0.001 4.297920e-05 0.0 4.297925e-05 0.001 4.297930e-05 0.0 4.297935e-05 0.001 4.297940e-05 0.0 4.297945e-05 0.001 4.297950e-05 0.0 4.297955e-05 0.001 4.297960e-05 0.0 4.297965e-05 0.001 4.297970e-05 0.0 4.297975e-05 0.001 4.297980e-05 0.0 4.297985e-05 0.001 4.297990e-05 0.0 4.297995e-05 0.001 4.298000e-05 0.0 4.298005e-05 0.001 4.298010e-05 0.0 4.298015e-05 0.001 4.298020e-05 0.0 4.298025e-05 0.001 4.298030e-05 0.0 4.298035e-05 0.001 4.298040e-05 0.0 4.298045e-05 0.001 4.298050e-05 0.0 4.298055e-05 0.001 4.298060e-05 0.0 4.298065e-05 0.001 4.298070e-05 0.0 4.298075e-05 0.001 4.298080e-05 0.0 4.298085e-05 0.001 4.298090e-05 0.0 4.298095e-05 0.001 4.298100e-05 0.0 4.298105e-05 0.001 4.298110e-05 0.0 4.298115e-05 0.001 4.298120e-05 0.0 4.298125e-05 0.001 4.298130e-05 0.0 4.298135e-05 0.001 4.298140e-05 0.0 4.298145e-05 0.001 4.298150e-05 0.0 4.298155e-05 0.001 4.298160e-05 0.0 4.298165e-05 0.001 4.298170e-05 0.0 4.298175e-05 0.001 4.298180e-05 0.0 4.298185e-05 0.001 4.298190e-05 0.0 4.298195e-05 0.001 4.298200e-05 0.0 4.298205e-05 0.001 4.298210e-05 0.0 4.298215e-05 0.001 4.298220e-05 0.0 4.298225e-05 0.001 4.298230e-05 0.0 4.298235e-05 0.001 4.298240e-05 0.0 4.298245e-05 0.001 4.298250e-05 0.0 4.298255e-05 0.001 4.298260e-05 0.0 4.298265e-05 0.001 4.298270e-05 0.0 4.298275e-05 0.001 4.298280e-05 0.0 4.298285e-05 0.001 4.298290e-05 0.0 4.298295e-05 0.001 4.298300e-05 0.0 4.298305e-05 0.001 4.298310e-05 0.0 4.298315e-05 0.001 4.298320e-05 0.0 4.298325e-05 0.001 4.298330e-05 0.0 4.298335e-05 0.001 4.298340e-05 0.0 4.298345e-05 0.001 4.298350e-05 0.0 4.298355e-05 0.001 4.298360e-05 0.0 4.298365e-05 0.001 4.298370e-05 0.0 4.298375e-05 0.001 4.298380e-05 0.0 4.298385e-05 0.001 4.298390e-05 0.0 4.298395e-05 0.001 4.298400e-05 0.0 4.298405e-05 0.001 4.298410e-05 0.0 4.298415e-05 0.001 4.298420e-05 0.0 4.298425e-05 0.001 4.298430e-05 0.0 4.298435e-05 0.001 4.298440e-05 0.0 4.298445e-05 0.001 4.298450e-05 0.0 4.298455e-05 0.001 4.298460e-05 0.0 4.298465e-05 0.001 4.298470e-05 0.0 4.298475e-05 0.001 4.298480e-05 0.0 4.298485e-05 0.001 4.298490e-05 0.0 4.298495e-05 0.001 4.298500e-05 0.0 4.298505e-05 0.001 4.298510e-05 0.0 4.298515e-05 0.001 4.298520e-05 0.0 4.298525e-05 0.001 4.298530e-05 0.0 4.298535e-05 0.001 4.298540e-05 0.0 4.298545e-05 0.001 4.298550e-05 0.0 4.298555e-05 0.001 4.298560e-05 0.0 4.298565e-05 0.001 4.298570e-05 0.0 4.298575e-05 0.001 4.298580e-05 0.0 4.298585e-05 0.001 4.298590e-05 0.0 4.298595e-05 0.001 4.298600e-05 0.0 4.298605e-05 0.001 4.298610e-05 0.0 4.298615e-05 0.001 4.298620e-05 0.0 4.298625e-05 0.001 4.298630e-05 0.0 4.298635e-05 0.001 4.298640e-05 0.0 4.298645e-05 0.001 4.298650e-05 0.0 4.298655e-05 0.001 4.298660e-05 0.0 4.298665e-05 0.001 4.298670e-05 0.0 4.298675e-05 0.001 4.298680e-05 0.0 4.298685e-05 0.001 4.298690e-05 0.0 4.298695e-05 0.001 4.298700e-05 0.0 4.298705e-05 0.001 4.298710e-05 0.0 4.298715e-05 0.001 4.298720e-05 0.0 4.298725e-05 0.001 4.298730e-05 0.0 4.298735e-05 0.001 4.298740e-05 0.0 4.298745e-05 0.001 4.298750e-05 0.0 4.298755e-05 0.001 4.298760e-05 0.0 4.298765e-05 0.001 4.298770e-05 0.0 4.298775e-05 0.001 4.298780e-05 0.0 4.298785e-05 0.001 4.298790e-05 0.0 4.298795e-05 0.001 4.298800e-05 0.0 4.298805e-05 0.001 4.298810e-05 0.0 4.298815e-05 0.001 4.298820e-05 0.0 4.298825e-05 0.001 4.298830e-05 0.0 4.298835e-05 0.001 4.298840e-05 0.0 4.298845e-05 0.001 4.298850e-05 0.0 4.298855e-05 0.001 4.298860e-05 0.0 4.298865e-05 0.001 4.298870e-05 0.0 4.298875e-05 0.001 4.298880e-05 0.0 4.298885e-05 0.001 4.298890e-05 0.0 4.298895e-05 0.001 4.298900e-05 0.0 4.298905e-05 0.001 4.298910e-05 0.0 4.298915e-05 0.001 4.298920e-05 0.0 4.298925e-05 0.001 4.298930e-05 0.0 4.298935e-05 0.001 4.298940e-05 0.0 4.298945e-05 0.001 4.298950e-05 0.0 4.298955e-05 0.001 4.298960e-05 0.0 4.298965e-05 0.001 4.298970e-05 0.0 4.298975e-05 0.001 4.298980e-05 0.0 4.298985e-05 0.001 4.298990e-05 0.0 4.298995e-05 0.001 4.299000e-05 0.0 4.299005e-05 0.001 4.299010e-05 0.0 4.299015e-05 0.001 4.299020e-05 0.0 4.299025e-05 0.001 4.299030e-05 0.0 4.299035e-05 0.001 4.299040e-05 0.0 4.299045e-05 0.001 4.299050e-05 0.0 4.299055e-05 0.001 4.299060e-05 0.0 4.299065e-05 0.001 4.299070e-05 0.0 4.299075e-05 0.001 4.299080e-05 0.0 4.299085e-05 0.001 4.299090e-05 0.0 4.299095e-05 0.001 4.299100e-05 0.0 4.299105e-05 0.001 4.299110e-05 0.0 4.299115e-05 0.001 4.299120e-05 0.0 4.299125e-05 0.001 4.299130e-05 0.0 4.299135e-05 0.001 4.299140e-05 0.0 4.299145e-05 0.001 4.299150e-05 0.0 4.299155e-05 0.001 4.299160e-05 0.0 4.299165e-05 0.001 4.299170e-05 0.0 4.299175e-05 0.001 4.299180e-05 0.0 4.299185e-05 0.001 4.299190e-05 0.0 4.299195e-05 0.001 4.299200e-05 0.0 4.299205e-05 0.001 4.299210e-05 0.0 4.299215e-05 0.001 4.299220e-05 0.0 4.299225e-05 0.001 4.299230e-05 0.0 4.299235e-05 0.001 4.299240e-05 0.0 4.299245e-05 0.001 4.299250e-05 0.0 4.299255e-05 0.001 4.299260e-05 0.0 4.299265e-05 0.001 4.299270e-05 0.0 4.299275e-05 0.001 4.299280e-05 0.0 4.299285e-05 0.001 4.299290e-05 0.0 4.299295e-05 0.001 4.299300e-05 0.0 4.299305e-05 0.001 4.299310e-05 0.0 4.299315e-05 0.001 4.299320e-05 0.0 4.299325e-05 0.001 4.299330e-05 0.0 4.299335e-05 0.001 4.299340e-05 0.0 4.299345e-05 0.001 4.299350e-05 0.0 4.299355e-05 0.001 4.299360e-05 0.0 4.299365e-05 0.001 4.299370e-05 0.0 4.299375e-05 0.001 4.299380e-05 0.0 4.299385e-05 0.001 4.299390e-05 0.0 4.299395e-05 0.001 4.299400e-05 0.0 4.299405e-05 0.001 4.299410e-05 0.0 4.299415e-05 0.001 4.299420e-05 0.0 4.299425e-05 0.001 4.299430e-05 0.0 4.299435e-05 0.001 4.299440e-05 0.0 4.299445e-05 0.001 4.299450e-05 0.0 4.299455e-05 0.001 4.299460e-05 0.0 4.299465e-05 0.001 4.299470e-05 0.0 4.299475e-05 0.001 4.299480e-05 0.0 4.299485e-05 0.001 4.299490e-05 0.0 4.299495e-05 0.001 4.299500e-05 0.0 4.299505e-05 0.001 4.299510e-05 0.0 4.299515e-05 0.001 4.299520e-05 0.0 4.299525e-05 0.001 4.299530e-05 0.0 4.299535e-05 0.001 4.299540e-05 0.0 4.299545e-05 0.001 4.299550e-05 0.0 4.299555e-05 0.001 4.299560e-05 0.0 4.299565e-05 0.001 4.299570e-05 0.0 4.299575e-05 0.001 4.299580e-05 0.0 4.299585e-05 0.001 4.299590e-05 0.0 4.299595e-05 0.001 4.299600e-05 0.0 4.299605e-05 0.001 4.299610e-05 0.0 4.299615e-05 0.001 4.299620e-05 0.0 4.299625e-05 0.001 4.299630e-05 0.0 4.299635e-05 0.001 4.299640e-05 0.0 4.299645e-05 0.001 4.299650e-05 0.0 4.299655e-05 0.001 4.299660e-05 0.0 4.299665e-05 0.001 4.299670e-05 0.0 4.299675e-05 0.001 4.299680e-05 0.0 4.299685e-05 0.001 4.299690e-05 0.0 4.299695e-05 0.001 4.299700e-05 0.0 4.299705e-05 0.001 4.299710e-05 0.0 4.299715e-05 0.001 4.299720e-05 0.0 4.299725e-05 0.001 4.299730e-05 0.0 4.299735e-05 0.001 4.299740e-05 0.0 4.299745e-05 0.001 4.299750e-05 0.0 4.299755e-05 0.001 4.299760e-05 0.0 4.299765e-05 0.001 4.299770e-05 0.0 4.299775e-05 0.001 4.299780e-05 0.0 4.299785e-05 0.001 4.299790e-05 0.0 4.299795e-05 0.001 4.299800e-05 0.0 4.299805e-05 0.001 4.299810e-05 0.0 4.299815e-05 0.001 4.299820e-05 0.0 4.299825e-05 0.001 4.299830e-05 0.0 4.299835e-05 0.001 4.299840e-05 0.0 4.299845e-05 0.001 4.299850e-05 0.0 4.299855e-05 0.001 4.299860e-05 0.0 4.299865e-05 0.001 4.299870e-05 0.0 4.299875e-05 0.001 4.299880e-05 0.0 4.299885e-05 0.001 4.299890e-05 0.0 4.299895e-05 0.001 4.299900e-05 0.0 4.299905e-05 0.001 4.299910e-05 0.0 4.299915e-05 0.001 4.299920e-05 0.0 4.299925e-05 0.001 4.299930e-05 0.0 4.299935e-05 0.001 4.299940e-05 0.0 4.299945e-05 0.001 4.299950e-05 0.0 4.299955e-05 0.001 4.299960e-05 0.0 4.299965e-05 0.001 4.299970e-05 0.0 4.299975e-05 0.001 4.299980e-05 0.0 4.299985e-05 0.001 4.299990e-05 0.0 4.299995e-05 0.001 4.300000e-05 0.0 4.300005e-05 0.001 4.300010e-05 0.0 4.300015e-05 0.001 4.300020e-05 0.0 4.300025e-05 0.001 4.300030e-05 0.0 4.300035e-05 0.001 4.300040e-05 0.0 4.300045e-05 0.001 4.300050e-05 0.0 4.300055e-05 0.001 4.300060e-05 0.0 4.300065e-05 0.001 4.300070e-05 0.0 4.300075e-05 0.001 4.300080e-05 0.0 4.300085e-05 0.001 4.300090e-05 0.0 4.300095e-05 0.001 4.300100e-05 0.0 4.300105e-05 0.001 4.300110e-05 0.0 4.300115e-05 0.001 4.300120e-05 0.0 4.300125e-05 0.001 4.300130e-05 0.0 4.300135e-05 0.001 4.300140e-05 0.0 4.300145e-05 0.001 4.300150e-05 0.0 4.300155e-05 0.001 4.300160e-05 0.0 4.300165e-05 0.001 4.300170e-05 0.0 4.300175e-05 0.001 4.300180e-05 0.0 4.300185e-05 0.001 4.300190e-05 0.0 4.300195e-05 0.001 4.300200e-05 0.0 4.300205e-05 0.001 4.300210e-05 0.0 4.300215e-05 0.001 4.300220e-05 0.0 4.300225e-05 0.001 4.300230e-05 0.0 4.300235e-05 0.001 4.300240e-05 0.0 4.300245e-05 0.001 4.300250e-05 0.0 4.300255e-05 0.001 4.300260e-05 0.0 4.300265e-05 0.001 4.300270e-05 0.0 4.300275e-05 0.001 4.300280e-05 0.0 4.300285e-05 0.001 4.300290e-05 0.0 4.300295e-05 0.001 4.300300e-05 0.0 4.300305e-05 0.001 4.300310e-05 0.0 4.300315e-05 0.001 4.300320e-05 0.0 4.300325e-05 0.001 4.300330e-05 0.0 4.300335e-05 0.001 4.300340e-05 0.0 4.300345e-05 0.001 4.300350e-05 0.0 4.300355e-05 0.001 4.300360e-05 0.0 4.300365e-05 0.001 4.300370e-05 0.0 4.300375e-05 0.001 4.300380e-05 0.0 4.300385e-05 0.001 4.300390e-05 0.0 4.300395e-05 0.001 4.300400e-05 0.0 4.300405e-05 0.001 4.300410e-05 0.0 4.300415e-05 0.001 4.300420e-05 0.0 4.300425e-05 0.001 4.300430e-05 0.0 4.300435e-05 0.001 4.300440e-05 0.0 4.300445e-05 0.001 4.300450e-05 0.0 4.300455e-05 0.001 4.300460e-05 0.0 4.300465e-05 0.001 4.300470e-05 0.0 4.300475e-05 0.001 4.300480e-05 0.0 4.300485e-05 0.001 4.300490e-05 0.0 4.300495e-05 0.001 4.300500e-05 0.0 4.300505e-05 0.001 4.300510e-05 0.0 4.300515e-05 0.001 4.300520e-05 0.0 4.300525e-05 0.001 4.300530e-05 0.0 4.300535e-05 0.001 4.300540e-05 0.0 4.300545e-05 0.001 4.300550e-05 0.0 4.300555e-05 0.001 4.300560e-05 0.0 4.300565e-05 0.001 4.300570e-05 0.0 4.300575e-05 0.001 4.300580e-05 0.0 4.300585e-05 0.001 4.300590e-05 0.0 4.300595e-05 0.001 4.300600e-05 0.0 4.300605e-05 0.001 4.300610e-05 0.0 4.300615e-05 0.001 4.300620e-05 0.0 4.300625e-05 0.001 4.300630e-05 0.0 4.300635e-05 0.001 4.300640e-05 0.0 4.300645e-05 0.001 4.300650e-05 0.0 4.300655e-05 0.001 4.300660e-05 0.0 4.300665e-05 0.001 4.300670e-05 0.0 4.300675e-05 0.001 4.300680e-05 0.0 4.300685e-05 0.001 4.300690e-05 0.0 4.300695e-05 0.001 4.300700e-05 0.0 4.300705e-05 0.001 4.300710e-05 0.0 4.300715e-05 0.001 4.300720e-05 0.0 4.300725e-05 0.001 4.300730e-05 0.0 4.300735e-05 0.001 4.300740e-05 0.0 4.300745e-05 0.001 4.300750e-05 0.0 4.300755e-05 0.001 4.300760e-05 0.0 4.300765e-05 0.001 4.300770e-05 0.0 4.300775e-05 0.001 4.300780e-05 0.0 4.300785e-05 0.001 4.300790e-05 0.0 4.300795e-05 0.001 4.300800e-05 0.0 4.300805e-05 0.001 4.300810e-05 0.0 4.300815e-05 0.001 4.300820e-05 0.0 4.300825e-05 0.001 4.300830e-05 0.0 4.300835e-05 0.001 4.300840e-05 0.0 4.300845e-05 0.001 4.300850e-05 0.0 4.300855e-05 0.001 4.300860e-05 0.0 4.300865e-05 0.001 4.300870e-05 0.0 4.300875e-05 0.001 4.300880e-05 0.0 4.300885e-05 0.001 4.300890e-05 0.0 4.300895e-05 0.001 4.300900e-05 0.0 4.300905e-05 0.001 4.300910e-05 0.0 4.300915e-05 0.001 4.300920e-05 0.0 4.300925e-05 0.001 4.300930e-05 0.0 4.300935e-05 0.001 4.300940e-05 0.0 4.300945e-05 0.001 4.300950e-05 0.0 4.300955e-05 0.001 4.300960e-05 0.0 4.300965e-05 0.001 4.300970e-05 0.0 4.300975e-05 0.001 4.300980e-05 0.0 4.300985e-05 0.001 4.300990e-05 0.0 4.300995e-05 0.001 4.301000e-05 0.0 4.301005e-05 0.001 4.301010e-05 0.0 4.301015e-05 0.001 4.301020e-05 0.0 4.301025e-05 0.001 4.301030e-05 0.0 4.301035e-05 0.001 4.301040e-05 0.0 4.301045e-05 0.001 4.301050e-05 0.0 4.301055e-05 0.001 4.301060e-05 0.0 4.301065e-05 0.001 4.301070e-05 0.0 4.301075e-05 0.001 4.301080e-05 0.0 4.301085e-05 0.001 4.301090e-05 0.0 4.301095e-05 0.001 4.301100e-05 0.0 4.301105e-05 0.001 4.301110e-05 0.0 4.301115e-05 0.001 4.301120e-05 0.0 4.301125e-05 0.001 4.301130e-05 0.0 4.301135e-05 0.001 4.301140e-05 0.0 4.301145e-05 0.001 4.301150e-05 0.0 4.301155e-05 0.001 4.301160e-05 0.0 4.301165e-05 0.001 4.301170e-05 0.0 4.301175e-05 0.001 4.301180e-05 0.0 4.301185e-05 0.001 4.301190e-05 0.0 4.301195e-05 0.001 4.301200e-05 0.0 4.301205e-05 0.001 4.301210e-05 0.0 4.301215e-05 0.001 4.301220e-05 0.0 4.301225e-05 0.001 4.301230e-05 0.0 4.301235e-05 0.001 4.301240e-05 0.0 4.301245e-05 0.001 4.301250e-05 0.0 4.301255e-05 0.001 4.301260e-05 0.0 4.301265e-05 0.001 4.301270e-05 0.0 4.301275e-05 0.001 4.301280e-05 0.0 4.301285e-05 0.001 4.301290e-05 0.0 4.301295e-05 0.001 4.301300e-05 0.0 4.301305e-05 0.001 4.301310e-05 0.0 4.301315e-05 0.001 4.301320e-05 0.0 4.301325e-05 0.001 4.301330e-05 0.0 4.301335e-05 0.001 4.301340e-05 0.0 4.301345e-05 0.001 4.301350e-05 0.0 4.301355e-05 0.001 4.301360e-05 0.0 4.301365e-05 0.001 4.301370e-05 0.0 4.301375e-05 0.001 4.301380e-05 0.0 4.301385e-05 0.001 4.301390e-05 0.0 4.301395e-05 0.001 4.301400e-05 0.0 4.301405e-05 0.001 4.301410e-05 0.0 4.301415e-05 0.001 4.301420e-05 0.0 4.301425e-05 0.001 4.301430e-05 0.0 4.301435e-05 0.001 4.301440e-05 0.0 4.301445e-05 0.001 4.301450e-05 0.0 4.301455e-05 0.001 4.301460e-05 0.0 4.301465e-05 0.001 4.301470e-05 0.0 4.301475e-05 0.001 4.301480e-05 0.0 4.301485e-05 0.001 4.301490e-05 0.0 4.301495e-05 0.001 4.301500e-05 0.0 4.301505e-05 0.001 4.301510e-05 0.0 4.301515e-05 0.001 4.301520e-05 0.0 4.301525e-05 0.001 4.301530e-05 0.0 4.301535e-05 0.001 4.301540e-05 0.0 4.301545e-05 0.001 4.301550e-05 0.0 4.301555e-05 0.001 4.301560e-05 0.0 4.301565e-05 0.001 4.301570e-05 0.0 4.301575e-05 0.001 4.301580e-05 0.0 4.301585e-05 0.001 4.301590e-05 0.0 4.301595e-05 0.001 4.301600e-05 0.0 4.301605e-05 0.001 4.301610e-05 0.0 4.301615e-05 0.001 4.301620e-05 0.0 4.301625e-05 0.001 4.301630e-05 0.0 4.301635e-05 0.001 4.301640e-05 0.0 4.301645e-05 0.001 4.301650e-05 0.0 4.301655e-05 0.001 4.301660e-05 0.0 4.301665e-05 0.001 4.301670e-05 0.0 4.301675e-05 0.001 4.301680e-05 0.0 4.301685e-05 0.001 4.301690e-05 0.0 4.301695e-05 0.001 4.301700e-05 0.0 4.301705e-05 0.001 4.301710e-05 0.0 4.301715e-05 0.001 4.301720e-05 0.0 4.301725e-05 0.001 4.301730e-05 0.0 4.301735e-05 0.001 4.301740e-05 0.0 4.301745e-05 0.001 4.301750e-05 0.0 4.301755e-05 0.001 4.301760e-05 0.0 4.301765e-05 0.001 4.301770e-05 0.0 4.301775e-05 0.001 4.301780e-05 0.0 4.301785e-05 0.001 4.301790e-05 0.0 4.301795e-05 0.001 4.301800e-05 0.0 4.301805e-05 0.001 4.301810e-05 0.0 4.301815e-05 0.001 4.301820e-05 0.0 4.301825e-05 0.001 4.301830e-05 0.0 4.301835e-05 0.001 4.301840e-05 0.0 4.301845e-05 0.001 4.301850e-05 0.0 4.301855e-05 0.001 4.301860e-05 0.0 4.301865e-05 0.001 4.301870e-05 0.0 4.301875e-05 0.001 4.301880e-05 0.0 4.301885e-05 0.001 4.301890e-05 0.0 4.301895e-05 0.001 4.301900e-05 0.0 4.301905e-05 0.001 4.301910e-05 0.0 4.301915e-05 0.001 4.301920e-05 0.0 4.301925e-05 0.001 4.301930e-05 0.0 4.301935e-05 0.001 4.301940e-05 0.0 4.301945e-05 0.001 4.301950e-05 0.0 4.301955e-05 0.001 4.301960e-05 0.0 4.301965e-05 0.001 4.301970e-05 0.0 4.301975e-05 0.001 4.301980e-05 0.0 4.301985e-05 0.001 4.301990e-05 0.0 4.301995e-05 0.001 4.302000e-05 0.0 4.302005e-05 0.001 4.302010e-05 0.0 4.302015e-05 0.001 4.302020e-05 0.0 4.302025e-05 0.001 4.302030e-05 0.0 4.302035e-05 0.001 4.302040e-05 0.0 4.302045e-05 0.001 4.302050e-05 0.0 4.302055e-05 0.001 4.302060e-05 0.0 4.302065e-05 0.001 4.302070e-05 0.0 4.302075e-05 0.001 4.302080e-05 0.0 4.302085e-05 0.001 4.302090e-05 0.0 4.302095e-05 0.001 4.302100e-05 0.0 4.302105e-05 0.001 4.302110e-05 0.0 4.302115e-05 0.001 4.302120e-05 0.0 4.302125e-05 0.001 4.302130e-05 0.0 4.302135e-05 0.001 4.302140e-05 0.0 4.302145e-05 0.001 4.302150e-05 0.0 4.302155e-05 0.001 4.302160e-05 0.0 4.302165e-05 0.001 4.302170e-05 0.0 4.302175e-05 0.001 4.302180e-05 0.0 4.302185e-05 0.001 4.302190e-05 0.0 4.302195e-05 0.001 4.302200e-05 0.0 4.302205e-05 0.001 4.302210e-05 0.0 4.302215e-05 0.001 4.302220e-05 0.0 4.302225e-05 0.001 4.302230e-05 0.0 4.302235e-05 0.001 4.302240e-05 0.0 4.302245e-05 0.001 4.302250e-05 0.0 4.302255e-05 0.001 4.302260e-05 0.0 4.302265e-05 0.001 4.302270e-05 0.0 4.302275e-05 0.001 4.302280e-05 0.0 4.302285e-05 0.001 4.302290e-05 0.0 4.302295e-05 0.001 4.302300e-05 0.0 4.302305e-05 0.001 4.302310e-05 0.0 4.302315e-05 0.001 4.302320e-05 0.0 4.302325e-05 0.001 4.302330e-05 0.0 4.302335e-05 0.001 4.302340e-05 0.0 4.302345e-05 0.001 4.302350e-05 0.0 4.302355e-05 0.001 4.302360e-05 0.0 4.302365e-05 0.001 4.302370e-05 0.0 4.302375e-05 0.001 4.302380e-05 0.0 4.302385e-05 0.001 4.302390e-05 0.0 4.302395e-05 0.001 4.302400e-05 0.0 4.302405e-05 0.001 4.302410e-05 0.0 4.302415e-05 0.001 4.302420e-05 0.0 4.302425e-05 0.001 4.302430e-05 0.0 4.302435e-05 0.001 4.302440e-05 0.0 4.302445e-05 0.001 4.302450e-05 0.0 4.302455e-05 0.001 4.302460e-05 0.0 4.302465e-05 0.001 4.302470e-05 0.0 4.302475e-05 0.001 4.302480e-05 0.0 4.302485e-05 0.001 4.302490e-05 0.0 4.302495e-05 0.001 4.302500e-05 0.0 4.302505e-05 0.001 4.302510e-05 0.0 4.302515e-05 0.001 4.302520e-05 0.0 4.302525e-05 0.001 4.302530e-05 0.0 4.302535e-05 0.001 4.302540e-05 0.0 4.302545e-05 0.001 4.302550e-05 0.0 4.302555e-05 0.001 4.302560e-05 0.0 4.302565e-05 0.001 4.302570e-05 0.0 4.302575e-05 0.001 4.302580e-05 0.0 4.302585e-05 0.001 4.302590e-05 0.0 4.302595e-05 0.001 4.302600e-05 0.0 4.302605e-05 0.001 4.302610e-05 0.0 4.302615e-05 0.001 4.302620e-05 0.0 4.302625e-05 0.001 4.302630e-05 0.0 4.302635e-05 0.001 4.302640e-05 0.0 4.302645e-05 0.001 4.302650e-05 0.0 4.302655e-05 0.001 4.302660e-05 0.0 4.302665e-05 0.001 4.302670e-05 0.0 4.302675e-05 0.001 4.302680e-05 0.0 4.302685e-05 0.001 4.302690e-05 0.0 4.302695e-05 0.001 4.302700e-05 0.0 4.302705e-05 0.001 4.302710e-05 0.0 4.302715e-05 0.001 4.302720e-05 0.0 4.302725e-05 0.001 4.302730e-05 0.0 4.302735e-05 0.001 4.302740e-05 0.0 4.302745e-05 0.001 4.302750e-05 0.0 4.302755e-05 0.001 4.302760e-05 0.0 4.302765e-05 0.001 4.302770e-05 0.0 4.302775e-05 0.001 4.302780e-05 0.0 4.302785e-05 0.001 4.302790e-05 0.0 4.302795e-05 0.001 4.302800e-05 0.0 4.302805e-05 0.001 4.302810e-05 0.0 4.302815e-05 0.001 4.302820e-05 0.0 4.302825e-05 0.001 4.302830e-05 0.0 4.302835e-05 0.001 4.302840e-05 0.0 4.302845e-05 0.001 4.302850e-05 0.0 4.302855e-05 0.001 4.302860e-05 0.0 4.302865e-05 0.001 4.302870e-05 0.0 4.302875e-05 0.001 4.302880e-05 0.0 4.302885e-05 0.001 4.302890e-05 0.0 4.302895e-05 0.001 4.302900e-05 0.0 4.302905e-05 0.001 4.302910e-05 0.0 4.302915e-05 0.001 4.302920e-05 0.0 4.302925e-05 0.001 4.302930e-05 0.0 4.302935e-05 0.001 4.302940e-05 0.0 4.302945e-05 0.001 4.302950e-05 0.0 4.302955e-05 0.001 4.302960e-05 0.0 4.302965e-05 0.001 4.302970e-05 0.0 4.302975e-05 0.001 4.302980e-05 0.0 4.302985e-05 0.001 4.302990e-05 0.0 4.302995e-05 0.001 4.303000e-05 0.0 4.303005e-05 0.001 4.303010e-05 0.0 4.303015e-05 0.001 4.303020e-05 0.0 4.303025e-05 0.001 4.303030e-05 0.0 4.303035e-05 0.001 4.303040e-05 0.0 4.303045e-05 0.001 4.303050e-05 0.0 4.303055e-05 0.001 4.303060e-05 0.0 4.303065e-05 0.001 4.303070e-05 0.0 4.303075e-05 0.001 4.303080e-05 0.0 4.303085e-05 0.001 4.303090e-05 0.0 4.303095e-05 0.001 4.303100e-05 0.0 4.303105e-05 0.001 4.303110e-05 0.0 4.303115e-05 0.001 4.303120e-05 0.0 4.303125e-05 0.001 4.303130e-05 0.0 4.303135e-05 0.001 4.303140e-05 0.0 4.303145e-05 0.001 4.303150e-05 0.0 4.303155e-05 0.001 4.303160e-05 0.0 4.303165e-05 0.001 4.303170e-05 0.0 4.303175e-05 0.001 4.303180e-05 0.0 4.303185e-05 0.001 4.303190e-05 0.0 4.303195e-05 0.001 4.303200e-05 0.0 4.303205e-05 0.001 4.303210e-05 0.0 4.303215e-05 0.001 4.303220e-05 0.0 4.303225e-05 0.001 4.303230e-05 0.0 4.303235e-05 0.001 4.303240e-05 0.0 4.303245e-05 0.001 4.303250e-05 0.0 4.303255e-05 0.001 4.303260e-05 0.0 4.303265e-05 0.001 4.303270e-05 0.0 4.303275e-05 0.001 4.303280e-05 0.0 4.303285e-05 0.001 4.303290e-05 0.0 4.303295e-05 0.001 4.303300e-05 0.0 4.303305e-05 0.001 4.303310e-05 0.0 4.303315e-05 0.001 4.303320e-05 0.0 4.303325e-05 0.001 4.303330e-05 0.0 4.303335e-05 0.001 4.303340e-05 0.0 4.303345e-05 0.001 4.303350e-05 0.0 4.303355e-05 0.001 4.303360e-05 0.0 4.303365e-05 0.001 4.303370e-05 0.0 4.303375e-05 0.001 4.303380e-05 0.0 4.303385e-05 0.001 4.303390e-05 0.0 4.303395e-05 0.001 4.303400e-05 0.0 4.303405e-05 0.001 4.303410e-05 0.0 4.303415e-05 0.001 4.303420e-05 0.0 4.303425e-05 0.001 4.303430e-05 0.0 4.303435e-05 0.001 4.303440e-05 0.0 4.303445e-05 0.001 4.303450e-05 0.0 4.303455e-05 0.001 4.303460e-05 0.0 4.303465e-05 0.001 4.303470e-05 0.0 4.303475e-05 0.001 4.303480e-05 0.0 4.303485e-05 0.001 4.303490e-05 0.0 4.303495e-05 0.001 4.303500e-05 0.0 4.303505e-05 0.001 4.303510e-05 0.0 4.303515e-05 0.001 4.303520e-05 0.0 4.303525e-05 0.001 4.303530e-05 0.0 4.303535e-05 0.001 4.303540e-05 0.0 4.303545e-05 0.001 4.303550e-05 0.0 4.303555e-05 0.001 4.303560e-05 0.0 4.303565e-05 0.001 4.303570e-05 0.0 4.303575e-05 0.001 4.303580e-05 0.0 4.303585e-05 0.001 4.303590e-05 0.0 4.303595e-05 0.001 4.303600e-05 0.0 4.303605e-05 0.001 4.303610e-05 0.0 4.303615e-05 0.001 4.303620e-05 0.0 4.303625e-05 0.001 4.303630e-05 0.0 4.303635e-05 0.001 4.303640e-05 0.0 4.303645e-05 0.001 4.303650e-05 0.0 4.303655e-05 0.001 4.303660e-05 0.0 4.303665e-05 0.001 4.303670e-05 0.0 4.303675e-05 0.001 4.303680e-05 0.0 4.303685e-05 0.001 4.303690e-05 0.0 4.303695e-05 0.001 4.303700e-05 0.0 4.303705e-05 0.001 4.303710e-05 0.0 4.303715e-05 0.001 4.303720e-05 0.0 4.303725e-05 0.001 4.303730e-05 0.0 4.303735e-05 0.001 4.303740e-05 0.0 4.303745e-05 0.001 4.303750e-05 0.0 4.303755e-05 0.001 4.303760e-05 0.0 4.303765e-05 0.001 4.303770e-05 0.0 4.303775e-05 0.001 4.303780e-05 0.0 4.303785e-05 0.001 4.303790e-05 0.0 4.303795e-05 0.001 4.303800e-05 0.0 4.303805e-05 0.001 4.303810e-05 0.0 4.303815e-05 0.001 4.303820e-05 0.0 4.303825e-05 0.001 4.303830e-05 0.0 4.303835e-05 0.001 4.303840e-05 0.0 4.303845e-05 0.001 4.303850e-05 0.0 4.303855e-05 0.001 4.303860e-05 0.0 4.303865e-05 0.001 4.303870e-05 0.0 4.303875e-05 0.001 4.303880e-05 0.0 4.303885e-05 0.001 4.303890e-05 0.0 4.303895e-05 0.001 4.303900e-05 0.0 4.303905e-05 0.001 4.303910e-05 0.0 4.303915e-05 0.001 4.303920e-05 0.0 4.303925e-05 0.001 4.303930e-05 0.0 4.303935e-05 0.001 4.303940e-05 0.0 4.303945e-05 0.001 4.303950e-05 0.0 4.303955e-05 0.001 4.303960e-05 0.0 4.303965e-05 0.001 4.303970e-05 0.0 4.303975e-05 0.001 4.303980e-05 0.0 4.303985e-05 0.001 4.303990e-05 0.0 4.303995e-05 0.001 4.304000e-05 0.0 4.304005e-05 0.001 4.304010e-05 0.0 4.304015e-05 0.001 4.304020e-05 0.0 4.304025e-05 0.001 4.304030e-05 0.0 4.304035e-05 0.001 4.304040e-05 0.0 4.304045e-05 0.001 4.304050e-05 0.0 4.304055e-05 0.001 4.304060e-05 0.0 4.304065e-05 0.001 4.304070e-05 0.0 4.304075e-05 0.001 4.304080e-05 0.0 4.304085e-05 0.001 4.304090e-05 0.0 4.304095e-05 0.001 4.304100e-05 0.0 4.304105e-05 0.001 4.304110e-05 0.0 4.304115e-05 0.001 4.304120e-05 0.0 4.304125e-05 0.001 4.304130e-05 0.0 4.304135e-05 0.001 4.304140e-05 0.0 4.304145e-05 0.001 4.304150e-05 0.0 4.304155e-05 0.001 4.304160e-05 0.0 4.304165e-05 0.001 4.304170e-05 0.0 4.304175e-05 0.001 4.304180e-05 0.0 4.304185e-05 0.001 4.304190e-05 0.0 4.304195e-05 0.001 4.304200e-05 0.0 4.304205e-05 0.001 4.304210e-05 0.0 4.304215e-05 0.001 4.304220e-05 0.0 4.304225e-05 0.001 4.304230e-05 0.0 4.304235e-05 0.001 4.304240e-05 0.0 4.304245e-05 0.001 4.304250e-05 0.0 4.304255e-05 0.001 4.304260e-05 0.0 4.304265e-05 0.001 4.304270e-05 0.0 4.304275e-05 0.001 4.304280e-05 0.0 4.304285e-05 0.001 4.304290e-05 0.0 4.304295e-05 0.001 4.304300e-05 0.0 4.304305e-05 0.001 4.304310e-05 0.0 4.304315e-05 0.001 4.304320e-05 0.0 4.304325e-05 0.001 4.304330e-05 0.0 4.304335e-05 0.001 4.304340e-05 0.0 4.304345e-05 0.001 4.304350e-05 0.0 4.304355e-05 0.001 4.304360e-05 0.0 4.304365e-05 0.001 4.304370e-05 0.0 4.304375e-05 0.001 4.304380e-05 0.0 4.304385e-05 0.001 4.304390e-05 0.0 4.304395e-05 0.001 4.304400e-05 0.0 4.304405e-05 0.001 4.304410e-05 0.0 4.304415e-05 0.001 4.304420e-05 0.0 4.304425e-05 0.001 4.304430e-05 0.0 4.304435e-05 0.001 4.304440e-05 0.0 4.304445e-05 0.001 4.304450e-05 0.0 4.304455e-05 0.001 4.304460e-05 0.0 4.304465e-05 0.001 4.304470e-05 0.0 4.304475e-05 0.001 4.304480e-05 0.0 4.304485e-05 0.001 4.304490e-05 0.0 4.304495e-05 0.001 4.304500e-05 0.0 4.304505e-05 0.001 4.304510e-05 0.0 4.304515e-05 0.001 4.304520e-05 0.0 4.304525e-05 0.001 4.304530e-05 0.0 4.304535e-05 0.001 4.304540e-05 0.0 4.304545e-05 0.001 4.304550e-05 0.0 4.304555e-05 0.001 4.304560e-05 0.0 4.304565e-05 0.001 4.304570e-05 0.0 4.304575e-05 0.001 4.304580e-05 0.0 4.304585e-05 0.001 4.304590e-05 0.0 4.304595e-05 0.001 4.304600e-05 0.0 4.304605e-05 0.001 4.304610e-05 0.0 4.304615e-05 0.001 4.304620e-05 0.0 4.304625e-05 0.001 4.304630e-05 0.0 4.304635e-05 0.001 4.304640e-05 0.0 4.304645e-05 0.001 4.304650e-05 0.0 4.304655e-05 0.001 4.304660e-05 0.0 4.304665e-05 0.001 4.304670e-05 0.0 4.304675e-05 0.001 4.304680e-05 0.0 4.304685e-05 0.001 4.304690e-05 0.0 4.304695e-05 0.001 4.304700e-05 0.0 4.304705e-05 0.001 4.304710e-05 0.0 4.304715e-05 0.001 4.304720e-05 0.0 4.304725e-05 0.001 4.304730e-05 0.0 4.304735e-05 0.001 4.304740e-05 0.0 4.304745e-05 0.001 4.304750e-05 0.0 4.304755e-05 0.001 4.304760e-05 0.0 4.304765e-05 0.001 4.304770e-05 0.0 4.304775e-05 0.001 4.304780e-05 0.0 4.304785e-05 0.001 4.304790e-05 0.0 4.304795e-05 0.001 4.304800e-05 0.0 4.304805e-05 0.001 4.304810e-05 0.0 4.304815e-05 0.001 4.304820e-05 0.0 4.304825e-05 0.001 4.304830e-05 0.0 4.304835e-05 0.001 4.304840e-05 0.0 4.304845e-05 0.001 4.304850e-05 0.0 4.304855e-05 0.001 4.304860e-05 0.0 4.304865e-05 0.001 4.304870e-05 0.0 4.304875e-05 0.001 4.304880e-05 0.0 4.304885e-05 0.001 4.304890e-05 0.0 4.304895e-05 0.001 4.304900e-05 0.0 4.304905e-05 0.001 4.304910e-05 0.0 4.304915e-05 0.001 4.304920e-05 0.0 4.304925e-05 0.001 4.304930e-05 0.0 4.304935e-05 0.001 4.304940e-05 0.0 4.304945e-05 0.001 4.304950e-05 0.0 4.304955e-05 0.001 4.304960e-05 0.0 4.304965e-05 0.001 4.304970e-05 0.0 4.304975e-05 0.001 4.304980e-05 0.0 4.304985e-05 0.001 4.304990e-05 0.0 4.304995e-05 0.001 4.305000e-05 0.0 4.305005e-05 0.001 4.305010e-05 0.0 4.305015e-05 0.001 4.305020e-05 0.0 4.305025e-05 0.001 4.305030e-05 0.0 4.305035e-05 0.001 4.305040e-05 0.0 4.305045e-05 0.001 4.305050e-05 0.0 4.305055e-05 0.001 4.305060e-05 0.0 4.305065e-05 0.001 4.305070e-05 0.0 4.305075e-05 0.001 4.305080e-05 0.0 4.305085e-05 0.001 4.305090e-05 0.0 4.305095e-05 0.001 4.305100e-05 0.0 4.305105e-05 0.001 4.305110e-05 0.0 4.305115e-05 0.001 4.305120e-05 0.0 4.305125e-05 0.001 4.305130e-05 0.0 4.305135e-05 0.001 4.305140e-05 0.0 4.305145e-05 0.001 4.305150e-05 0.0 4.305155e-05 0.001 4.305160e-05 0.0 4.305165e-05 0.001 4.305170e-05 0.0 4.305175e-05 0.001 4.305180e-05 0.0 4.305185e-05 0.001 4.305190e-05 0.0 4.305195e-05 0.001 4.305200e-05 0.0 4.305205e-05 0.001 4.305210e-05 0.0 4.305215e-05 0.001 4.305220e-05 0.0 4.305225e-05 0.001 4.305230e-05 0.0 4.305235e-05 0.001 4.305240e-05 0.0 4.305245e-05 0.001 4.305250e-05 0.0 4.305255e-05 0.001 4.305260e-05 0.0 4.305265e-05 0.001 4.305270e-05 0.0 4.305275e-05 0.001 4.305280e-05 0.0 4.305285e-05 0.001 4.305290e-05 0.0 4.305295e-05 0.001 4.305300e-05 0.0 4.305305e-05 0.001 4.305310e-05 0.0 4.305315e-05 0.001 4.305320e-05 0.0 4.305325e-05 0.001 4.305330e-05 0.0 4.305335e-05 0.001 4.305340e-05 0.0 4.305345e-05 0.001 4.305350e-05 0.0 4.305355e-05 0.001 4.305360e-05 0.0 4.305365e-05 0.001 4.305370e-05 0.0 4.305375e-05 0.001 4.305380e-05 0.0 4.305385e-05 0.001 4.305390e-05 0.0 4.305395e-05 0.001 4.305400e-05 0.0 4.305405e-05 0.001 4.305410e-05 0.0 4.305415e-05 0.001 4.305420e-05 0.0 4.305425e-05 0.001 4.305430e-05 0.0 4.305435e-05 0.001 4.305440e-05 0.0 4.305445e-05 0.001 4.305450e-05 0.0 4.305455e-05 0.001 4.305460e-05 0.0 4.305465e-05 0.001 4.305470e-05 0.0 4.305475e-05 0.001 4.305480e-05 0.0 4.305485e-05 0.001 4.305490e-05 0.0 4.305495e-05 0.001 4.305500e-05 0.0 4.305505e-05 0.001 4.305510e-05 0.0 4.305515e-05 0.001 4.305520e-05 0.0 4.305525e-05 0.001 4.305530e-05 0.0 4.305535e-05 0.001 4.305540e-05 0.0 4.305545e-05 0.001 4.305550e-05 0.0 4.305555e-05 0.001 4.305560e-05 0.0 4.305565e-05 0.001 4.305570e-05 0.0 4.305575e-05 0.001 4.305580e-05 0.0 4.305585e-05 0.001 4.305590e-05 0.0 4.305595e-05 0.001 4.305600e-05 0.0 4.305605e-05 0.001 4.305610e-05 0.0 4.305615e-05 0.001 4.305620e-05 0.0 4.305625e-05 0.001 4.305630e-05 0.0 4.305635e-05 0.001 4.305640e-05 0.0 4.305645e-05 0.001 4.305650e-05 0.0 4.305655e-05 0.001 4.305660e-05 0.0 4.305665e-05 0.001 4.305670e-05 0.0 4.305675e-05 0.001 4.305680e-05 0.0 4.305685e-05 0.001 4.305690e-05 0.0 4.305695e-05 0.001 4.305700e-05 0.0 4.305705e-05 0.001 4.305710e-05 0.0 4.305715e-05 0.001 4.305720e-05 0.0 4.305725e-05 0.001 4.305730e-05 0.0 4.305735e-05 0.001 4.305740e-05 0.0 4.305745e-05 0.001 4.305750e-05 0.0 4.305755e-05 0.001 4.305760e-05 0.0 4.305765e-05 0.001 4.305770e-05 0.0 4.305775e-05 0.001 4.305780e-05 0.0 4.305785e-05 0.001 4.305790e-05 0.0 4.305795e-05 0.001 4.305800e-05 0.0 4.305805e-05 0.001 4.305810e-05 0.0 4.305815e-05 0.001 4.305820e-05 0.0 4.305825e-05 0.001 4.305830e-05 0.0 4.305835e-05 0.001 4.305840e-05 0.0 4.305845e-05 0.001 4.305850e-05 0.0 4.305855e-05 0.001 4.305860e-05 0.0 4.305865e-05 0.001 4.305870e-05 0.0 4.305875e-05 0.001 4.305880e-05 0.0 4.305885e-05 0.001 4.305890e-05 0.0 4.305895e-05 0.001 4.305900e-05 0.0 4.305905e-05 0.001 4.305910e-05 0.0 4.305915e-05 0.001 4.305920e-05 0.0 4.305925e-05 0.001 4.305930e-05 0.0 4.305935e-05 0.001 4.305940e-05 0.0 4.305945e-05 0.001 4.305950e-05 0.0 4.305955e-05 0.001 4.305960e-05 0.0 4.305965e-05 0.001 4.305970e-05 0.0 4.305975e-05 0.001 4.305980e-05 0.0 4.305985e-05 0.001 4.305990e-05 0.0 4.305995e-05 0.001 4.306000e-05 0.0 4.306005e-05 0.001 4.306010e-05 0.0 4.306015e-05 0.001 4.306020e-05 0.0 4.306025e-05 0.001 4.306030e-05 0.0 4.306035e-05 0.001 4.306040e-05 0.0 4.306045e-05 0.001 4.306050e-05 0.0 4.306055e-05 0.001 4.306060e-05 0.0 4.306065e-05 0.001 4.306070e-05 0.0 4.306075e-05 0.001 4.306080e-05 0.0 4.306085e-05 0.001 4.306090e-05 0.0 4.306095e-05 0.001 4.306100e-05 0.0 4.306105e-05 0.001 4.306110e-05 0.0 4.306115e-05 0.001 4.306120e-05 0.0 4.306125e-05 0.001 4.306130e-05 0.0 4.306135e-05 0.001 4.306140e-05 0.0 4.306145e-05 0.001 4.306150e-05 0.0 4.306155e-05 0.001 4.306160e-05 0.0 4.306165e-05 0.001 4.306170e-05 0.0 4.306175e-05 0.001 4.306180e-05 0.0 4.306185e-05 0.001 4.306190e-05 0.0 4.306195e-05 0.001 4.306200e-05 0.0 4.306205e-05 0.001 4.306210e-05 0.0 4.306215e-05 0.001 4.306220e-05 0.0 4.306225e-05 0.001 4.306230e-05 0.0 4.306235e-05 0.001 4.306240e-05 0.0 4.306245e-05 0.001 4.306250e-05 0.0 4.306255e-05 0.001 4.306260e-05 0.0 4.306265e-05 0.001 4.306270e-05 0.0 4.306275e-05 0.001 4.306280e-05 0.0 4.306285e-05 0.001 4.306290e-05 0.0 4.306295e-05 0.001 4.306300e-05 0.0 4.306305e-05 0.001 4.306310e-05 0.0 4.306315e-05 0.001 4.306320e-05 0.0 4.306325e-05 0.001 4.306330e-05 0.0 4.306335e-05 0.001 4.306340e-05 0.0 4.306345e-05 0.001 4.306350e-05 0.0 4.306355e-05 0.001 4.306360e-05 0.0 4.306365e-05 0.001 4.306370e-05 0.0 4.306375e-05 0.001 4.306380e-05 0.0 4.306385e-05 0.001 4.306390e-05 0.0 4.306395e-05 0.001 4.306400e-05 0.0 4.306405e-05 0.001 4.306410e-05 0.0 4.306415e-05 0.001 4.306420e-05 0.0 4.306425e-05 0.001 4.306430e-05 0.0 4.306435e-05 0.001 4.306440e-05 0.0 4.306445e-05 0.001 4.306450e-05 0.0 4.306455e-05 0.001 4.306460e-05 0.0 4.306465e-05 0.001 4.306470e-05 0.0 4.306475e-05 0.001 4.306480e-05 0.0 4.306485e-05 0.001 4.306490e-05 0.0 4.306495e-05 0.001 4.306500e-05 0.0 4.306505e-05 0.001 4.306510e-05 0.0 4.306515e-05 0.001 4.306520e-05 0.0 4.306525e-05 0.001 4.306530e-05 0.0 4.306535e-05 0.001 4.306540e-05 0.0 4.306545e-05 0.001 4.306550e-05 0.0 4.306555e-05 0.001 4.306560e-05 0.0 4.306565e-05 0.001 4.306570e-05 0.0 4.306575e-05 0.001 4.306580e-05 0.0 4.306585e-05 0.001 4.306590e-05 0.0 4.306595e-05 0.001 4.306600e-05 0.0 4.306605e-05 0.001 4.306610e-05 0.0 4.306615e-05 0.001 4.306620e-05 0.0 4.306625e-05 0.001 4.306630e-05 0.0 4.306635e-05 0.001 4.306640e-05 0.0 4.306645e-05 0.001 4.306650e-05 0.0 4.306655e-05 0.001 4.306660e-05 0.0 4.306665e-05 0.001 4.306670e-05 0.0 4.306675e-05 0.001 4.306680e-05 0.0 4.306685e-05 0.001 4.306690e-05 0.0 4.306695e-05 0.001 4.306700e-05 0.0 4.306705e-05 0.001 4.306710e-05 0.0 4.306715e-05 0.001 4.306720e-05 0.0 4.306725e-05 0.001 4.306730e-05 0.0 4.306735e-05 0.001 4.306740e-05 0.0 4.306745e-05 0.001 4.306750e-05 0.0 4.306755e-05 0.001 4.306760e-05 0.0 4.306765e-05 0.001 4.306770e-05 0.0 4.306775e-05 0.001 4.306780e-05 0.0 4.306785e-05 0.001 4.306790e-05 0.0 4.306795e-05 0.001 4.306800e-05 0.0 4.306805e-05 0.001 4.306810e-05 0.0 4.306815e-05 0.001 4.306820e-05 0.0 4.306825e-05 0.001 4.306830e-05 0.0 4.306835e-05 0.001 4.306840e-05 0.0 4.306845e-05 0.001 4.306850e-05 0.0 4.306855e-05 0.001 4.306860e-05 0.0 4.306865e-05 0.001 4.306870e-05 0.0 4.306875e-05 0.001 4.306880e-05 0.0 4.306885e-05 0.001 4.306890e-05 0.0 4.306895e-05 0.001 4.306900e-05 0.0 4.306905e-05 0.001 4.306910e-05 0.0 4.306915e-05 0.001 4.306920e-05 0.0 4.306925e-05 0.001 4.306930e-05 0.0 4.306935e-05 0.001 4.306940e-05 0.0 4.306945e-05 0.001 4.306950e-05 0.0 4.306955e-05 0.001 4.306960e-05 0.0 4.306965e-05 0.001 4.306970e-05 0.0 4.306975e-05 0.001 4.306980e-05 0.0 4.306985e-05 0.001 4.306990e-05 0.0 4.306995e-05 0.001 4.307000e-05 0.0 4.307005e-05 0.001 4.307010e-05 0.0 4.307015e-05 0.001 4.307020e-05 0.0 4.307025e-05 0.001 4.307030e-05 0.0 4.307035e-05 0.001 4.307040e-05 0.0 4.307045e-05 0.001 4.307050e-05 0.0 4.307055e-05 0.001 4.307060e-05 0.0 4.307065e-05 0.001 4.307070e-05 0.0 4.307075e-05 0.001 4.307080e-05 0.0 4.307085e-05 0.001 4.307090e-05 0.0 4.307095e-05 0.001 4.307100e-05 0.0 4.307105e-05 0.001 4.307110e-05 0.0 4.307115e-05 0.001 4.307120e-05 0.0 4.307125e-05 0.001 4.307130e-05 0.0 4.307135e-05 0.001 4.307140e-05 0.0 4.307145e-05 0.001 4.307150e-05 0.0 4.307155e-05 0.001 4.307160e-05 0.0 4.307165e-05 0.001 4.307170e-05 0.0 4.307175e-05 0.001 4.307180e-05 0.0 4.307185e-05 0.001 4.307190e-05 0.0 4.307195e-05 0.001 4.307200e-05 0.0 4.307205e-05 0.001 4.307210e-05 0.0 4.307215e-05 0.001 4.307220e-05 0.0 4.307225e-05 0.001 4.307230e-05 0.0 4.307235e-05 0.001 4.307240e-05 0.0 4.307245e-05 0.001 4.307250e-05 0.0 4.307255e-05 0.001 4.307260e-05 0.0 4.307265e-05 0.001 4.307270e-05 0.0 4.307275e-05 0.001 4.307280e-05 0.0 4.307285e-05 0.001 4.307290e-05 0.0 4.307295e-05 0.001 4.307300e-05 0.0 4.307305e-05 0.001 4.307310e-05 0.0 4.307315e-05 0.001 4.307320e-05 0.0 4.307325e-05 0.001 4.307330e-05 0.0 4.307335e-05 0.001 4.307340e-05 0.0 4.307345e-05 0.001 4.307350e-05 0.0 4.307355e-05 0.001 4.307360e-05 0.0 4.307365e-05 0.001 4.307370e-05 0.0 4.307375e-05 0.001 4.307380e-05 0.0 4.307385e-05 0.001 4.307390e-05 0.0 4.307395e-05 0.001 4.307400e-05 0.0 4.307405e-05 0.001 4.307410e-05 0.0 4.307415e-05 0.001 4.307420e-05 0.0 4.307425e-05 0.001 4.307430e-05 0.0 4.307435e-05 0.001 4.307440e-05 0.0 4.307445e-05 0.001 4.307450e-05 0.0 4.307455e-05 0.001 4.307460e-05 0.0 4.307465e-05 0.001 4.307470e-05 0.0 4.307475e-05 0.001 4.307480e-05 0.0 4.307485e-05 0.001 4.307490e-05 0.0 4.307495e-05 0.001 4.307500e-05 0.0 4.307505e-05 0.001 4.307510e-05 0.0 4.307515e-05 0.001 4.307520e-05 0.0 4.307525e-05 0.001 4.307530e-05 0.0 4.307535e-05 0.001 4.307540e-05 0.0 4.307545e-05 0.001 4.307550e-05 0.0 4.307555e-05 0.001 4.307560e-05 0.0 4.307565e-05 0.001 4.307570e-05 0.0 4.307575e-05 0.001 4.307580e-05 0.0 4.307585e-05 0.001 4.307590e-05 0.0 4.307595e-05 0.001 4.307600e-05 0.0 4.307605e-05 0.001 4.307610e-05 0.0 4.307615e-05 0.001 4.307620e-05 0.0 4.307625e-05 0.001 4.307630e-05 0.0 4.307635e-05 0.001 4.307640e-05 0.0 4.307645e-05 0.001 4.307650e-05 0.0 4.307655e-05 0.001 4.307660e-05 0.0 4.307665e-05 0.001 4.307670e-05 0.0 4.307675e-05 0.001 4.307680e-05 0.0 4.307685e-05 0.001 4.307690e-05 0.0 4.307695e-05 0.001 4.307700e-05 0.0 4.307705e-05 0.001 4.307710e-05 0.0 4.307715e-05 0.001 4.307720e-05 0.0 4.307725e-05 0.001 4.307730e-05 0.0 4.307735e-05 0.001 4.307740e-05 0.0 4.307745e-05 0.001 4.307750e-05 0.0 4.307755e-05 0.001 4.307760e-05 0.0 4.307765e-05 0.001 4.307770e-05 0.0 4.307775e-05 0.001 4.307780e-05 0.0 4.307785e-05 0.001 4.307790e-05 0.0 4.307795e-05 0.001 4.307800e-05 0.0 4.307805e-05 0.001 4.307810e-05 0.0 4.307815e-05 0.001 4.307820e-05 0.0 4.307825e-05 0.001 4.307830e-05 0.0 4.307835e-05 0.001 4.307840e-05 0.0 4.307845e-05 0.001 4.307850e-05 0.0 4.307855e-05 0.001 4.307860e-05 0.0 4.307865e-05 0.001 4.307870e-05 0.0 4.307875e-05 0.001 4.307880e-05 0.0 4.307885e-05 0.001 4.307890e-05 0.0 4.307895e-05 0.001 4.307900e-05 0.0 4.307905e-05 0.001 4.307910e-05 0.0 4.307915e-05 0.001 4.307920e-05 0.0 4.307925e-05 0.001 4.307930e-05 0.0 4.307935e-05 0.001 4.307940e-05 0.0 4.307945e-05 0.001 4.307950e-05 0.0 4.307955e-05 0.001 4.307960e-05 0.0 4.307965e-05 0.001 4.307970e-05 0.0 4.307975e-05 0.001 4.307980e-05 0.0 4.307985e-05 0.001 4.307990e-05 0.0 4.307995e-05 0.001 4.308000e-05 0.0 4.308005e-05 0.001 4.308010e-05 0.0 4.308015e-05 0.001 4.308020e-05 0.0 4.308025e-05 0.001 4.308030e-05 0.0 4.308035e-05 0.001 4.308040e-05 0.0 4.308045e-05 0.001 4.308050e-05 0.0 4.308055e-05 0.001 4.308060e-05 0.0 4.308065e-05 0.001 4.308070e-05 0.0 4.308075e-05 0.001 4.308080e-05 0.0 4.308085e-05 0.001 4.308090e-05 0.0 4.308095e-05 0.001 4.308100e-05 0.0 4.308105e-05 0.001 4.308110e-05 0.0 4.308115e-05 0.001 4.308120e-05 0.0 4.308125e-05 0.001 4.308130e-05 0.0 4.308135e-05 0.001 4.308140e-05 0.0 4.308145e-05 0.001 4.308150e-05 0.0 4.308155e-05 0.001 4.308160e-05 0.0 4.308165e-05 0.001 4.308170e-05 0.0 4.308175e-05 0.001 4.308180e-05 0.0 4.308185e-05 0.001 4.308190e-05 0.0 4.308195e-05 0.001 4.308200e-05 0.0 4.308205e-05 0.001 4.308210e-05 0.0 4.308215e-05 0.001 4.308220e-05 0.0 4.308225e-05 0.001 4.308230e-05 0.0 4.308235e-05 0.001 4.308240e-05 0.0 4.308245e-05 0.001 4.308250e-05 0.0 4.308255e-05 0.001 4.308260e-05 0.0 4.308265e-05 0.001 4.308270e-05 0.0 4.308275e-05 0.001 4.308280e-05 0.0 4.308285e-05 0.001 4.308290e-05 0.0 4.308295e-05 0.001 4.308300e-05 0.0 4.308305e-05 0.001 4.308310e-05 0.0 4.308315e-05 0.001 4.308320e-05 0.0 4.308325e-05 0.001 4.308330e-05 0.0 4.308335e-05 0.001 4.308340e-05 0.0 4.308345e-05 0.001 4.308350e-05 0.0 4.308355e-05 0.001 4.308360e-05 0.0 4.308365e-05 0.001 4.308370e-05 0.0 4.308375e-05 0.001 4.308380e-05 0.0 4.308385e-05 0.001 4.308390e-05 0.0 4.308395e-05 0.001 4.308400e-05 0.0 4.308405e-05 0.001 4.308410e-05 0.0 4.308415e-05 0.001 4.308420e-05 0.0 4.308425e-05 0.001 4.308430e-05 0.0 4.308435e-05 0.001 4.308440e-05 0.0 4.308445e-05 0.001 4.308450e-05 0.0 4.308455e-05 0.001 4.308460e-05 0.0 4.308465e-05 0.001 4.308470e-05 0.0 4.308475e-05 0.001 4.308480e-05 0.0 4.308485e-05 0.001 4.308490e-05 0.0 4.308495e-05 0.001 4.308500e-05 0.0 4.308505e-05 0.001 4.308510e-05 0.0 4.308515e-05 0.001 4.308520e-05 0.0 4.308525e-05 0.001 4.308530e-05 0.0 4.308535e-05 0.001 4.308540e-05 0.0 4.308545e-05 0.001 4.308550e-05 0.0 4.308555e-05 0.001 4.308560e-05 0.0 4.308565e-05 0.001 4.308570e-05 0.0 4.308575e-05 0.001 4.308580e-05 0.0 4.308585e-05 0.001 4.308590e-05 0.0 4.308595e-05 0.001 4.308600e-05 0.0 4.308605e-05 0.001 4.308610e-05 0.0 4.308615e-05 0.001 4.308620e-05 0.0 4.308625e-05 0.001 4.308630e-05 0.0 4.308635e-05 0.001 4.308640e-05 0.0 4.308645e-05 0.001 4.308650e-05 0.0 4.308655e-05 0.001 4.308660e-05 0.0 4.308665e-05 0.001 4.308670e-05 0.0 4.308675e-05 0.001 4.308680e-05 0.0 4.308685e-05 0.001 4.308690e-05 0.0 4.308695e-05 0.001 4.308700e-05 0.0 4.308705e-05 0.001 4.308710e-05 0.0 4.308715e-05 0.001 4.308720e-05 0.0 4.308725e-05 0.001 4.308730e-05 0.0 4.308735e-05 0.001 4.308740e-05 0.0 4.308745e-05 0.001 4.308750e-05 0.0 4.308755e-05 0.001 4.308760e-05 0.0 4.308765e-05 0.001 4.308770e-05 0.0 4.308775e-05 0.001 4.308780e-05 0.0 4.308785e-05 0.001 4.308790e-05 0.0 4.308795e-05 0.001 4.308800e-05 0.0 4.308805e-05 0.001 4.308810e-05 0.0 4.308815e-05 0.001 4.308820e-05 0.0 4.308825e-05 0.001 4.308830e-05 0.0 4.308835e-05 0.001 4.308840e-05 0.0 4.308845e-05 0.001 4.308850e-05 0.0 4.308855e-05 0.001 4.308860e-05 0.0 4.308865e-05 0.001 4.308870e-05 0.0 4.308875e-05 0.001 4.308880e-05 0.0 4.308885e-05 0.001 4.308890e-05 0.0 4.308895e-05 0.001 4.308900e-05 0.0 4.308905e-05 0.001 4.308910e-05 0.0 4.308915e-05 0.001 4.308920e-05 0.0 4.308925e-05 0.001 4.308930e-05 0.0 4.308935e-05 0.001 4.308940e-05 0.0 4.308945e-05 0.001 4.308950e-05 0.0 4.308955e-05 0.001 4.308960e-05 0.0 4.308965e-05 0.001 4.308970e-05 0.0 4.308975e-05 0.001 4.308980e-05 0.0 4.308985e-05 0.001 4.308990e-05 0.0 4.308995e-05 0.001 4.309000e-05 0.0 4.309005e-05 0.001 4.309010e-05 0.0 4.309015e-05 0.001 4.309020e-05 0.0 4.309025e-05 0.001 4.309030e-05 0.0 4.309035e-05 0.001 4.309040e-05 0.0 4.309045e-05 0.001 4.309050e-05 0.0 4.309055e-05 0.001 4.309060e-05 0.0 4.309065e-05 0.001 4.309070e-05 0.0 4.309075e-05 0.001 4.309080e-05 0.0 4.309085e-05 0.001 4.309090e-05 0.0 4.309095e-05 0.001 4.309100e-05 0.0 4.309105e-05 0.001 4.309110e-05 0.0 4.309115e-05 0.001 4.309120e-05 0.0 4.309125e-05 0.001 4.309130e-05 0.0 4.309135e-05 0.001 4.309140e-05 0.0 4.309145e-05 0.001 4.309150e-05 0.0 4.309155e-05 0.001 4.309160e-05 0.0 4.309165e-05 0.001 4.309170e-05 0.0 4.309175e-05 0.001 4.309180e-05 0.0 4.309185e-05 0.001 4.309190e-05 0.0 4.309195e-05 0.001 4.309200e-05 0.0 4.309205e-05 0.001 4.309210e-05 0.0 4.309215e-05 0.001 4.309220e-05 0.0 4.309225e-05 0.001 4.309230e-05 0.0 4.309235e-05 0.001 4.309240e-05 0.0 4.309245e-05 0.001 4.309250e-05 0.0 4.309255e-05 0.001 4.309260e-05 0.0 4.309265e-05 0.001 4.309270e-05 0.0 4.309275e-05 0.001 4.309280e-05 0.0 4.309285e-05 0.001 4.309290e-05 0.0 4.309295e-05 0.001 4.309300e-05 0.0 4.309305e-05 0.001 4.309310e-05 0.0 4.309315e-05 0.001 4.309320e-05 0.0 4.309325e-05 0.001 4.309330e-05 0.0 4.309335e-05 0.001 4.309340e-05 0.0 4.309345e-05 0.001 4.309350e-05 0.0 4.309355e-05 0.001 4.309360e-05 0.0 4.309365e-05 0.001 4.309370e-05 0.0 4.309375e-05 0.001 4.309380e-05 0.0 4.309385e-05 0.001 4.309390e-05 0.0 4.309395e-05 0.001 4.309400e-05 0.0 4.309405e-05 0.001 4.309410e-05 0.0 4.309415e-05 0.001 4.309420e-05 0.0 4.309425e-05 0.001 4.309430e-05 0.0 4.309435e-05 0.001 4.309440e-05 0.0 4.309445e-05 0.001 4.309450e-05 0.0 4.309455e-05 0.001 4.309460e-05 0.0 4.309465e-05 0.001 4.309470e-05 0.0 4.309475e-05 0.001 4.309480e-05 0.0 4.309485e-05 0.001 4.309490e-05 0.0 4.309495e-05 0.001 4.309500e-05 0.0 4.309505e-05 0.001 4.309510e-05 0.0 4.309515e-05 0.001 4.309520e-05 0.0 4.309525e-05 0.001 4.309530e-05 0.0 4.309535e-05 0.001 4.309540e-05 0.0 4.309545e-05 0.001 4.309550e-05 0.0 4.309555e-05 0.001 4.309560e-05 0.0 4.309565e-05 0.001 4.309570e-05 0.0 4.309575e-05 0.001 4.309580e-05 0.0 4.309585e-05 0.001 4.309590e-05 0.0 4.309595e-05 0.001 4.309600e-05 0.0 4.309605e-05 0.001 4.309610e-05 0.0 4.309615e-05 0.001 4.309620e-05 0.0 4.309625e-05 0.001 4.309630e-05 0.0 4.309635e-05 0.001 4.309640e-05 0.0 4.309645e-05 0.001 4.309650e-05 0.0 4.309655e-05 0.001 4.309660e-05 0.0 4.309665e-05 0.001 4.309670e-05 0.0 4.309675e-05 0.001 4.309680e-05 0.0 4.309685e-05 0.001 4.309690e-05 0.0 4.309695e-05 0.001 4.309700e-05 0.0 4.309705e-05 0.001 4.309710e-05 0.0 4.309715e-05 0.001 4.309720e-05 0.0 4.309725e-05 0.001 4.309730e-05 0.0 4.309735e-05 0.001 4.309740e-05 0.0 4.309745e-05 0.001 4.309750e-05 0.0 4.309755e-05 0.001 4.309760e-05 0.0 4.309765e-05 0.001 4.309770e-05 0.0 4.309775e-05 0.001 4.309780e-05 0.0 4.309785e-05 0.001 4.309790e-05 0.0 4.309795e-05 0.001 4.309800e-05 0.0 4.309805e-05 0.001 4.309810e-05 0.0 4.309815e-05 0.001 4.309820e-05 0.0 4.309825e-05 0.001 4.309830e-05 0.0 4.309835e-05 0.001 4.309840e-05 0.0 4.309845e-05 0.001 4.309850e-05 0.0 4.309855e-05 0.001 4.309860e-05 0.0 4.309865e-05 0.001 4.309870e-05 0.0 4.309875e-05 0.001 4.309880e-05 0.0 4.309885e-05 0.001 4.309890e-05 0.0 4.309895e-05 0.001 4.309900e-05 0.0 4.309905e-05 0.001 4.309910e-05 0.0 4.309915e-05 0.001 4.309920e-05 0.0 4.309925e-05 0.001 4.309930e-05 0.0 4.309935e-05 0.001 4.309940e-05 0.0 4.309945e-05 0.001 4.309950e-05 0.0 4.309955e-05 0.001 4.309960e-05 0.0 4.309965e-05 0.001 4.309970e-05 0.0 4.309975e-05 0.001 4.309980e-05 0.0 4.309985e-05 0.001 4.309990e-05 0.0 4.309995e-05 0.001 4.310000e-05 0.0 4.310005e-05 0.001 4.310010e-05 0.0 4.310015e-05 0.001 4.310020e-05 0.0 4.310025e-05 0.001 4.310030e-05 0.0 4.310035e-05 0.001 4.310040e-05 0.0 4.310045e-05 0.001 4.310050e-05 0.0 4.310055e-05 0.001 4.310060e-05 0.0 4.310065e-05 0.001 4.310070e-05 0.0 4.310075e-05 0.001 4.310080e-05 0.0 4.310085e-05 0.001 4.310090e-05 0.0 4.310095e-05 0.001 4.310100e-05 0.0 4.310105e-05 0.001 4.310110e-05 0.0 4.310115e-05 0.001 4.310120e-05 0.0 4.310125e-05 0.001 4.310130e-05 0.0 4.310135e-05 0.001 4.310140e-05 0.0 4.310145e-05 0.001 4.310150e-05 0.0 4.310155e-05 0.001 4.310160e-05 0.0 4.310165e-05 0.001 4.310170e-05 0.0 4.310175e-05 0.001 4.310180e-05 0.0 4.310185e-05 0.001 4.310190e-05 0.0 4.310195e-05 0.001 4.310200e-05 0.0 4.310205e-05 0.001 4.310210e-05 0.0 4.310215e-05 0.001 4.310220e-05 0.0 4.310225e-05 0.001 4.310230e-05 0.0 4.310235e-05 0.001 4.310240e-05 0.0 4.310245e-05 0.001 4.310250e-05 0.0 4.310255e-05 0.001 4.310260e-05 0.0 4.310265e-05 0.001 4.310270e-05 0.0 4.310275e-05 0.001 4.310280e-05 0.0 4.310285e-05 0.001 4.310290e-05 0.0 4.310295e-05 0.001 4.310300e-05 0.0 4.310305e-05 0.001 4.310310e-05 0.0 4.310315e-05 0.001 4.310320e-05 0.0 4.310325e-05 0.001 4.310330e-05 0.0 4.310335e-05 0.001 4.310340e-05 0.0 4.310345e-05 0.001 4.310350e-05 0.0 4.310355e-05 0.001 4.310360e-05 0.0 4.310365e-05 0.001 4.310370e-05 0.0 4.310375e-05 0.001 4.310380e-05 0.0 4.310385e-05 0.001 4.310390e-05 0.0 4.310395e-05 0.001 4.310400e-05 0.0 4.310405e-05 0.001 4.310410e-05 0.0 4.310415e-05 0.001 4.310420e-05 0.0 4.310425e-05 0.001 4.310430e-05 0.0 4.310435e-05 0.001 4.310440e-05 0.0 4.310445e-05 0.001 4.310450e-05 0.0 4.310455e-05 0.001 4.310460e-05 0.0 4.310465e-05 0.001 4.310470e-05 0.0 4.310475e-05 0.001 4.310480e-05 0.0 4.310485e-05 0.001 4.310490e-05 0.0 4.310495e-05 0.001 4.310500e-05 0.0 4.310505e-05 0.001 4.310510e-05 0.0 4.310515e-05 0.001 4.310520e-05 0.0 4.310525e-05 0.001 4.310530e-05 0.0 4.310535e-05 0.001 4.310540e-05 0.0 4.310545e-05 0.001 4.310550e-05 0.0 4.310555e-05 0.001 4.310560e-05 0.0 4.310565e-05 0.001 4.310570e-05 0.0 4.310575e-05 0.001 4.310580e-05 0.0 4.310585e-05 0.001 4.310590e-05 0.0 4.310595e-05 0.001 4.310600e-05 0.0 4.310605e-05 0.001 4.310610e-05 0.0 4.310615e-05 0.001 4.310620e-05 0.0 4.310625e-05 0.001 4.310630e-05 0.0 4.310635e-05 0.001 4.310640e-05 0.0 4.310645e-05 0.001 4.310650e-05 0.0 4.310655e-05 0.001 4.310660e-05 0.0 4.310665e-05 0.001 4.310670e-05 0.0 4.310675e-05 0.001 4.310680e-05 0.0 4.310685e-05 0.001 4.310690e-05 0.0 4.310695e-05 0.001 4.310700e-05 0.0 4.310705e-05 0.001 4.310710e-05 0.0 4.310715e-05 0.001 4.310720e-05 0.0 4.310725e-05 0.001 4.310730e-05 0.0 4.310735e-05 0.001 4.310740e-05 0.0 4.310745e-05 0.001 4.310750e-05 0.0 4.310755e-05 0.001 4.310760e-05 0.0 4.310765e-05 0.001 4.310770e-05 0.0 4.310775e-05 0.001 4.310780e-05 0.0 4.310785e-05 0.001 4.310790e-05 0.0 4.310795e-05 0.001 4.310800e-05 0.0 4.310805e-05 0.001 4.310810e-05 0.0 4.310815e-05 0.001 4.310820e-05 0.0 4.310825e-05 0.001 4.310830e-05 0.0 4.310835e-05 0.001 4.310840e-05 0.0 4.310845e-05 0.001 4.310850e-05 0.0 4.310855e-05 0.001 4.310860e-05 0.0 4.310865e-05 0.001 4.310870e-05 0.0 4.310875e-05 0.001 4.310880e-05 0.0 4.310885e-05 0.001 4.310890e-05 0.0 4.310895e-05 0.001 4.310900e-05 0.0 4.310905e-05 0.001 4.310910e-05 0.0 4.310915e-05 0.001 4.310920e-05 0.0 4.310925e-05 0.001 4.310930e-05 0.0 4.310935e-05 0.001 4.310940e-05 0.0 4.310945e-05 0.001 4.310950e-05 0.0 4.310955e-05 0.001 4.310960e-05 0.0 4.310965e-05 0.001 4.310970e-05 0.0 4.310975e-05 0.001 4.310980e-05 0.0 4.310985e-05 0.001 4.310990e-05 0.0 4.310995e-05 0.001 4.311000e-05 0.0 4.311005e-05 0.001 4.311010e-05 0.0 4.311015e-05 0.001 4.311020e-05 0.0 4.311025e-05 0.001 4.311030e-05 0.0 4.311035e-05 0.001 4.311040e-05 0.0 4.311045e-05 0.001 4.311050e-05 0.0 4.311055e-05 0.001 4.311060e-05 0.0 4.311065e-05 0.001 4.311070e-05 0.0 4.311075e-05 0.001 4.311080e-05 0.0 4.311085e-05 0.001 4.311090e-05 0.0 4.311095e-05 0.001 4.311100e-05 0.0 4.311105e-05 0.001 4.311110e-05 0.0 4.311115e-05 0.001 4.311120e-05 0.0 4.311125e-05 0.001 4.311130e-05 0.0 4.311135e-05 0.001 4.311140e-05 0.0 4.311145e-05 0.001 4.311150e-05 0.0 4.311155e-05 0.001 4.311160e-05 0.0 4.311165e-05 0.001 4.311170e-05 0.0 4.311175e-05 0.001 4.311180e-05 0.0 4.311185e-05 0.001 4.311190e-05 0.0 4.311195e-05 0.001 4.311200e-05 0.0 4.311205e-05 0.001 4.311210e-05 0.0 4.311215e-05 0.001 4.311220e-05 0.0 4.311225e-05 0.001 4.311230e-05 0.0 4.311235e-05 0.001 4.311240e-05 0.0 4.311245e-05 0.001 4.311250e-05 0.0 4.311255e-05 0.001 4.311260e-05 0.0 4.311265e-05 0.001 4.311270e-05 0.0 4.311275e-05 0.001 4.311280e-05 0.0 4.311285e-05 0.001 4.311290e-05 0.0 4.311295e-05 0.001 4.311300e-05 0.0 4.311305e-05 0.001 4.311310e-05 0.0 4.311315e-05 0.001 4.311320e-05 0.0 4.311325e-05 0.001 4.311330e-05 0.0 4.311335e-05 0.001 4.311340e-05 0.0 4.311345e-05 0.001 4.311350e-05 0.0 4.311355e-05 0.001 4.311360e-05 0.0 4.311365e-05 0.001 4.311370e-05 0.0 4.311375e-05 0.001 4.311380e-05 0.0 4.311385e-05 0.001 4.311390e-05 0.0 4.311395e-05 0.001 4.311400e-05 0.0 4.311405e-05 0.001 4.311410e-05 0.0 4.311415e-05 0.001 4.311420e-05 0.0 4.311425e-05 0.001 4.311430e-05 0.0 4.311435e-05 0.001 4.311440e-05 0.0 4.311445e-05 0.001 4.311450e-05 0.0 4.311455e-05 0.001 4.311460e-05 0.0 4.311465e-05 0.001 4.311470e-05 0.0 4.311475e-05 0.001 4.311480e-05 0.0 4.311485e-05 0.001 4.311490e-05 0.0 4.311495e-05 0.001 4.311500e-05 0.0 4.311505e-05 0.001 4.311510e-05 0.0 4.311515e-05 0.001 4.311520e-05 0.0 4.311525e-05 0.001 4.311530e-05 0.0 4.311535e-05 0.001 4.311540e-05 0.0 4.311545e-05 0.001 4.311550e-05 0.0 4.311555e-05 0.001 4.311560e-05 0.0 4.311565e-05 0.001 4.311570e-05 0.0 4.311575e-05 0.001 4.311580e-05 0.0 4.311585e-05 0.001 4.311590e-05 0.0 4.311595e-05 0.001 4.311600e-05 0.0 4.311605e-05 0.001 4.311610e-05 0.0 4.311615e-05 0.001 4.311620e-05 0.0 4.311625e-05 0.001 4.311630e-05 0.0 4.311635e-05 0.001 4.311640e-05 0.0 4.311645e-05 0.001 4.311650e-05 0.0 4.311655e-05 0.001 4.311660e-05 0.0 4.311665e-05 0.001 4.311670e-05 0.0 4.311675e-05 0.001 4.311680e-05 0.0 4.311685e-05 0.001 4.311690e-05 0.0 4.311695e-05 0.001 4.311700e-05 0.0 4.311705e-05 0.001 4.311710e-05 0.0 4.311715e-05 0.001 4.311720e-05 0.0 4.311725e-05 0.001 4.311730e-05 0.0 4.311735e-05 0.001 4.311740e-05 0.0 4.311745e-05 0.001 4.311750e-05 0.0 4.311755e-05 0.001 4.311760e-05 0.0 4.311765e-05 0.001 4.311770e-05 0.0 4.311775e-05 0.001 4.311780e-05 0.0 4.311785e-05 0.001 4.311790e-05 0.0 4.311795e-05 0.001 4.311800e-05 0.0 4.311805e-05 0.001 4.311810e-05 0.0 4.311815e-05 0.001 4.311820e-05 0.0 4.311825e-05 0.001 4.311830e-05 0.0 4.311835e-05 0.001 4.311840e-05 0.0 4.311845e-05 0.001 4.311850e-05 0.0 4.311855e-05 0.001 4.311860e-05 0.0 4.311865e-05 0.001 4.311870e-05 0.0 4.311875e-05 0.001 4.311880e-05 0.0 4.311885e-05 0.001 4.311890e-05 0.0 4.311895e-05 0.001 4.311900e-05 0.0 4.311905e-05 0.001 4.311910e-05 0.0 4.311915e-05 0.001 4.311920e-05 0.0 4.311925e-05 0.001 4.311930e-05 0.0 4.311935e-05 0.001 4.311940e-05 0.0 4.311945e-05 0.001 4.311950e-05 0.0 4.311955e-05 0.001 4.311960e-05 0.0 4.311965e-05 0.001 4.311970e-05 0.0 4.311975e-05 0.001 4.311980e-05 0.0 4.311985e-05 0.001 4.311990e-05 0.0 4.311995e-05 0.001 4.312000e-05 0.0 4.312005e-05 0.001 4.312010e-05 0.0 4.312015e-05 0.001 4.312020e-05 0.0 4.312025e-05 0.001 4.312030e-05 0.0 4.312035e-05 0.001 4.312040e-05 0.0 4.312045e-05 0.001 4.312050e-05 0.0 4.312055e-05 0.001 4.312060e-05 0.0 4.312065e-05 0.001 4.312070e-05 0.0 4.312075e-05 0.001 4.312080e-05 0.0 4.312085e-05 0.001 4.312090e-05 0.0 4.312095e-05 0.001 4.312100e-05 0.0 4.312105e-05 0.001 4.312110e-05 0.0 4.312115e-05 0.001 4.312120e-05 0.0 4.312125e-05 0.001 4.312130e-05 0.0 4.312135e-05 0.001 4.312140e-05 0.0 4.312145e-05 0.001 4.312150e-05 0.0 4.312155e-05 0.001 4.312160e-05 0.0 4.312165e-05 0.001 4.312170e-05 0.0 4.312175e-05 0.001 4.312180e-05 0.0 4.312185e-05 0.001 4.312190e-05 0.0 4.312195e-05 0.001 4.312200e-05 0.0 4.312205e-05 0.001 4.312210e-05 0.0 4.312215e-05 0.001 4.312220e-05 0.0 4.312225e-05 0.001 4.312230e-05 0.0 4.312235e-05 0.001 4.312240e-05 0.0 4.312245e-05 0.001 4.312250e-05 0.0 4.312255e-05 0.001 4.312260e-05 0.0 4.312265e-05 0.001 4.312270e-05 0.0 4.312275e-05 0.001 4.312280e-05 0.0 4.312285e-05 0.001 4.312290e-05 0.0 4.312295e-05 0.001 4.312300e-05 0.0 4.312305e-05 0.001 4.312310e-05 0.0 4.312315e-05 0.001 4.312320e-05 0.0 4.312325e-05 0.001 4.312330e-05 0.0 4.312335e-05 0.001 4.312340e-05 0.0 4.312345e-05 0.001 4.312350e-05 0.0 4.312355e-05 0.001 4.312360e-05 0.0 4.312365e-05 0.001 4.312370e-05 0.0 4.312375e-05 0.001 4.312380e-05 0.0 4.312385e-05 0.001 4.312390e-05 0.0 4.312395e-05 0.001 4.312400e-05 0.0 4.312405e-05 0.001 4.312410e-05 0.0 4.312415e-05 0.001 4.312420e-05 0.0 4.312425e-05 0.001 4.312430e-05 0.0 4.312435e-05 0.001 4.312440e-05 0.0 4.312445e-05 0.001 4.312450e-05 0.0 4.312455e-05 0.001 4.312460e-05 0.0 4.312465e-05 0.001 4.312470e-05 0.0 4.312475e-05 0.001 4.312480e-05 0.0 4.312485e-05 0.001 4.312490e-05 0.0 4.312495e-05 0.001 4.312500e-05 0.0 4.312505e-05 0.001 4.312510e-05 0.0 4.312515e-05 0.001 4.312520e-05 0.0 4.312525e-05 0.001 4.312530e-05 0.0 4.312535e-05 0.001 4.312540e-05 0.0 4.312545e-05 0.001 4.312550e-05 0.0 4.312555e-05 0.001 4.312560e-05 0.0 4.312565e-05 0.001 4.312570e-05 0.0 4.312575e-05 0.001 4.312580e-05 0.0 4.312585e-05 0.001 4.312590e-05 0.0 4.312595e-05 0.001 4.312600e-05 0.0 4.312605e-05 0.001 4.312610e-05 0.0 4.312615e-05 0.001 4.312620e-05 0.0 4.312625e-05 0.001 4.312630e-05 0.0 4.312635e-05 0.001 4.312640e-05 0.0 4.312645e-05 0.001 4.312650e-05 0.0 4.312655e-05 0.001 4.312660e-05 0.0 4.312665e-05 0.001 4.312670e-05 0.0 4.312675e-05 0.001 4.312680e-05 0.0 4.312685e-05 0.001 4.312690e-05 0.0 4.312695e-05 0.001 4.312700e-05 0.0 4.312705e-05 0.001 4.312710e-05 0.0 4.312715e-05 0.001 4.312720e-05 0.0 4.312725e-05 0.001 4.312730e-05 0.0 4.312735e-05 0.001 4.312740e-05 0.0 4.312745e-05 0.001 4.312750e-05 0.0 4.312755e-05 0.001 4.312760e-05 0.0 4.312765e-05 0.001 4.312770e-05 0.0 4.312775e-05 0.001 4.312780e-05 0.0 4.312785e-05 0.001 4.312790e-05 0.0 4.312795e-05 0.001 4.312800e-05 0.0 4.312805e-05 0.001 4.312810e-05 0.0 4.312815e-05 0.001 4.312820e-05 0.0 4.312825e-05 0.001 4.312830e-05 0.0 4.312835e-05 0.001 4.312840e-05 0.0 4.312845e-05 0.001 4.312850e-05 0.0 4.312855e-05 0.001 4.312860e-05 0.0 4.312865e-05 0.001 4.312870e-05 0.0 4.312875e-05 0.001 4.312880e-05 0.0 4.312885e-05 0.001 4.312890e-05 0.0 4.312895e-05 0.001 4.312900e-05 0.0 4.312905e-05 0.001 4.312910e-05 0.0 4.312915e-05 0.001 4.312920e-05 0.0 4.312925e-05 0.001 4.312930e-05 0.0 4.312935e-05 0.001 4.312940e-05 0.0 4.312945e-05 0.001 4.312950e-05 0.0 4.312955e-05 0.001 4.312960e-05 0.0 4.312965e-05 0.001 4.312970e-05 0.0 4.312975e-05 0.001 4.312980e-05 0.0 4.312985e-05 0.001 4.312990e-05 0.0 4.312995e-05 0.001 4.313000e-05 0.0 4.313005e-05 0.001 4.313010e-05 0.0 4.313015e-05 0.001 4.313020e-05 0.0 4.313025e-05 0.001 4.313030e-05 0.0 4.313035e-05 0.001 4.313040e-05 0.0 4.313045e-05 0.001 4.313050e-05 0.0 4.313055e-05 0.001 4.313060e-05 0.0 4.313065e-05 0.001 4.313070e-05 0.0 4.313075e-05 0.001 4.313080e-05 0.0 4.313085e-05 0.001 4.313090e-05 0.0 4.313095e-05 0.001 4.313100e-05 0.0 4.313105e-05 0.001 4.313110e-05 0.0 4.313115e-05 0.001 4.313120e-05 0.0 4.313125e-05 0.001 4.313130e-05 0.0 4.313135e-05 0.001 4.313140e-05 0.0 4.313145e-05 0.001 4.313150e-05 0.0 4.313155e-05 0.001 4.313160e-05 0.0 4.313165e-05 0.001 4.313170e-05 0.0 4.313175e-05 0.001 4.313180e-05 0.0 4.313185e-05 0.001 4.313190e-05 0.0 4.313195e-05 0.001 4.313200e-05 0.0 4.313205e-05 0.001 4.313210e-05 0.0 4.313215e-05 0.001 4.313220e-05 0.0 4.313225e-05 0.001 4.313230e-05 0.0 4.313235e-05 0.001 4.313240e-05 0.0 4.313245e-05 0.001 4.313250e-05 0.0 4.313255e-05 0.001 4.313260e-05 0.0 4.313265e-05 0.001 4.313270e-05 0.0 4.313275e-05 0.001 4.313280e-05 0.0 4.313285e-05 0.001 4.313290e-05 0.0 4.313295e-05 0.001 4.313300e-05 0.0 4.313305e-05 0.001 4.313310e-05 0.0 4.313315e-05 0.001 4.313320e-05 0.0 4.313325e-05 0.001 4.313330e-05 0.0 4.313335e-05 0.001 4.313340e-05 0.0 4.313345e-05 0.001 4.313350e-05 0.0 4.313355e-05 0.001 4.313360e-05 0.0 4.313365e-05 0.001 4.313370e-05 0.0 4.313375e-05 0.001 4.313380e-05 0.0 4.313385e-05 0.001 4.313390e-05 0.0 4.313395e-05 0.001 4.313400e-05 0.0 4.313405e-05 0.001 4.313410e-05 0.0 4.313415e-05 0.001 4.313420e-05 0.0 4.313425e-05 0.001 4.313430e-05 0.0 4.313435e-05 0.001 4.313440e-05 0.0 4.313445e-05 0.001 4.313450e-05 0.0 4.313455e-05 0.001 4.313460e-05 0.0 4.313465e-05 0.001 4.313470e-05 0.0 4.313475e-05 0.001 4.313480e-05 0.0 4.313485e-05 0.001 4.313490e-05 0.0 4.313495e-05 0.001 4.313500e-05 0.0 4.313505e-05 0.001 4.313510e-05 0.0 4.313515e-05 0.001 4.313520e-05 0.0 4.313525e-05 0.001 4.313530e-05 0.0 4.313535e-05 0.001 4.313540e-05 0.0 4.313545e-05 0.001 4.313550e-05 0.0 4.313555e-05 0.001 4.313560e-05 0.0 4.313565e-05 0.001 4.313570e-05 0.0 4.313575e-05 0.001 4.313580e-05 0.0 4.313585e-05 0.001 4.313590e-05 0.0 4.313595e-05 0.001 4.313600e-05 0.0 4.313605e-05 0.001 4.313610e-05 0.0 4.313615e-05 0.001 4.313620e-05 0.0 4.313625e-05 0.001 4.313630e-05 0.0 4.313635e-05 0.001 4.313640e-05 0.0 4.313645e-05 0.001 4.313650e-05 0.0 4.313655e-05 0.001 4.313660e-05 0.0 4.313665e-05 0.001 4.313670e-05 0.0 4.313675e-05 0.001 4.313680e-05 0.0 4.313685e-05 0.001 4.313690e-05 0.0 4.313695e-05 0.001 4.313700e-05 0.0 4.313705e-05 0.001 4.313710e-05 0.0 4.313715e-05 0.001 4.313720e-05 0.0 4.313725e-05 0.001 4.313730e-05 0.0 4.313735e-05 0.001 4.313740e-05 0.0 4.313745e-05 0.001 4.313750e-05 0.0 4.313755e-05 0.001 4.313760e-05 0.0 4.313765e-05 0.001 4.313770e-05 0.0 4.313775e-05 0.001 4.313780e-05 0.0 4.313785e-05 0.001 4.313790e-05 0.0 4.313795e-05 0.001 4.313800e-05 0.0 4.313805e-05 0.001 4.313810e-05 0.0 4.313815e-05 0.001 4.313820e-05 0.0 4.313825e-05 0.001 4.313830e-05 0.0 4.313835e-05 0.001 4.313840e-05 0.0 4.313845e-05 0.001 4.313850e-05 0.0 4.313855e-05 0.001 4.313860e-05 0.0 4.313865e-05 0.001 4.313870e-05 0.0 4.313875e-05 0.001 4.313880e-05 0.0 4.313885e-05 0.001 4.313890e-05 0.0 4.313895e-05 0.001 4.313900e-05 0.0 4.313905e-05 0.001 4.313910e-05 0.0 4.313915e-05 0.001 4.313920e-05 0.0 4.313925e-05 0.001 4.313930e-05 0.0 4.313935e-05 0.001 4.313940e-05 0.0 4.313945e-05 0.001 4.313950e-05 0.0 4.313955e-05 0.001 4.313960e-05 0.0 4.313965e-05 0.001 4.313970e-05 0.0 4.313975e-05 0.001 4.313980e-05 0.0 4.313985e-05 0.001 4.313990e-05 0.0 4.313995e-05 0.001 4.314000e-05 0.0 4.314005e-05 0.001 4.314010e-05 0.0 4.314015e-05 0.001 4.314020e-05 0.0 4.314025e-05 0.001 4.314030e-05 0.0 4.314035e-05 0.001 4.314040e-05 0.0 4.314045e-05 0.001 4.314050e-05 0.0 4.314055e-05 0.001 4.314060e-05 0.0 4.314065e-05 0.001 4.314070e-05 0.0 4.314075e-05 0.001 4.314080e-05 0.0 4.314085e-05 0.001 4.314090e-05 0.0 4.314095e-05 0.001 4.314100e-05 0.0 4.314105e-05 0.001 4.314110e-05 0.0 4.314115e-05 0.001 4.314120e-05 0.0 4.314125e-05 0.001 4.314130e-05 0.0 4.314135e-05 0.001 4.314140e-05 0.0 4.314145e-05 0.001 4.314150e-05 0.0 4.314155e-05 0.001 4.314160e-05 0.0 4.314165e-05 0.001 4.314170e-05 0.0 4.314175e-05 0.001 4.314180e-05 0.0 4.314185e-05 0.001 4.314190e-05 0.0 4.314195e-05 0.001 4.314200e-05 0.0 4.314205e-05 0.001 4.314210e-05 0.0 4.314215e-05 0.001 4.314220e-05 0.0 4.314225e-05 0.001 4.314230e-05 0.0 4.314235e-05 0.001 4.314240e-05 0.0 4.314245e-05 0.001 4.314250e-05 0.0 4.314255e-05 0.001 4.314260e-05 0.0 4.314265e-05 0.001 4.314270e-05 0.0 4.314275e-05 0.001 4.314280e-05 0.0 4.314285e-05 0.001 4.314290e-05 0.0 4.314295e-05 0.001 4.314300e-05 0.0 4.314305e-05 0.001 4.314310e-05 0.0 4.314315e-05 0.001 4.314320e-05 0.0 4.314325e-05 0.001 4.314330e-05 0.0 4.314335e-05 0.001 4.314340e-05 0.0 4.314345e-05 0.001 4.314350e-05 0.0 4.314355e-05 0.001 4.314360e-05 0.0 4.314365e-05 0.001 4.314370e-05 0.0 4.314375e-05 0.001 4.314380e-05 0.0 4.314385e-05 0.001 4.314390e-05 0.0 4.314395e-05 0.001 4.314400e-05 0.0 4.314405e-05 0.001 4.314410e-05 0.0 4.314415e-05 0.001 4.314420e-05 0.0 4.314425e-05 0.001 4.314430e-05 0.0 4.314435e-05 0.001 4.314440e-05 0.0 4.314445e-05 0.001 4.314450e-05 0.0 4.314455e-05 0.001 4.314460e-05 0.0 4.314465e-05 0.001 4.314470e-05 0.0 4.314475e-05 0.001 4.314480e-05 0.0 4.314485e-05 0.001 4.314490e-05 0.0 4.314495e-05 0.001 4.314500e-05 0.0 4.314505e-05 0.001 4.314510e-05 0.0 4.314515e-05 0.001 4.314520e-05 0.0 4.314525e-05 0.001 4.314530e-05 0.0 4.314535e-05 0.001 4.314540e-05 0.0 4.314545e-05 0.001 4.314550e-05 0.0 4.314555e-05 0.001 4.314560e-05 0.0 4.314565e-05 0.001 4.314570e-05 0.0 4.314575e-05 0.001 4.314580e-05 0.0 4.314585e-05 0.001 4.314590e-05 0.0 4.314595e-05 0.001 4.314600e-05 0.0 4.314605e-05 0.001 4.314610e-05 0.0 4.314615e-05 0.001 4.314620e-05 0.0 4.314625e-05 0.001 4.314630e-05 0.0 4.314635e-05 0.001 4.314640e-05 0.0 4.314645e-05 0.001 4.314650e-05 0.0 4.314655e-05 0.001 4.314660e-05 0.0 4.314665e-05 0.001 4.314670e-05 0.0 4.314675e-05 0.001 4.314680e-05 0.0 4.314685e-05 0.001 4.314690e-05 0.0 4.314695e-05 0.001 4.314700e-05 0.0 4.314705e-05 0.001 4.314710e-05 0.0 4.314715e-05 0.001 4.314720e-05 0.0 4.314725e-05 0.001 4.314730e-05 0.0 4.314735e-05 0.001 4.314740e-05 0.0 4.314745e-05 0.001 4.314750e-05 0.0 4.314755e-05 0.001 4.314760e-05 0.0 4.314765e-05 0.001 4.314770e-05 0.0 4.314775e-05 0.001 4.314780e-05 0.0 4.314785e-05 0.001 4.314790e-05 0.0 4.314795e-05 0.001 4.314800e-05 0.0 4.314805e-05 0.001 4.314810e-05 0.0 4.314815e-05 0.001 4.314820e-05 0.0 4.314825e-05 0.001 4.314830e-05 0.0 4.314835e-05 0.001 4.314840e-05 0.0 4.314845e-05 0.001 4.314850e-05 0.0 4.314855e-05 0.001 4.314860e-05 0.0 4.314865e-05 0.001 4.314870e-05 0.0 4.314875e-05 0.001 4.314880e-05 0.0 4.314885e-05 0.001 4.314890e-05 0.0 4.314895e-05 0.001 4.314900e-05 0.0 4.314905e-05 0.001 4.314910e-05 0.0 4.314915e-05 0.001 4.314920e-05 0.0 4.314925e-05 0.001 4.314930e-05 0.0 4.314935e-05 0.001 4.314940e-05 0.0 4.314945e-05 0.001 4.314950e-05 0.0 4.314955e-05 0.001 4.314960e-05 0.0 4.314965e-05 0.001 4.314970e-05 0.0 4.314975e-05 0.001 4.314980e-05 0.0 4.314985e-05 0.001 4.314990e-05 0.0 4.314995e-05 0.001 4.315000e-05 0.0 4.315005e-05 0.001 4.315010e-05 0.0 4.315015e-05 0.001 4.315020e-05 0.0 4.315025e-05 0.001 4.315030e-05 0.0 4.315035e-05 0.001 4.315040e-05 0.0 4.315045e-05 0.001 4.315050e-05 0.0 4.315055e-05 0.001 4.315060e-05 0.0 4.315065e-05 0.001 4.315070e-05 0.0 4.315075e-05 0.001 4.315080e-05 0.0 4.315085e-05 0.001 4.315090e-05 0.0 4.315095e-05 0.001 4.315100e-05 0.0 4.315105e-05 0.001 4.315110e-05 0.0 4.315115e-05 0.001 4.315120e-05 0.0 4.315125e-05 0.001 4.315130e-05 0.0 4.315135e-05 0.001 4.315140e-05 0.0 4.315145e-05 0.001 4.315150e-05 0.0 4.315155e-05 0.001 4.315160e-05 0.0 4.315165e-05 0.001 4.315170e-05 0.0 4.315175e-05 0.001 4.315180e-05 0.0 4.315185e-05 0.001 4.315190e-05 0.0 4.315195e-05 0.001 4.315200e-05 0.0 4.315205e-05 0.001 4.315210e-05 0.0 4.315215e-05 0.001 4.315220e-05 0.0 4.315225e-05 0.001 4.315230e-05 0.0 4.315235e-05 0.001 4.315240e-05 0.0 4.315245e-05 0.001 4.315250e-05 0.0 4.315255e-05 0.001 4.315260e-05 0.0 4.315265e-05 0.001 4.315270e-05 0.0 4.315275e-05 0.001 4.315280e-05 0.0 4.315285e-05 0.001 4.315290e-05 0.0 4.315295e-05 0.001 4.315300e-05 0.0 4.315305e-05 0.001 4.315310e-05 0.0 4.315315e-05 0.001 4.315320e-05 0.0 4.315325e-05 0.001 4.315330e-05 0.0 4.315335e-05 0.001 4.315340e-05 0.0 4.315345e-05 0.001 4.315350e-05 0.0 4.315355e-05 0.001 4.315360e-05 0.0 4.315365e-05 0.001 4.315370e-05 0.0 4.315375e-05 0.001 4.315380e-05 0.0 4.315385e-05 0.001 4.315390e-05 0.0 4.315395e-05 0.001 4.315400e-05 0.0 4.315405e-05 0.001 4.315410e-05 0.0 4.315415e-05 0.001 4.315420e-05 0.0 4.315425e-05 0.001 4.315430e-05 0.0 4.315435e-05 0.001 4.315440e-05 0.0 4.315445e-05 0.001 4.315450e-05 0.0 4.315455e-05 0.001 4.315460e-05 0.0 4.315465e-05 0.001 4.315470e-05 0.0 4.315475e-05 0.001 4.315480e-05 0.0 4.315485e-05 0.001 4.315490e-05 0.0 4.315495e-05 0.001 4.315500e-05 0.0 4.315505e-05 0.001 4.315510e-05 0.0 4.315515e-05 0.001 4.315520e-05 0.0 4.315525e-05 0.001 4.315530e-05 0.0 4.315535e-05 0.001 4.315540e-05 0.0 4.315545e-05 0.001 4.315550e-05 0.0 4.315555e-05 0.001 4.315560e-05 0.0 4.315565e-05 0.001 4.315570e-05 0.0 4.315575e-05 0.001 4.315580e-05 0.0 4.315585e-05 0.001 4.315590e-05 0.0 4.315595e-05 0.001 4.315600e-05 0.0 4.315605e-05 0.001 4.315610e-05 0.0 4.315615e-05 0.001 4.315620e-05 0.0 4.315625e-05 0.001 4.315630e-05 0.0 4.315635e-05 0.001 4.315640e-05 0.0 4.315645e-05 0.001 4.315650e-05 0.0 4.315655e-05 0.001 4.315660e-05 0.0 4.315665e-05 0.001 4.315670e-05 0.0 4.315675e-05 0.001 4.315680e-05 0.0 4.315685e-05 0.001 4.315690e-05 0.0 4.315695e-05 0.001 4.315700e-05 0.0 4.315705e-05 0.001 4.315710e-05 0.0 4.315715e-05 0.001 4.315720e-05 0.0 4.315725e-05 0.001 4.315730e-05 0.0 4.315735e-05 0.001 4.315740e-05 0.0 4.315745e-05 0.001 4.315750e-05 0.0 4.315755e-05 0.001 4.315760e-05 0.0 4.315765e-05 0.001 4.315770e-05 0.0 4.315775e-05 0.001 4.315780e-05 0.0 4.315785e-05 0.001 4.315790e-05 0.0 4.315795e-05 0.001 4.315800e-05 0.0 4.315805e-05 0.001 4.315810e-05 0.0 4.315815e-05 0.001 4.315820e-05 0.0 4.315825e-05 0.001 4.315830e-05 0.0 4.315835e-05 0.001 4.315840e-05 0.0 4.315845e-05 0.001 4.315850e-05 0.0 4.315855e-05 0.001 4.315860e-05 0.0 4.315865e-05 0.001 4.315870e-05 0.0 4.315875e-05 0.001 4.315880e-05 0.0 4.315885e-05 0.001 4.315890e-05 0.0 4.315895e-05 0.001 4.315900e-05 0.0 4.315905e-05 0.001 4.315910e-05 0.0 4.315915e-05 0.001 4.315920e-05 0.0 4.315925e-05 0.001 4.315930e-05 0.0 4.315935e-05 0.001 4.315940e-05 0.0 4.315945e-05 0.001 4.315950e-05 0.0 4.315955e-05 0.001 4.315960e-05 0.0 4.315965e-05 0.001 4.315970e-05 0.0 4.315975e-05 0.001 4.315980e-05 0.0 4.315985e-05 0.001 4.315990e-05 0.0 4.315995e-05 0.001 4.316000e-05 0.0 4.316005e-05 0.001 4.316010e-05 0.0 4.316015e-05 0.001 4.316020e-05 0.0 4.316025e-05 0.001 4.316030e-05 0.0 4.316035e-05 0.001 4.316040e-05 0.0 4.316045e-05 0.001 4.316050e-05 0.0 4.316055e-05 0.001 4.316060e-05 0.0 4.316065e-05 0.001 4.316070e-05 0.0 4.316075e-05 0.001 4.316080e-05 0.0 4.316085e-05 0.001 4.316090e-05 0.0 4.316095e-05 0.001 4.316100e-05 0.0 4.316105e-05 0.001 4.316110e-05 0.0 4.316115e-05 0.001 4.316120e-05 0.0 4.316125e-05 0.001 4.316130e-05 0.0 4.316135e-05 0.001 4.316140e-05 0.0 4.316145e-05 0.001 4.316150e-05 0.0 4.316155e-05 0.001 4.316160e-05 0.0 4.316165e-05 0.001 4.316170e-05 0.0 4.316175e-05 0.001 4.316180e-05 0.0 4.316185e-05 0.001 4.316190e-05 0.0 4.316195e-05 0.001 4.316200e-05 0.0 4.316205e-05 0.001 4.316210e-05 0.0 4.316215e-05 0.001 4.316220e-05 0.0 4.316225e-05 0.001 4.316230e-05 0.0 4.316235e-05 0.001 4.316240e-05 0.0 4.316245e-05 0.001 4.316250e-05 0.0 4.316255e-05 0.001 4.316260e-05 0.0 4.316265e-05 0.001 4.316270e-05 0.0 4.316275e-05 0.001 4.316280e-05 0.0 4.316285e-05 0.001 4.316290e-05 0.0 4.316295e-05 0.001 4.316300e-05 0.0 4.316305e-05 0.001 4.316310e-05 0.0 4.316315e-05 0.001 4.316320e-05 0.0 4.316325e-05 0.001 4.316330e-05 0.0 4.316335e-05 0.001 4.316340e-05 0.0 4.316345e-05 0.001 4.316350e-05 0.0 4.316355e-05 0.001 4.316360e-05 0.0 4.316365e-05 0.001 4.316370e-05 0.0 4.316375e-05 0.001 4.316380e-05 0.0 4.316385e-05 0.001 4.316390e-05 0.0 4.316395e-05 0.001 4.316400e-05 0.0 4.316405e-05 0.001 4.316410e-05 0.0 4.316415e-05 0.001 4.316420e-05 0.0 4.316425e-05 0.001 4.316430e-05 0.0 4.316435e-05 0.001 4.316440e-05 0.0 4.316445e-05 0.001 4.316450e-05 0.0 4.316455e-05 0.001 4.316460e-05 0.0 4.316465e-05 0.001 4.316470e-05 0.0 4.316475e-05 0.001 4.316480e-05 0.0 4.316485e-05 0.001 4.316490e-05 0.0 4.316495e-05 0.001 4.316500e-05 0.0 4.316505e-05 0.001 4.316510e-05 0.0 4.316515e-05 0.001 4.316520e-05 0.0 4.316525e-05 0.001 4.316530e-05 0.0 4.316535e-05 0.001 4.316540e-05 0.0 4.316545e-05 0.001 4.316550e-05 0.0 4.316555e-05 0.001 4.316560e-05 0.0 4.316565e-05 0.001 4.316570e-05 0.0 4.316575e-05 0.001 4.316580e-05 0.0 4.316585e-05 0.001 4.316590e-05 0.0 4.316595e-05 0.001 4.316600e-05 0.0 4.316605e-05 0.001 4.316610e-05 0.0 4.316615e-05 0.001 4.316620e-05 0.0 4.316625e-05 0.001 4.316630e-05 0.0 4.316635e-05 0.001 4.316640e-05 0.0 4.316645e-05 0.001 4.316650e-05 0.0 4.316655e-05 0.001 4.316660e-05 0.0 4.316665e-05 0.001 4.316670e-05 0.0 4.316675e-05 0.001 4.316680e-05 0.0 4.316685e-05 0.001 4.316690e-05 0.0 4.316695e-05 0.001 4.316700e-05 0.0 4.316705e-05 0.001 4.316710e-05 0.0 4.316715e-05 0.001 4.316720e-05 0.0 4.316725e-05 0.001 4.316730e-05 0.0 4.316735e-05 0.001 4.316740e-05 0.0 4.316745e-05 0.001 4.316750e-05 0.0 4.316755e-05 0.001 4.316760e-05 0.0 4.316765e-05 0.001 4.316770e-05 0.0 4.316775e-05 0.001 4.316780e-05 0.0 4.316785e-05 0.001 4.316790e-05 0.0 4.316795e-05 0.001 4.316800e-05 0.0 4.316805e-05 0.001 4.316810e-05 0.0 4.316815e-05 0.001 4.316820e-05 0.0 4.316825e-05 0.001 4.316830e-05 0.0 4.316835e-05 0.001 4.316840e-05 0.0 4.316845e-05 0.001 4.316850e-05 0.0 4.316855e-05 0.001 4.316860e-05 0.0 4.316865e-05 0.001 4.316870e-05 0.0 4.316875e-05 0.001 4.316880e-05 0.0 4.316885e-05 0.001 4.316890e-05 0.0 4.316895e-05 0.001 4.316900e-05 0.0 4.316905e-05 0.001 4.316910e-05 0.0 4.316915e-05 0.001 4.316920e-05 0.0 4.316925e-05 0.001 4.316930e-05 0.0 4.316935e-05 0.001 4.316940e-05 0.0 4.316945e-05 0.001 4.316950e-05 0.0 4.316955e-05 0.001 4.316960e-05 0.0 4.316965e-05 0.001 4.316970e-05 0.0 4.316975e-05 0.001 4.316980e-05 0.0 4.316985e-05 0.001 4.316990e-05 0.0 4.316995e-05 0.001 4.317000e-05 0.0 4.317005e-05 0.001 4.317010e-05 0.0 4.317015e-05 0.001 4.317020e-05 0.0 4.317025e-05 0.001 4.317030e-05 0.0 4.317035e-05 0.001 4.317040e-05 0.0 4.317045e-05 0.001 4.317050e-05 0.0 4.317055e-05 0.001 4.317060e-05 0.0 4.317065e-05 0.001 4.317070e-05 0.0 4.317075e-05 0.001 4.317080e-05 0.0 4.317085e-05 0.001 4.317090e-05 0.0 4.317095e-05 0.001 4.317100e-05 0.0 4.317105e-05 0.001 4.317110e-05 0.0 4.317115e-05 0.001 4.317120e-05 0.0 4.317125e-05 0.001 4.317130e-05 0.0 4.317135e-05 0.001 4.317140e-05 0.0 4.317145e-05 0.001 4.317150e-05 0.0 4.317155e-05 0.001 4.317160e-05 0.0 4.317165e-05 0.001 4.317170e-05 0.0 4.317175e-05 0.001 4.317180e-05 0.0 4.317185e-05 0.001 4.317190e-05 0.0 4.317195e-05 0.001 4.317200e-05 0.0 4.317205e-05 0.001 4.317210e-05 0.0 4.317215e-05 0.001 4.317220e-05 0.0 4.317225e-05 0.001 4.317230e-05 0.0 4.317235e-05 0.001 4.317240e-05 0.0 4.317245e-05 0.001 4.317250e-05 0.0 4.317255e-05 0.001 4.317260e-05 0.0 4.317265e-05 0.001 4.317270e-05 0.0 4.317275e-05 0.001 4.317280e-05 0.0 4.317285e-05 0.001 4.317290e-05 0.0 4.317295e-05 0.001 4.317300e-05 0.0 4.317305e-05 0.001 4.317310e-05 0.0 4.317315e-05 0.001 4.317320e-05 0.0 4.317325e-05 0.001 4.317330e-05 0.0 4.317335e-05 0.001 4.317340e-05 0.0 4.317345e-05 0.001 4.317350e-05 0.0 4.317355e-05 0.001 4.317360e-05 0.0 4.317365e-05 0.001 4.317370e-05 0.0 4.317375e-05 0.001 4.317380e-05 0.0 4.317385e-05 0.001 4.317390e-05 0.0 4.317395e-05 0.001 4.317400e-05 0.0 4.317405e-05 0.001 4.317410e-05 0.0 4.317415e-05 0.001 4.317420e-05 0.0 4.317425e-05 0.001 4.317430e-05 0.0 4.317435e-05 0.001 4.317440e-05 0.0 4.317445e-05 0.001 4.317450e-05 0.0 4.317455e-05 0.001 4.317460e-05 0.0 4.317465e-05 0.001 4.317470e-05 0.0 4.317475e-05 0.001 4.317480e-05 0.0 4.317485e-05 0.001 4.317490e-05 0.0 4.317495e-05 0.001 4.317500e-05 0.0 4.317505e-05 0.001 4.317510e-05 0.0 4.317515e-05 0.001 4.317520e-05 0.0 4.317525e-05 0.001 4.317530e-05 0.0 4.317535e-05 0.001 4.317540e-05 0.0 4.317545e-05 0.001 4.317550e-05 0.0 4.317555e-05 0.001 4.317560e-05 0.0 4.317565e-05 0.001 4.317570e-05 0.0 4.317575e-05 0.001 4.317580e-05 0.0 4.317585e-05 0.001 4.317590e-05 0.0 4.317595e-05 0.001 4.317600e-05 0.0 4.317605e-05 0.001 4.317610e-05 0.0 4.317615e-05 0.001 4.317620e-05 0.0 4.317625e-05 0.001 4.317630e-05 0.0 4.317635e-05 0.001 4.317640e-05 0.0 4.317645e-05 0.001 4.317650e-05 0.0 4.317655e-05 0.001 4.317660e-05 0.0 4.317665e-05 0.001 4.317670e-05 0.0 4.317675e-05 0.001 4.317680e-05 0.0 4.317685e-05 0.001 4.317690e-05 0.0 4.317695e-05 0.001 4.317700e-05 0.0 4.317705e-05 0.001 4.317710e-05 0.0 4.317715e-05 0.001 4.317720e-05 0.0 4.317725e-05 0.001 4.317730e-05 0.0 4.317735e-05 0.001 4.317740e-05 0.0 4.317745e-05 0.001 4.317750e-05 0.0 4.317755e-05 0.001 4.317760e-05 0.0 4.317765e-05 0.001 4.317770e-05 0.0 4.317775e-05 0.001 4.317780e-05 0.0 4.317785e-05 0.001 4.317790e-05 0.0 4.317795e-05 0.001 4.317800e-05 0.0 4.317805e-05 0.001 4.317810e-05 0.0 4.317815e-05 0.001 4.317820e-05 0.0 4.317825e-05 0.001 4.317830e-05 0.0 4.317835e-05 0.001 4.317840e-05 0.0 4.317845e-05 0.001 4.317850e-05 0.0 4.317855e-05 0.001 4.317860e-05 0.0 4.317865e-05 0.001 4.317870e-05 0.0 4.317875e-05 0.001 4.317880e-05 0.0 4.317885e-05 0.001 4.317890e-05 0.0 4.317895e-05 0.001 4.317900e-05 0.0 4.317905e-05 0.001 4.317910e-05 0.0 4.317915e-05 0.001 4.317920e-05 0.0 4.317925e-05 0.001 4.317930e-05 0.0 4.317935e-05 0.001 4.317940e-05 0.0 4.317945e-05 0.001 4.317950e-05 0.0 4.317955e-05 0.001 4.317960e-05 0.0 4.317965e-05 0.001 4.317970e-05 0.0 4.317975e-05 0.001 4.317980e-05 0.0 4.317985e-05 0.001 4.317990e-05 0.0 4.317995e-05 0.001 4.318000e-05 0.0 4.318005e-05 0.001 4.318010e-05 0.0 4.318015e-05 0.001 4.318020e-05 0.0 4.318025e-05 0.001 4.318030e-05 0.0 4.318035e-05 0.001 4.318040e-05 0.0 4.318045e-05 0.001 4.318050e-05 0.0 4.318055e-05 0.001 4.318060e-05 0.0 4.318065e-05 0.001 4.318070e-05 0.0 4.318075e-05 0.001 4.318080e-05 0.0 4.318085e-05 0.001 4.318090e-05 0.0 4.318095e-05 0.001 4.318100e-05 0.0 4.318105e-05 0.001 4.318110e-05 0.0 4.318115e-05 0.001 4.318120e-05 0.0 4.318125e-05 0.001 4.318130e-05 0.0 4.318135e-05 0.001 4.318140e-05 0.0 4.318145e-05 0.001 4.318150e-05 0.0 4.318155e-05 0.001 4.318160e-05 0.0 4.318165e-05 0.001 4.318170e-05 0.0 4.318175e-05 0.001 4.318180e-05 0.0 4.318185e-05 0.001 4.318190e-05 0.0 4.318195e-05 0.001 4.318200e-05 0.0 4.318205e-05 0.001 4.318210e-05 0.0 4.318215e-05 0.001 4.318220e-05 0.0 4.318225e-05 0.001 4.318230e-05 0.0 4.318235e-05 0.001 4.318240e-05 0.0 4.318245e-05 0.001 4.318250e-05 0.0 4.318255e-05 0.001 4.318260e-05 0.0 4.318265e-05 0.001 4.318270e-05 0.0 4.318275e-05 0.001 4.318280e-05 0.0 4.318285e-05 0.001 4.318290e-05 0.0 4.318295e-05 0.001 4.318300e-05 0.0 4.318305e-05 0.001 4.318310e-05 0.0 4.318315e-05 0.001 4.318320e-05 0.0 4.318325e-05 0.001 4.318330e-05 0.0 4.318335e-05 0.001 4.318340e-05 0.0 4.318345e-05 0.001 4.318350e-05 0.0 4.318355e-05 0.001 4.318360e-05 0.0 4.318365e-05 0.001 4.318370e-05 0.0 4.318375e-05 0.001 4.318380e-05 0.0 4.318385e-05 0.001 4.318390e-05 0.0 4.318395e-05 0.001 4.318400e-05 0.0 4.318405e-05 0.001 4.318410e-05 0.0 4.318415e-05 0.001 4.318420e-05 0.0 4.318425e-05 0.001 4.318430e-05 0.0 4.318435e-05 0.001 4.318440e-05 0.0 4.318445e-05 0.001 4.318450e-05 0.0 4.318455e-05 0.001 4.318460e-05 0.0 4.318465e-05 0.001 4.318470e-05 0.0 4.318475e-05 0.001 4.318480e-05 0.0 4.318485e-05 0.001 4.318490e-05 0.0 4.318495e-05 0.001 4.318500e-05 0.0 4.318505e-05 0.001 4.318510e-05 0.0 4.318515e-05 0.001 4.318520e-05 0.0 4.318525e-05 0.001 4.318530e-05 0.0 4.318535e-05 0.001 4.318540e-05 0.0 4.318545e-05 0.001 4.318550e-05 0.0 4.318555e-05 0.001 4.318560e-05 0.0 4.318565e-05 0.001 4.318570e-05 0.0 4.318575e-05 0.001 4.318580e-05 0.0 4.318585e-05 0.001 4.318590e-05 0.0 4.318595e-05 0.001 4.318600e-05 0.0 4.318605e-05 0.001 4.318610e-05 0.0 4.318615e-05 0.001 4.318620e-05 0.0 4.318625e-05 0.001 4.318630e-05 0.0 4.318635e-05 0.001 4.318640e-05 0.0 4.318645e-05 0.001 4.318650e-05 0.0 4.318655e-05 0.001 4.318660e-05 0.0 4.318665e-05 0.001 4.318670e-05 0.0 4.318675e-05 0.001 4.318680e-05 0.0 4.318685e-05 0.001 4.318690e-05 0.0 4.318695e-05 0.001 4.318700e-05 0.0 4.318705e-05 0.001 4.318710e-05 0.0 4.318715e-05 0.001 4.318720e-05 0.0 4.318725e-05 0.001 4.318730e-05 0.0 4.318735e-05 0.001 4.318740e-05 0.0 4.318745e-05 0.001 4.318750e-05 0.0 4.318755e-05 0.001 4.318760e-05 0.0 4.318765e-05 0.001 4.318770e-05 0.0 4.318775e-05 0.001 4.318780e-05 0.0 4.318785e-05 0.001 4.318790e-05 0.0 4.318795e-05 0.001 4.318800e-05 0.0 4.318805e-05 0.001 4.318810e-05 0.0 4.318815e-05 0.001 4.318820e-05 0.0 4.318825e-05 0.001 4.318830e-05 0.0 4.318835e-05 0.001 4.318840e-05 0.0 4.318845e-05 0.001 4.318850e-05 0.0 4.318855e-05 0.001 4.318860e-05 0.0 4.318865e-05 0.001 4.318870e-05 0.0 4.318875e-05 0.001 4.318880e-05 0.0 4.318885e-05 0.001 4.318890e-05 0.0 4.318895e-05 0.001 4.318900e-05 0.0 4.318905e-05 0.001 4.318910e-05 0.0 4.318915e-05 0.001 4.318920e-05 0.0 4.318925e-05 0.001 4.318930e-05 0.0 4.318935e-05 0.001 4.318940e-05 0.0 4.318945e-05 0.001 4.318950e-05 0.0 4.318955e-05 0.001 4.318960e-05 0.0 4.318965e-05 0.001 4.318970e-05 0.0 4.318975e-05 0.001 4.318980e-05 0.0 4.318985e-05 0.001 4.318990e-05 0.0 4.318995e-05 0.001 4.319000e-05 0.0 4.319005e-05 0.001 4.319010e-05 0.0 4.319015e-05 0.001 4.319020e-05 0.0 4.319025e-05 0.001 4.319030e-05 0.0 4.319035e-05 0.001 4.319040e-05 0.0 4.319045e-05 0.001 4.319050e-05 0.0 4.319055e-05 0.001 4.319060e-05 0.0 4.319065e-05 0.001 4.319070e-05 0.0 4.319075e-05 0.001 4.319080e-05 0.0 4.319085e-05 0.001 4.319090e-05 0.0 4.319095e-05 0.001 4.319100e-05 0.0 4.319105e-05 0.001 4.319110e-05 0.0 4.319115e-05 0.001 4.319120e-05 0.0 4.319125e-05 0.001 4.319130e-05 0.0 4.319135e-05 0.001 4.319140e-05 0.0 4.319145e-05 0.001 4.319150e-05 0.0 4.319155e-05 0.001 4.319160e-05 0.0 4.319165e-05 0.001 4.319170e-05 0.0 4.319175e-05 0.001 4.319180e-05 0.0 4.319185e-05 0.001 4.319190e-05 0.0 4.319195e-05 0.001 4.319200e-05 0.0 4.319205e-05 0.001 4.319210e-05 0.0 4.319215e-05 0.001 4.319220e-05 0.0 4.319225e-05 0.001 4.319230e-05 0.0 4.319235e-05 0.001 4.319240e-05 0.0 4.319245e-05 0.001 4.319250e-05 0.0 4.319255e-05 0.001 4.319260e-05 0.0 4.319265e-05 0.001 4.319270e-05 0.0 4.319275e-05 0.001 4.319280e-05 0.0 4.319285e-05 0.001 4.319290e-05 0.0 4.319295e-05 0.001 4.319300e-05 0.0 4.319305e-05 0.001 4.319310e-05 0.0 4.319315e-05 0.001 4.319320e-05 0.0 4.319325e-05 0.001 4.319330e-05 0.0 4.319335e-05 0.001 4.319340e-05 0.0 4.319345e-05 0.001 4.319350e-05 0.0 4.319355e-05 0.001 4.319360e-05 0.0 4.319365e-05 0.001 4.319370e-05 0.0 4.319375e-05 0.001 4.319380e-05 0.0 4.319385e-05 0.001 4.319390e-05 0.0 4.319395e-05 0.001 4.319400e-05 0.0 4.319405e-05 0.001 4.319410e-05 0.0 4.319415e-05 0.001 4.319420e-05 0.0 4.319425e-05 0.001 4.319430e-05 0.0 4.319435e-05 0.001 4.319440e-05 0.0 4.319445e-05 0.001 4.319450e-05 0.0 4.319455e-05 0.001 4.319460e-05 0.0 4.319465e-05 0.001 4.319470e-05 0.0 4.319475e-05 0.001 4.319480e-05 0.0 4.319485e-05 0.001 4.319490e-05 0.0 4.319495e-05 0.001 4.319500e-05 0.0 4.319505e-05 0.001 4.319510e-05 0.0 4.319515e-05 0.001 4.319520e-05 0.0 4.319525e-05 0.001 4.319530e-05 0.0 4.319535e-05 0.001 4.319540e-05 0.0 4.319545e-05 0.001 4.319550e-05 0.0 4.319555e-05 0.001 4.319560e-05 0.0 4.319565e-05 0.001 4.319570e-05 0.0 4.319575e-05 0.001 4.319580e-05 0.0 4.319585e-05 0.001 4.319590e-05 0.0 4.319595e-05 0.001 4.319600e-05 0.0 4.319605e-05 0.001 4.319610e-05 0.0 4.319615e-05 0.001 4.319620e-05 0.0 4.319625e-05 0.001 4.319630e-05 0.0 4.319635e-05 0.001 4.319640e-05 0.0 4.319645e-05 0.001 4.319650e-05 0.0 4.319655e-05 0.001 4.319660e-05 0.0 4.319665e-05 0.001 4.319670e-05 0.0 4.319675e-05 0.001 4.319680e-05 0.0 4.319685e-05 0.001 4.319690e-05 0.0 4.319695e-05 0.001 4.319700e-05 0.0 4.319705e-05 0.001 4.319710e-05 0.0 4.319715e-05 0.001 4.319720e-05 0.0 4.319725e-05 0.001 4.319730e-05 0.0 4.319735e-05 0.001 4.319740e-05 0.0 4.319745e-05 0.001 4.319750e-05 0.0 4.319755e-05 0.001 4.319760e-05 0.0 4.319765e-05 0.001 4.319770e-05 0.0 4.319775e-05 0.001 4.319780e-05 0.0 4.319785e-05 0.001 4.319790e-05 0.0 4.319795e-05 0.001 4.319800e-05 0.0 4.319805e-05 0.001 4.319810e-05 0.0 4.319815e-05 0.001 4.319820e-05 0.0 4.319825e-05 0.001 4.319830e-05 0.0 4.319835e-05 0.001 4.319840e-05 0.0 4.319845e-05 0.001 4.319850e-05 0.0 4.319855e-05 0.001 4.319860e-05 0.0 4.319865e-05 0.001 4.319870e-05 0.0 4.319875e-05 0.001 4.319880e-05 0.0 4.319885e-05 0.001 4.319890e-05 0.0 4.319895e-05 0.001 4.319900e-05 0.0 4.319905e-05 0.001 4.319910e-05 0.0 4.319915e-05 0.001 4.319920e-05 0.0 4.319925e-05 0.001 4.319930e-05 0.0 4.319935e-05 0.001 4.319940e-05 0.0 4.319945e-05 0.001 4.319950e-05 0.0 4.319955e-05 0.001 4.319960e-05 0.0 4.319965e-05 0.001 4.319970e-05 0.0 4.319975e-05 0.001 4.319980e-05 0.0 4.319985e-05 0.001 4.319990e-05 0.0 4.319995e-05 0.001 4.320000e-05 0.0 4.320005e-05 0.001 4.320010e-05 0.0 4.320015e-05 0.001 4.320020e-05 0.0 4.320025e-05 0.001 4.320030e-05 0.0 4.320035e-05 0.001 4.320040e-05 0.0 4.320045e-05 0.001 4.320050e-05 0.0 4.320055e-05 0.001 4.320060e-05 0.0 4.320065e-05 0.001 4.320070e-05 0.0 4.320075e-05 0.001 4.320080e-05 0.0 4.320085e-05 0.001 4.320090e-05 0.0 4.320095e-05 0.001 4.320100e-05 0.0 4.320105e-05 0.001 4.320110e-05 0.0 4.320115e-05 0.001 4.320120e-05 0.0 4.320125e-05 0.001 4.320130e-05 0.0 4.320135e-05 0.001 4.320140e-05 0.0 4.320145e-05 0.001 4.320150e-05 0.0 4.320155e-05 0.001 4.320160e-05 0.0 4.320165e-05 0.001 4.320170e-05 0.0 4.320175e-05 0.001 4.320180e-05 0.0 4.320185e-05 0.001 4.320190e-05 0.0 4.320195e-05 0.001 4.320200e-05 0.0 4.320205e-05 0.001 4.320210e-05 0.0 4.320215e-05 0.001 4.320220e-05 0.0 4.320225e-05 0.001 4.320230e-05 0.0 4.320235e-05 0.001 4.320240e-05 0.0 4.320245e-05 0.001 4.320250e-05 0.0 4.320255e-05 0.001 4.320260e-05 0.0 4.320265e-05 0.001 4.320270e-05 0.0 4.320275e-05 0.001 4.320280e-05 0.0 4.320285e-05 0.001 4.320290e-05 0.0 4.320295e-05 0.001 4.320300e-05 0.0 4.320305e-05 0.001 4.320310e-05 0.0 4.320315e-05 0.001 4.320320e-05 0.0 4.320325e-05 0.001 4.320330e-05 0.0 4.320335e-05 0.001 4.320340e-05 0.0 4.320345e-05 0.001 4.320350e-05 0.0 4.320355e-05 0.001 4.320360e-05 0.0 4.320365e-05 0.001 4.320370e-05 0.0 4.320375e-05 0.001 4.320380e-05 0.0 4.320385e-05 0.001 4.320390e-05 0.0 4.320395e-05 0.001 4.320400e-05 0.0 4.320405e-05 0.001 4.320410e-05 0.0 4.320415e-05 0.001 4.320420e-05 0.0 4.320425e-05 0.001 4.320430e-05 0.0 4.320435e-05 0.001 4.320440e-05 0.0 4.320445e-05 0.001 4.320450e-05 0.0 4.320455e-05 0.001 4.320460e-05 0.0 4.320465e-05 0.001 4.320470e-05 0.0 4.320475e-05 0.001 4.320480e-05 0.0 4.320485e-05 0.001 4.320490e-05 0.0 4.320495e-05 0.001 4.320500e-05 0.0 4.320505e-05 0.001 4.320510e-05 0.0 4.320515e-05 0.001 4.320520e-05 0.0 4.320525e-05 0.001 4.320530e-05 0.0 4.320535e-05 0.001 4.320540e-05 0.0 4.320545e-05 0.001 4.320550e-05 0.0 4.320555e-05 0.001 4.320560e-05 0.0 4.320565e-05 0.001 4.320570e-05 0.0 4.320575e-05 0.001 4.320580e-05 0.0 4.320585e-05 0.001 4.320590e-05 0.0 4.320595e-05 0.001 4.320600e-05 0.0 4.320605e-05 0.001 4.320610e-05 0.0 4.320615e-05 0.001 4.320620e-05 0.0 4.320625e-05 0.001 4.320630e-05 0.0 4.320635e-05 0.001 4.320640e-05 0.0 4.320645e-05 0.001 4.320650e-05 0.0 4.320655e-05 0.001 4.320660e-05 0.0 4.320665e-05 0.001 4.320670e-05 0.0 4.320675e-05 0.001 4.320680e-05 0.0 4.320685e-05 0.001 4.320690e-05 0.0 4.320695e-05 0.001 4.320700e-05 0.0 4.320705e-05 0.001 4.320710e-05 0.0 4.320715e-05 0.001 4.320720e-05 0.0 4.320725e-05 0.001 4.320730e-05 0.0 4.320735e-05 0.001 4.320740e-05 0.0 4.320745e-05 0.001 4.320750e-05 0.0 4.320755e-05 0.001 4.320760e-05 0.0 4.320765e-05 0.001 4.320770e-05 0.0 4.320775e-05 0.001 4.320780e-05 0.0 4.320785e-05 0.001 4.320790e-05 0.0 4.320795e-05 0.001 4.320800e-05 0.0 4.320805e-05 0.001 4.320810e-05 0.0 4.320815e-05 0.001 4.320820e-05 0.0 4.320825e-05 0.001 4.320830e-05 0.0 4.320835e-05 0.001 4.320840e-05 0.0 4.320845e-05 0.001 4.320850e-05 0.0 4.320855e-05 0.001 4.320860e-05 0.0 4.320865e-05 0.001 4.320870e-05 0.0 4.320875e-05 0.001 4.320880e-05 0.0 4.320885e-05 0.001 4.320890e-05 0.0 4.320895e-05 0.001 4.320900e-05 0.0 4.320905e-05 0.001 4.320910e-05 0.0 4.320915e-05 0.001 4.320920e-05 0.0 4.320925e-05 0.001 4.320930e-05 0.0 4.320935e-05 0.001 4.320940e-05 0.0 4.320945e-05 0.001 4.320950e-05 0.0 4.320955e-05 0.001 4.320960e-05 0.0 4.320965e-05 0.001 4.320970e-05 0.0 4.320975e-05 0.001 4.320980e-05 0.0 4.320985e-05 0.001 4.320990e-05 0.0 4.320995e-05 0.001 4.321000e-05 0.0 4.321005e-05 0.001 4.321010e-05 0.0 4.321015e-05 0.001 4.321020e-05 0.0 4.321025e-05 0.001 4.321030e-05 0.0 4.321035e-05 0.001 4.321040e-05 0.0 4.321045e-05 0.001 4.321050e-05 0.0 4.321055e-05 0.001 4.321060e-05 0.0 4.321065e-05 0.001 4.321070e-05 0.0 4.321075e-05 0.001 4.321080e-05 0.0 4.321085e-05 0.001 4.321090e-05 0.0 4.321095e-05 0.001 4.321100e-05 0.0 4.321105e-05 0.001 4.321110e-05 0.0 4.321115e-05 0.001 4.321120e-05 0.0 4.321125e-05 0.001 4.321130e-05 0.0 4.321135e-05 0.001 4.321140e-05 0.0 4.321145e-05 0.001 4.321150e-05 0.0 4.321155e-05 0.001 4.321160e-05 0.0 4.321165e-05 0.001 4.321170e-05 0.0 4.321175e-05 0.001 4.321180e-05 0.0 4.321185e-05 0.001 4.321190e-05 0.0 4.321195e-05 0.001 4.321200e-05 0.0 4.321205e-05 0.001 4.321210e-05 0.0 4.321215e-05 0.001 4.321220e-05 0.0 4.321225e-05 0.001 4.321230e-05 0.0 4.321235e-05 0.001 4.321240e-05 0.0 4.321245e-05 0.001 4.321250e-05 0.0 4.321255e-05 0.001 4.321260e-05 0.0 4.321265e-05 0.001 4.321270e-05 0.0 4.321275e-05 0.001 4.321280e-05 0.0 4.321285e-05 0.001 4.321290e-05 0.0 4.321295e-05 0.001 4.321300e-05 0.0 4.321305e-05 0.001 4.321310e-05 0.0 4.321315e-05 0.001 4.321320e-05 0.0 4.321325e-05 0.001 4.321330e-05 0.0 4.321335e-05 0.001 4.321340e-05 0.0 4.321345e-05 0.001 4.321350e-05 0.0 4.321355e-05 0.001 4.321360e-05 0.0 4.321365e-05 0.001 4.321370e-05 0.0 4.321375e-05 0.001 4.321380e-05 0.0 4.321385e-05 0.001 4.321390e-05 0.0 4.321395e-05 0.001 4.321400e-05 0.0 4.321405e-05 0.001 4.321410e-05 0.0 4.321415e-05 0.001 4.321420e-05 0.0 4.321425e-05 0.001 4.321430e-05 0.0 4.321435e-05 0.001 4.321440e-05 0.0 4.321445e-05 0.001 4.321450e-05 0.0 4.321455e-05 0.001 4.321460e-05 0.0 4.321465e-05 0.001 4.321470e-05 0.0 4.321475e-05 0.001 4.321480e-05 0.0 4.321485e-05 0.001 4.321490e-05 0.0 4.321495e-05 0.001 4.321500e-05 0.0 4.321505e-05 0.001 4.321510e-05 0.0 4.321515e-05 0.001 4.321520e-05 0.0 4.321525e-05 0.001 4.321530e-05 0.0 4.321535e-05 0.001 4.321540e-05 0.0 4.321545e-05 0.001 4.321550e-05 0.0 4.321555e-05 0.001 4.321560e-05 0.0 4.321565e-05 0.001 4.321570e-05 0.0 4.321575e-05 0.001 4.321580e-05 0.0 4.321585e-05 0.001 4.321590e-05 0.0 4.321595e-05 0.001 4.321600e-05 0.0 4.321605e-05 0.001 4.321610e-05 0.0 4.321615e-05 0.001 4.321620e-05 0.0 4.321625e-05 0.001 4.321630e-05 0.0 4.321635e-05 0.001 4.321640e-05 0.0 4.321645e-05 0.001 4.321650e-05 0.0 4.321655e-05 0.001 4.321660e-05 0.0 4.321665e-05 0.001 4.321670e-05 0.0 4.321675e-05 0.001 4.321680e-05 0.0 4.321685e-05 0.001 4.321690e-05 0.0 4.321695e-05 0.001 4.321700e-05 0.0 4.321705e-05 0.001 4.321710e-05 0.0 4.321715e-05 0.001 4.321720e-05 0.0 4.321725e-05 0.001 4.321730e-05 0.0 4.321735e-05 0.001 4.321740e-05 0.0 4.321745e-05 0.001 4.321750e-05 0.0 4.321755e-05 0.001 4.321760e-05 0.0 4.321765e-05 0.001 4.321770e-05 0.0 4.321775e-05 0.001 4.321780e-05 0.0 4.321785e-05 0.001 4.321790e-05 0.0 4.321795e-05 0.001 4.321800e-05 0.0 4.321805e-05 0.001 4.321810e-05 0.0 4.321815e-05 0.001 4.321820e-05 0.0 4.321825e-05 0.001 4.321830e-05 0.0 4.321835e-05 0.001 4.321840e-05 0.0 4.321845e-05 0.001 4.321850e-05 0.0 4.321855e-05 0.001 4.321860e-05 0.0 4.321865e-05 0.001 4.321870e-05 0.0 4.321875e-05 0.001 4.321880e-05 0.0 4.321885e-05 0.001 4.321890e-05 0.0 4.321895e-05 0.001 4.321900e-05 0.0 4.321905e-05 0.001 4.321910e-05 0.0 4.321915e-05 0.001 4.321920e-05 0.0 4.321925e-05 0.001 4.321930e-05 0.0 4.321935e-05 0.001 4.321940e-05 0.0 4.321945e-05 0.001 4.321950e-05 0.0 4.321955e-05 0.001 4.321960e-05 0.0 4.321965e-05 0.001 4.321970e-05 0.0 4.321975e-05 0.001 4.321980e-05 0.0 4.321985e-05 0.001 4.321990e-05 0.0 4.321995e-05 0.001 4.322000e-05 0.0 4.322005e-05 0.001 4.322010e-05 0.0 4.322015e-05 0.001 4.322020e-05 0.0 4.322025e-05 0.001 4.322030e-05 0.0 4.322035e-05 0.001 4.322040e-05 0.0 4.322045e-05 0.001 4.322050e-05 0.0 4.322055e-05 0.001 4.322060e-05 0.0 4.322065e-05 0.001 4.322070e-05 0.0 4.322075e-05 0.001 4.322080e-05 0.0 4.322085e-05 0.001 4.322090e-05 0.0 4.322095e-05 0.001 4.322100e-05 0.0 4.322105e-05 0.001 4.322110e-05 0.0 4.322115e-05 0.001 4.322120e-05 0.0 4.322125e-05 0.001 4.322130e-05 0.0 4.322135e-05 0.001 4.322140e-05 0.0 4.322145e-05 0.001 4.322150e-05 0.0 4.322155e-05 0.001 4.322160e-05 0.0 4.322165e-05 0.001 4.322170e-05 0.0 4.322175e-05 0.001 4.322180e-05 0.0 4.322185e-05 0.001 4.322190e-05 0.0 4.322195e-05 0.001 4.322200e-05 0.0 4.322205e-05 0.001 4.322210e-05 0.0 4.322215e-05 0.001 4.322220e-05 0.0 4.322225e-05 0.001 4.322230e-05 0.0 4.322235e-05 0.001 4.322240e-05 0.0 4.322245e-05 0.001 4.322250e-05 0.0 4.322255e-05 0.001 4.322260e-05 0.0 4.322265e-05 0.001 4.322270e-05 0.0 4.322275e-05 0.001 4.322280e-05 0.0 4.322285e-05 0.001 4.322290e-05 0.0 4.322295e-05 0.001 4.322300e-05 0.0 4.322305e-05 0.001 4.322310e-05 0.0 4.322315e-05 0.001 4.322320e-05 0.0 4.322325e-05 0.001 4.322330e-05 0.0 4.322335e-05 0.001 4.322340e-05 0.0 4.322345e-05 0.001 4.322350e-05 0.0 4.322355e-05 0.001 4.322360e-05 0.0 4.322365e-05 0.001 4.322370e-05 0.0 4.322375e-05 0.001 4.322380e-05 0.0 4.322385e-05 0.001 4.322390e-05 0.0 4.322395e-05 0.001 4.322400e-05 0.0 4.322405e-05 0.001 4.322410e-05 0.0 4.322415e-05 0.001 4.322420e-05 0.0 4.322425e-05 0.001 4.322430e-05 0.0 4.322435e-05 0.001 4.322440e-05 0.0 4.322445e-05 0.001 4.322450e-05 0.0 4.322455e-05 0.001 4.322460e-05 0.0 4.322465e-05 0.001 4.322470e-05 0.0 4.322475e-05 0.001 4.322480e-05 0.0 4.322485e-05 0.001 4.322490e-05 0.0 4.322495e-05 0.001 4.322500e-05 0.0 4.322505e-05 0.001 4.322510e-05 0.0 4.322515e-05 0.001 4.322520e-05 0.0 4.322525e-05 0.001 4.322530e-05 0.0 4.322535e-05 0.001 4.322540e-05 0.0 4.322545e-05 0.001 4.322550e-05 0.0 4.322555e-05 0.001 4.322560e-05 0.0 4.322565e-05 0.001 4.322570e-05 0.0 4.322575e-05 0.001 4.322580e-05 0.0 4.322585e-05 0.001 4.322590e-05 0.0 4.322595e-05 0.001 4.322600e-05 0.0 4.322605e-05 0.001 4.322610e-05 0.0 4.322615e-05 0.001 4.322620e-05 0.0 4.322625e-05 0.001 4.322630e-05 0.0 4.322635e-05 0.001 4.322640e-05 0.0 4.322645e-05 0.001 4.322650e-05 0.0 4.322655e-05 0.001 4.322660e-05 0.0 4.322665e-05 0.001 4.322670e-05 0.0 4.322675e-05 0.001 4.322680e-05 0.0 4.322685e-05 0.001 4.322690e-05 0.0 4.322695e-05 0.001 4.322700e-05 0.0 4.322705e-05 0.001 4.322710e-05 0.0 4.322715e-05 0.001 4.322720e-05 0.0 4.322725e-05 0.001 4.322730e-05 0.0 4.322735e-05 0.001 4.322740e-05 0.0 4.322745e-05 0.001 4.322750e-05 0.0 4.322755e-05 0.001 4.322760e-05 0.0 4.322765e-05 0.001 4.322770e-05 0.0 4.322775e-05 0.001 4.322780e-05 0.0 4.322785e-05 0.001 4.322790e-05 0.0 4.322795e-05 0.001 4.322800e-05 0.0 4.322805e-05 0.001 4.322810e-05 0.0 4.322815e-05 0.001 4.322820e-05 0.0 4.322825e-05 0.001 4.322830e-05 0.0 4.322835e-05 0.001 4.322840e-05 0.0 4.322845e-05 0.001 4.322850e-05 0.0 4.322855e-05 0.001 4.322860e-05 0.0 4.322865e-05 0.001 4.322870e-05 0.0 4.322875e-05 0.001 4.322880e-05 0.0 4.322885e-05 0.001 4.322890e-05 0.0 4.322895e-05 0.001 4.322900e-05 0.0 4.322905e-05 0.001 4.322910e-05 0.0 4.322915e-05 0.001 4.322920e-05 0.0 4.322925e-05 0.001 4.322930e-05 0.0 4.322935e-05 0.001 4.322940e-05 0.0 4.322945e-05 0.001 4.322950e-05 0.0 4.322955e-05 0.001 4.322960e-05 0.0 4.322965e-05 0.001 4.322970e-05 0.0 4.322975e-05 0.001 4.322980e-05 0.0 4.322985e-05 0.001 4.322990e-05 0.0 4.322995e-05 0.001 4.323000e-05 0.0 4.323005e-05 0.001 4.323010e-05 0.0 4.323015e-05 0.001 4.323020e-05 0.0 4.323025e-05 0.001 4.323030e-05 0.0 4.323035e-05 0.001 4.323040e-05 0.0 4.323045e-05 0.001 4.323050e-05 0.0 4.323055e-05 0.001 4.323060e-05 0.0 4.323065e-05 0.001 4.323070e-05 0.0 4.323075e-05 0.001 4.323080e-05 0.0 4.323085e-05 0.001 4.323090e-05 0.0 4.323095e-05 0.001 4.323100e-05 0.0 4.323105e-05 0.001 4.323110e-05 0.0 4.323115e-05 0.001 4.323120e-05 0.0 4.323125e-05 0.001 4.323130e-05 0.0 4.323135e-05 0.001 4.323140e-05 0.0 4.323145e-05 0.001 4.323150e-05 0.0 4.323155e-05 0.001 4.323160e-05 0.0 4.323165e-05 0.001 4.323170e-05 0.0 4.323175e-05 0.001 4.323180e-05 0.0 4.323185e-05 0.001 4.323190e-05 0.0 4.323195e-05 0.001 4.323200e-05 0.0 4.323205e-05 0.001 4.323210e-05 0.0 4.323215e-05 0.001 4.323220e-05 0.0 4.323225e-05 0.001 4.323230e-05 0.0 4.323235e-05 0.001 4.323240e-05 0.0 4.323245e-05 0.001 4.323250e-05 0.0 4.323255e-05 0.001 4.323260e-05 0.0 4.323265e-05 0.001 4.323270e-05 0.0 4.323275e-05 0.001 4.323280e-05 0.0 4.323285e-05 0.001 4.323290e-05 0.0 4.323295e-05 0.001 4.323300e-05 0.0 4.323305e-05 0.001 4.323310e-05 0.0 4.323315e-05 0.001 4.323320e-05 0.0 4.323325e-05 0.001 4.323330e-05 0.0 4.323335e-05 0.001 4.323340e-05 0.0 4.323345e-05 0.001 4.323350e-05 0.0 4.323355e-05 0.001 4.323360e-05 0.0 4.323365e-05 0.001 4.323370e-05 0.0 4.323375e-05 0.001 4.323380e-05 0.0 4.323385e-05 0.001 4.323390e-05 0.0 4.323395e-05 0.001 4.323400e-05 0.0 4.323405e-05 0.001 4.323410e-05 0.0 4.323415e-05 0.001 4.323420e-05 0.0 4.323425e-05 0.001 4.323430e-05 0.0 4.323435e-05 0.001 4.323440e-05 0.0 4.323445e-05 0.001 4.323450e-05 0.0 4.323455e-05 0.001 4.323460e-05 0.0 4.323465e-05 0.001 4.323470e-05 0.0 4.323475e-05 0.001 4.323480e-05 0.0 4.323485e-05 0.001 4.323490e-05 0.0 4.323495e-05 0.001 4.323500e-05 0.0 4.323505e-05 0.001 4.323510e-05 0.0 4.323515e-05 0.001 4.323520e-05 0.0 4.323525e-05 0.001 4.323530e-05 0.0 4.323535e-05 0.001 4.323540e-05 0.0 4.323545e-05 0.001 4.323550e-05 0.0 4.323555e-05 0.001 4.323560e-05 0.0 4.323565e-05 0.001 4.323570e-05 0.0 4.323575e-05 0.001 4.323580e-05 0.0 4.323585e-05 0.001 4.323590e-05 0.0 4.323595e-05 0.001 4.323600e-05 0.0 4.323605e-05 0.001 4.323610e-05 0.0 4.323615e-05 0.001 4.323620e-05 0.0 4.323625e-05 0.001 4.323630e-05 0.0 4.323635e-05 0.001 4.323640e-05 0.0 4.323645e-05 0.001 4.323650e-05 0.0 4.323655e-05 0.001 4.323660e-05 0.0 4.323665e-05 0.001 4.323670e-05 0.0 4.323675e-05 0.001 4.323680e-05 0.0 4.323685e-05 0.001 4.323690e-05 0.0 4.323695e-05 0.001 4.323700e-05 0.0 4.323705e-05 0.001 4.323710e-05 0.0 4.323715e-05 0.001 4.323720e-05 0.0 4.323725e-05 0.001 4.323730e-05 0.0 4.323735e-05 0.001 4.323740e-05 0.0 4.323745e-05 0.001 4.323750e-05 0.0 4.323755e-05 0.001 4.323760e-05 0.0 4.323765e-05 0.001 4.323770e-05 0.0 4.323775e-05 0.001 4.323780e-05 0.0 4.323785e-05 0.001 4.323790e-05 0.0 4.323795e-05 0.001 4.323800e-05 0.0 4.323805e-05 0.001 4.323810e-05 0.0 4.323815e-05 0.001 4.323820e-05 0.0 4.323825e-05 0.001 4.323830e-05 0.0 4.323835e-05 0.001 4.323840e-05 0.0 4.323845e-05 0.001 4.323850e-05 0.0 4.323855e-05 0.001 4.323860e-05 0.0 4.323865e-05 0.001 4.323870e-05 0.0 4.323875e-05 0.001 4.323880e-05 0.0 4.323885e-05 0.001 4.323890e-05 0.0 4.323895e-05 0.001 4.323900e-05 0.0 4.323905e-05 0.001 4.323910e-05 0.0 4.323915e-05 0.001 4.323920e-05 0.0 4.323925e-05 0.001 4.323930e-05 0.0 4.323935e-05 0.001 4.323940e-05 0.0 4.323945e-05 0.001 4.323950e-05 0.0 4.323955e-05 0.001 4.323960e-05 0.0 4.323965e-05 0.001 4.323970e-05 0.0 4.323975e-05 0.001 4.323980e-05 0.0 4.323985e-05 0.001 4.323990e-05 0.0 4.323995e-05 0.001 4.324000e-05 0.0 4.324005e-05 0.001 4.324010e-05 0.0 4.324015e-05 0.001 4.324020e-05 0.0 4.324025e-05 0.001 4.324030e-05 0.0 4.324035e-05 0.001 4.324040e-05 0.0 4.324045e-05 0.001 4.324050e-05 0.0 4.324055e-05 0.001 4.324060e-05 0.0 4.324065e-05 0.001 4.324070e-05 0.0 4.324075e-05 0.001 4.324080e-05 0.0 4.324085e-05 0.001 4.324090e-05 0.0 4.324095e-05 0.001 4.324100e-05 0.0 4.324105e-05 0.001 4.324110e-05 0.0 4.324115e-05 0.001 4.324120e-05 0.0 4.324125e-05 0.001 4.324130e-05 0.0 4.324135e-05 0.001 4.324140e-05 0.0 4.324145e-05 0.001 4.324150e-05 0.0 4.324155e-05 0.001 4.324160e-05 0.0 4.324165e-05 0.001 4.324170e-05 0.0 4.324175e-05 0.001 4.324180e-05 0.0 4.324185e-05 0.001 4.324190e-05 0.0 4.324195e-05 0.001 4.324200e-05 0.0 4.324205e-05 0.001 4.324210e-05 0.0 4.324215e-05 0.001 4.324220e-05 0.0 4.324225e-05 0.001 4.324230e-05 0.0 4.324235e-05 0.001 4.324240e-05 0.0 4.324245e-05 0.001 4.324250e-05 0.0 4.324255e-05 0.001 4.324260e-05 0.0 4.324265e-05 0.001 4.324270e-05 0.0 4.324275e-05 0.001 4.324280e-05 0.0 4.324285e-05 0.001 4.324290e-05 0.0 4.324295e-05 0.001 4.324300e-05 0.0 4.324305e-05 0.001 4.324310e-05 0.0 4.324315e-05 0.001 4.324320e-05 0.0 4.324325e-05 0.001 4.324330e-05 0.0 4.324335e-05 0.001 4.324340e-05 0.0 4.324345e-05 0.001 4.324350e-05 0.0 4.324355e-05 0.001 4.324360e-05 0.0 4.324365e-05 0.001 4.324370e-05 0.0 4.324375e-05 0.001 4.324380e-05 0.0 4.324385e-05 0.001 4.324390e-05 0.0 4.324395e-05 0.001 4.324400e-05 0.0 4.324405e-05 0.001 4.324410e-05 0.0 4.324415e-05 0.001 4.324420e-05 0.0 4.324425e-05 0.001 4.324430e-05 0.0 4.324435e-05 0.001 4.324440e-05 0.0 4.324445e-05 0.001 4.324450e-05 0.0 4.324455e-05 0.001 4.324460e-05 0.0 4.324465e-05 0.001 4.324470e-05 0.0 4.324475e-05 0.001 4.324480e-05 0.0 4.324485e-05 0.001 4.324490e-05 0.0 4.324495e-05 0.001 4.324500e-05 0.0 4.324505e-05 0.001 4.324510e-05 0.0 4.324515e-05 0.001 4.324520e-05 0.0 4.324525e-05 0.001 4.324530e-05 0.0 4.324535e-05 0.001 4.324540e-05 0.0 4.324545e-05 0.001 4.324550e-05 0.0 4.324555e-05 0.001 4.324560e-05 0.0 4.324565e-05 0.001 4.324570e-05 0.0 4.324575e-05 0.001 4.324580e-05 0.0 4.324585e-05 0.001 4.324590e-05 0.0 4.324595e-05 0.001 4.324600e-05 0.0 4.324605e-05 0.001 4.324610e-05 0.0 4.324615e-05 0.001 4.324620e-05 0.0 4.324625e-05 0.001 4.324630e-05 0.0 4.324635e-05 0.001 4.324640e-05 0.0 4.324645e-05 0.001 4.324650e-05 0.0 4.324655e-05 0.001 4.324660e-05 0.0 4.324665e-05 0.001 4.324670e-05 0.0 4.324675e-05 0.001 4.324680e-05 0.0 4.324685e-05 0.001 4.324690e-05 0.0 4.324695e-05 0.001 4.324700e-05 0.0 4.324705e-05 0.001 4.324710e-05 0.0 4.324715e-05 0.001 4.324720e-05 0.0 4.324725e-05 0.001 4.324730e-05 0.0 4.324735e-05 0.001 4.324740e-05 0.0 4.324745e-05 0.001 4.324750e-05 0.0 4.324755e-05 0.001 4.324760e-05 0.0 4.324765e-05 0.001 4.324770e-05 0.0 4.324775e-05 0.001 4.324780e-05 0.0 4.324785e-05 0.001 4.324790e-05 0.0 4.324795e-05 0.001 4.324800e-05 0.0 4.324805e-05 0.001 4.324810e-05 0.0 4.324815e-05 0.001 4.324820e-05 0.0 4.324825e-05 0.001 4.324830e-05 0.0 4.324835e-05 0.001 4.324840e-05 0.0 4.324845e-05 0.001 4.324850e-05 0.0 4.324855e-05 0.001 4.324860e-05 0.0 4.324865e-05 0.001 4.324870e-05 0.0 4.324875e-05 0.001 4.324880e-05 0.0 4.324885e-05 0.001 4.324890e-05 0.0 4.324895e-05 0.001 4.324900e-05 0.0 4.324905e-05 0.001 4.324910e-05 0.0 4.324915e-05 0.001 4.324920e-05 0.0 4.324925e-05 0.001 4.324930e-05 0.0 4.324935e-05 0.001 4.324940e-05 0.0 4.324945e-05 0.001 4.324950e-05 0.0 4.324955e-05 0.001 4.324960e-05 0.0 4.324965e-05 0.001 4.324970e-05 0.0 4.324975e-05 0.001 4.324980e-05 0.0 4.324985e-05 0.001 4.324990e-05 0.0 4.324995e-05 0.001 4.325000e-05 0.0 4.325005e-05 0.001 4.325010e-05 0.0 4.325015e-05 0.001 4.325020e-05 0.0 4.325025e-05 0.001 4.325030e-05 0.0 4.325035e-05 0.001 4.325040e-05 0.0 4.325045e-05 0.001 4.325050e-05 0.0 4.325055e-05 0.001 4.325060e-05 0.0 4.325065e-05 0.001 4.325070e-05 0.0 4.325075e-05 0.001 4.325080e-05 0.0 4.325085e-05 0.001 4.325090e-05 0.0 4.325095e-05 0.001 4.325100e-05 0.0 4.325105e-05 0.001 4.325110e-05 0.0 4.325115e-05 0.001 4.325120e-05 0.0 4.325125e-05 0.001 4.325130e-05 0.0 4.325135e-05 0.001 4.325140e-05 0.0 4.325145e-05 0.001 4.325150e-05 0.0 4.325155e-05 0.001 4.325160e-05 0.0 4.325165e-05 0.001 4.325170e-05 0.0 4.325175e-05 0.001 4.325180e-05 0.0 4.325185e-05 0.001 4.325190e-05 0.0 4.325195e-05 0.001 4.325200e-05 0.0 4.325205e-05 0.001 4.325210e-05 0.0 4.325215e-05 0.001 4.325220e-05 0.0 4.325225e-05 0.001 4.325230e-05 0.0 4.325235e-05 0.001 4.325240e-05 0.0 4.325245e-05 0.001 4.325250e-05 0.0 4.325255e-05 0.001 4.325260e-05 0.0 4.325265e-05 0.001 4.325270e-05 0.0 4.325275e-05 0.001 4.325280e-05 0.0 4.325285e-05 0.001 4.325290e-05 0.0 4.325295e-05 0.001 4.325300e-05 0.0 4.325305e-05 0.001 4.325310e-05 0.0 4.325315e-05 0.001 4.325320e-05 0.0 4.325325e-05 0.001 4.325330e-05 0.0 4.325335e-05 0.001 4.325340e-05 0.0 4.325345e-05 0.001 4.325350e-05 0.0 4.325355e-05 0.001 4.325360e-05 0.0 4.325365e-05 0.001 4.325370e-05 0.0 4.325375e-05 0.001 4.325380e-05 0.0 4.325385e-05 0.001 4.325390e-05 0.0 4.325395e-05 0.001 4.325400e-05 0.0 4.325405e-05 0.001 4.325410e-05 0.0 4.325415e-05 0.001 4.325420e-05 0.0 4.325425e-05 0.001 4.325430e-05 0.0 4.325435e-05 0.001 4.325440e-05 0.0 4.325445e-05 0.001 4.325450e-05 0.0 4.325455e-05 0.001 4.325460e-05 0.0 4.325465e-05 0.001 4.325470e-05 0.0 4.325475e-05 0.001 4.325480e-05 0.0 4.325485e-05 0.001 4.325490e-05 0.0 4.325495e-05 0.001 4.325500e-05 0.0 4.325505e-05 0.001 4.325510e-05 0.0 4.325515e-05 0.001 4.325520e-05 0.0 4.325525e-05 0.001 4.325530e-05 0.0 4.325535e-05 0.001 4.325540e-05 0.0 4.325545e-05 0.001 4.325550e-05 0.0 4.325555e-05 0.001 4.325560e-05 0.0 4.325565e-05 0.001 4.325570e-05 0.0 4.325575e-05 0.001 4.325580e-05 0.0 4.325585e-05 0.001 4.325590e-05 0.0 4.325595e-05 0.001 4.325600e-05 0.0 4.325605e-05 0.001 4.325610e-05 0.0 4.325615e-05 0.001 4.325620e-05 0.0 4.325625e-05 0.001 4.325630e-05 0.0 4.325635e-05 0.001 4.325640e-05 0.0 4.325645e-05 0.001 4.325650e-05 0.0 4.325655e-05 0.001 4.325660e-05 0.0 4.325665e-05 0.001 4.325670e-05 0.0 4.325675e-05 0.001 4.325680e-05 0.0 4.325685e-05 0.001 4.325690e-05 0.0 4.325695e-05 0.001 4.325700e-05 0.0 4.325705e-05 0.001 4.325710e-05 0.0 4.325715e-05 0.001 4.325720e-05 0.0 4.325725e-05 0.001 4.325730e-05 0.0 4.325735e-05 0.001 4.325740e-05 0.0 4.325745e-05 0.001 4.325750e-05 0.0 4.325755e-05 0.001 4.325760e-05 0.0 4.325765e-05 0.001 4.325770e-05 0.0 4.325775e-05 0.001 4.325780e-05 0.0 4.325785e-05 0.001 4.325790e-05 0.0 4.325795e-05 0.001 4.325800e-05 0.0 4.325805e-05 0.001 4.325810e-05 0.0 4.325815e-05 0.001 4.325820e-05 0.0 4.325825e-05 0.001 4.325830e-05 0.0 4.325835e-05 0.001 4.325840e-05 0.0 4.325845e-05 0.001 4.325850e-05 0.0 4.325855e-05 0.001 4.325860e-05 0.0 4.325865e-05 0.001 4.325870e-05 0.0 4.325875e-05 0.001 4.325880e-05 0.0 4.325885e-05 0.001 4.325890e-05 0.0 4.325895e-05 0.001 4.325900e-05 0.0 4.325905e-05 0.001 4.325910e-05 0.0 4.325915e-05 0.001 4.325920e-05 0.0 4.325925e-05 0.001 4.325930e-05 0.0 4.325935e-05 0.001 4.325940e-05 0.0 4.325945e-05 0.001 4.325950e-05 0.0 4.325955e-05 0.001 4.325960e-05 0.0 4.325965e-05 0.001 4.325970e-05 0.0 4.325975e-05 0.001 4.325980e-05 0.0 4.325985e-05 0.001 4.325990e-05 0.0 4.325995e-05 0.001 4.326000e-05 0.0 4.326005e-05 0.001 4.326010e-05 0.0 4.326015e-05 0.001 4.326020e-05 0.0 4.326025e-05 0.001 4.326030e-05 0.0 4.326035e-05 0.001 4.326040e-05 0.0 4.326045e-05 0.001 4.326050e-05 0.0 4.326055e-05 0.001 4.326060e-05 0.0 4.326065e-05 0.001 4.326070e-05 0.0 4.326075e-05 0.001 4.326080e-05 0.0 4.326085e-05 0.001 4.326090e-05 0.0 4.326095e-05 0.001 4.326100e-05 0.0 4.326105e-05 0.001 4.326110e-05 0.0 4.326115e-05 0.001 4.326120e-05 0.0 4.326125e-05 0.001 4.326130e-05 0.0 4.326135e-05 0.001 4.326140e-05 0.0 4.326145e-05 0.001 4.326150e-05 0.0 4.326155e-05 0.001 4.326160e-05 0.0 4.326165e-05 0.001 4.326170e-05 0.0 4.326175e-05 0.001 4.326180e-05 0.0 4.326185e-05 0.001 4.326190e-05 0.0 4.326195e-05 0.001 4.326200e-05 0.0 4.326205e-05 0.001 4.326210e-05 0.0 4.326215e-05 0.001 4.326220e-05 0.0 4.326225e-05 0.001 4.326230e-05 0.0 4.326235e-05 0.001 4.326240e-05 0.0 4.326245e-05 0.001 4.326250e-05 0.0 4.326255e-05 0.001 4.326260e-05 0.0 4.326265e-05 0.001 4.326270e-05 0.0 4.326275e-05 0.001 4.326280e-05 0.0 4.326285e-05 0.001 4.326290e-05 0.0 4.326295e-05 0.001 4.326300e-05 0.0 4.326305e-05 0.001 4.326310e-05 0.0 4.326315e-05 0.001 4.326320e-05 0.0 4.326325e-05 0.001 4.326330e-05 0.0 4.326335e-05 0.001 4.326340e-05 0.0 4.326345e-05 0.001 4.326350e-05 0.0 4.326355e-05 0.001 4.326360e-05 0.0 4.326365e-05 0.001 4.326370e-05 0.0 4.326375e-05 0.001 4.326380e-05 0.0 4.326385e-05 0.001 4.326390e-05 0.0 4.326395e-05 0.001 4.326400e-05 0.0 4.326405e-05 0.001 4.326410e-05 0.0 4.326415e-05 0.001 4.326420e-05 0.0 4.326425e-05 0.001 4.326430e-05 0.0 4.326435e-05 0.001 4.326440e-05 0.0 4.326445e-05 0.001 4.326450e-05 0.0 4.326455e-05 0.001 4.326460e-05 0.0 4.326465e-05 0.001 4.326470e-05 0.0 4.326475e-05 0.001 4.326480e-05 0.0 4.326485e-05 0.001 4.326490e-05 0.0 4.326495e-05 0.001 4.326500e-05 0.0 4.326505e-05 0.001 4.326510e-05 0.0 4.326515e-05 0.001 4.326520e-05 0.0 4.326525e-05 0.001 4.326530e-05 0.0 4.326535e-05 0.001 4.326540e-05 0.0 4.326545e-05 0.001 4.326550e-05 0.0 4.326555e-05 0.001 4.326560e-05 0.0 4.326565e-05 0.001 4.326570e-05 0.0 4.326575e-05 0.001 4.326580e-05 0.0 4.326585e-05 0.001 4.326590e-05 0.0 4.326595e-05 0.001 4.326600e-05 0.0 4.326605e-05 0.001 4.326610e-05 0.0 4.326615e-05 0.001 4.326620e-05 0.0 4.326625e-05 0.001 4.326630e-05 0.0 4.326635e-05 0.001 4.326640e-05 0.0 4.326645e-05 0.001 4.326650e-05 0.0 4.326655e-05 0.001 4.326660e-05 0.0 4.326665e-05 0.001 4.326670e-05 0.0 4.326675e-05 0.001 4.326680e-05 0.0 4.326685e-05 0.001 4.326690e-05 0.0 4.326695e-05 0.001 4.326700e-05 0.0 4.326705e-05 0.001 4.326710e-05 0.0 4.326715e-05 0.001 4.326720e-05 0.0 4.326725e-05 0.001 4.326730e-05 0.0 4.326735e-05 0.001 4.326740e-05 0.0 4.326745e-05 0.001 4.326750e-05 0.0 4.326755e-05 0.001 4.326760e-05 0.0 4.326765e-05 0.001 4.326770e-05 0.0 4.326775e-05 0.001 4.326780e-05 0.0 4.326785e-05 0.001 4.326790e-05 0.0 4.326795e-05 0.001 4.326800e-05 0.0 4.326805e-05 0.001 4.326810e-05 0.0 4.326815e-05 0.001 4.326820e-05 0.0 4.326825e-05 0.001 4.326830e-05 0.0 4.326835e-05 0.001 4.326840e-05 0.0 4.326845e-05 0.001 4.326850e-05 0.0 4.326855e-05 0.001 4.326860e-05 0.0 4.326865e-05 0.001 4.326870e-05 0.0 4.326875e-05 0.001 4.326880e-05 0.0 4.326885e-05 0.001 4.326890e-05 0.0 4.326895e-05 0.001 4.326900e-05 0.0 4.326905e-05 0.001 4.326910e-05 0.0 4.326915e-05 0.001 4.326920e-05 0.0 4.326925e-05 0.001 4.326930e-05 0.0 4.326935e-05 0.001 4.326940e-05 0.0 4.326945e-05 0.001 4.326950e-05 0.0 4.326955e-05 0.001 4.326960e-05 0.0 4.326965e-05 0.001 4.326970e-05 0.0 4.326975e-05 0.001 4.326980e-05 0.0 4.326985e-05 0.001 4.326990e-05 0.0 4.326995e-05 0.001 4.327000e-05 0.0 4.327005e-05 0.001 4.327010e-05 0.0 4.327015e-05 0.001 4.327020e-05 0.0 4.327025e-05 0.001 4.327030e-05 0.0 4.327035e-05 0.001 4.327040e-05 0.0 4.327045e-05 0.001 4.327050e-05 0.0 4.327055e-05 0.001 4.327060e-05 0.0 4.327065e-05 0.001 4.327070e-05 0.0 4.327075e-05 0.001 4.327080e-05 0.0 4.327085e-05 0.001 4.327090e-05 0.0 4.327095e-05 0.001 4.327100e-05 0.0 4.327105e-05 0.001 4.327110e-05 0.0 4.327115e-05 0.001 4.327120e-05 0.0 4.327125e-05 0.001 4.327130e-05 0.0 4.327135e-05 0.001 4.327140e-05 0.0 4.327145e-05 0.001 4.327150e-05 0.0 4.327155e-05 0.001 4.327160e-05 0.0 4.327165e-05 0.001 4.327170e-05 0.0 4.327175e-05 0.001 4.327180e-05 0.0 4.327185e-05 0.001 4.327190e-05 0.0 4.327195e-05 0.001 4.327200e-05 0.0 4.327205e-05 0.001 4.327210e-05 0.0 4.327215e-05 0.001 4.327220e-05 0.0 4.327225e-05 0.001 4.327230e-05 0.0 4.327235e-05 0.001 4.327240e-05 0.0 4.327245e-05 0.001 4.327250e-05 0.0 4.327255e-05 0.001 4.327260e-05 0.0 4.327265e-05 0.001 4.327270e-05 0.0 4.327275e-05 0.001 4.327280e-05 0.0 4.327285e-05 0.001 4.327290e-05 0.0 4.327295e-05 0.001 4.327300e-05 0.0 4.327305e-05 0.001 4.327310e-05 0.0 4.327315e-05 0.001 4.327320e-05 0.0 4.327325e-05 0.001 4.327330e-05 0.0 4.327335e-05 0.001 4.327340e-05 0.0 4.327345e-05 0.001 4.327350e-05 0.0 4.327355e-05 0.001 4.327360e-05 0.0 4.327365e-05 0.001 4.327370e-05 0.0 4.327375e-05 0.001 4.327380e-05 0.0 4.327385e-05 0.001 4.327390e-05 0.0 4.327395e-05 0.001 4.327400e-05 0.0 4.327405e-05 0.001 4.327410e-05 0.0 4.327415e-05 0.001 4.327420e-05 0.0 4.327425e-05 0.001 4.327430e-05 0.0 4.327435e-05 0.001 4.327440e-05 0.0 4.327445e-05 0.001 4.327450e-05 0.0 4.327455e-05 0.001 4.327460e-05 0.0 4.327465e-05 0.001 4.327470e-05 0.0 4.327475e-05 0.001 4.327480e-05 0.0 4.327485e-05 0.001 4.327490e-05 0.0 4.327495e-05 0.001 4.327500e-05 0.0 4.327505e-05 0.001 4.327510e-05 0.0 4.327515e-05 0.001 4.327520e-05 0.0 4.327525e-05 0.001 4.327530e-05 0.0 4.327535e-05 0.001 4.327540e-05 0.0 4.327545e-05 0.001 4.327550e-05 0.0 4.327555e-05 0.001 4.327560e-05 0.0 4.327565e-05 0.001 4.327570e-05 0.0 4.327575e-05 0.001 4.327580e-05 0.0 4.327585e-05 0.001 4.327590e-05 0.0 4.327595e-05 0.001 4.327600e-05 0.0 4.327605e-05 0.001 4.327610e-05 0.0 4.327615e-05 0.001 4.327620e-05 0.0 4.327625e-05 0.001 4.327630e-05 0.0 4.327635e-05 0.001 4.327640e-05 0.0 4.327645e-05 0.001 4.327650e-05 0.0 4.327655e-05 0.001 4.327660e-05 0.0 4.327665e-05 0.001 4.327670e-05 0.0 4.327675e-05 0.001 4.327680e-05 0.0 4.327685e-05 0.001 4.327690e-05 0.0 4.327695e-05 0.001 4.327700e-05 0.0 4.327705e-05 0.001 4.327710e-05 0.0 4.327715e-05 0.001 4.327720e-05 0.0 4.327725e-05 0.001 4.327730e-05 0.0 4.327735e-05 0.001 4.327740e-05 0.0 4.327745e-05 0.001 4.327750e-05 0.0 4.327755e-05 0.001 4.327760e-05 0.0 4.327765e-05 0.001 4.327770e-05 0.0 4.327775e-05 0.001 4.327780e-05 0.0 4.327785e-05 0.001 4.327790e-05 0.0 4.327795e-05 0.001 4.327800e-05 0.0 4.327805e-05 0.001 4.327810e-05 0.0 4.327815e-05 0.001 4.327820e-05 0.0 4.327825e-05 0.001 4.327830e-05 0.0 4.327835e-05 0.001 4.327840e-05 0.0 4.327845e-05 0.001 4.327850e-05 0.0 4.327855e-05 0.001 4.327860e-05 0.0 4.327865e-05 0.001 4.327870e-05 0.0 4.327875e-05 0.001 4.327880e-05 0.0 4.327885e-05 0.001 4.327890e-05 0.0 4.327895e-05 0.001 4.327900e-05 0.0 4.327905e-05 0.001 4.327910e-05 0.0 4.327915e-05 0.001 4.327920e-05 0.0 4.327925e-05 0.001 4.327930e-05 0.0 4.327935e-05 0.001 4.327940e-05 0.0 4.327945e-05 0.001 4.327950e-05 0.0 4.327955e-05 0.001 4.327960e-05 0.0 4.327965e-05 0.001 4.327970e-05 0.0 4.327975e-05 0.001 4.327980e-05 0.0 4.327985e-05 0.001 4.327990e-05 0.0 4.327995e-05 0.001 4.328000e-05 0.0 4.328005e-05 0.001 4.328010e-05 0.0 4.328015e-05 0.001 4.328020e-05 0.0 4.328025e-05 0.001 4.328030e-05 0.0 4.328035e-05 0.001 4.328040e-05 0.0 4.328045e-05 0.001 4.328050e-05 0.0 4.328055e-05 0.001 4.328060e-05 0.0 4.328065e-05 0.001 4.328070e-05 0.0 4.328075e-05 0.001 4.328080e-05 0.0 4.328085e-05 0.001 4.328090e-05 0.0 4.328095e-05 0.001 4.328100e-05 0.0 4.328105e-05 0.001 4.328110e-05 0.0 4.328115e-05 0.001 4.328120e-05 0.0 4.328125e-05 0.001 4.328130e-05 0.0 4.328135e-05 0.001 4.328140e-05 0.0 4.328145e-05 0.001 4.328150e-05 0.0 4.328155e-05 0.001 4.328160e-05 0.0 4.328165e-05 0.001 4.328170e-05 0.0 4.328175e-05 0.001 4.328180e-05 0.0 4.328185e-05 0.001 4.328190e-05 0.0 4.328195e-05 0.001 4.328200e-05 0.0 4.328205e-05 0.001 4.328210e-05 0.0 4.328215e-05 0.001 4.328220e-05 0.0 4.328225e-05 0.001 4.328230e-05 0.0 4.328235e-05 0.001 4.328240e-05 0.0 4.328245e-05 0.001 4.328250e-05 0.0 4.328255e-05 0.001 4.328260e-05 0.0 4.328265e-05 0.001 4.328270e-05 0.0 4.328275e-05 0.001 4.328280e-05 0.0 4.328285e-05 0.001 4.328290e-05 0.0 4.328295e-05 0.001 4.328300e-05 0.0 4.328305e-05 0.001 4.328310e-05 0.0 4.328315e-05 0.001 4.328320e-05 0.0 4.328325e-05 0.001 4.328330e-05 0.0 4.328335e-05 0.001 4.328340e-05 0.0 4.328345e-05 0.001 4.328350e-05 0.0 4.328355e-05 0.001 4.328360e-05 0.0 4.328365e-05 0.001 4.328370e-05 0.0 4.328375e-05 0.001 4.328380e-05 0.0 4.328385e-05 0.001 4.328390e-05 0.0 4.328395e-05 0.001 4.328400e-05 0.0 4.328405e-05 0.001 4.328410e-05 0.0 4.328415e-05 0.001 4.328420e-05 0.0 4.328425e-05 0.001 4.328430e-05 0.0 4.328435e-05 0.001 4.328440e-05 0.0 4.328445e-05 0.001 4.328450e-05 0.0 4.328455e-05 0.001 4.328460e-05 0.0 4.328465e-05 0.001 4.328470e-05 0.0 4.328475e-05 0.001 4.328480e-05 0.0 4.328485e-05 0.001 4.328490e-05 0.0 4.328495e-05 0.001 4.328500e-05 0.0 4.328505e-05 0.001 4.328510e-05 0.0 4.328515e-05 0.001 4.328520e-05 0.0 4.328525e-05 0.001 4.328530e-05 0.0 4.328535e-05 0.001 4.328540e-05 0.0 4.328545e-05 0.001 4.328550e-05 0.0 4.328555e-05 0.001 4.328560e-05 0.0 4.328565e-05 0.001 4.328570e-05 0.0 4.328575e-05 0.001 4.328580e-05 0.0 4.328585e-05 0.001 4.328590e-05 0.0 4.328595e-05 0.001 4.328600e-05 0.0 4.328605e-05 0.001 4.328610e-05 0.0 4.328615e-05 0.001 4.328620e-05 0.0 4.328625e-05 0.001 4.328630e-05 0.0 4.328635e-05 0.001 4.328640e-05 0.0 4.328645e-05 0.001 4.328650e-05 0.0 4.328655e-05 0.001 4.328660e-05 0.0 4.328665e-05 0.001 4.328670e-05 0.0 4.328675e-05 0.001 4.328680e-05 0.0 4.328685e-05 0.001 4.328690e-05 0.0 4.328695e-05 0.001 4.328700e-05 0.0 4.328705e-05 0.001 4.328710e-05 0.0 4.328715e-05 0.001 4.328720e-05 0.0 4.328725e-05 0.001 4.328730e-05 0.0 4.328735e-05 0.001 4.328740e-05 0.0 4.328745e-05 0.001 4.328750e-05 0.0 4.328755e-05 0.001 4.328760e-05 0.0 4.328765e-05 0.001 4.328770e-05 0.0 4.328775e-05 0.001 4.328780e-05 0.0 4.328785e-05 0.001 4.328790e-05 0.0 4.328795e-05 0.001 4.328800e-05 0.0 4.328805e-05 0.001 4.328810e-05 0.0 4.328815e-05 0.001 4.328820e-05 0.0 4.328825e-05 0.001 4.328830e-05 0.0 4.328835e-05 0.001 4.328840e-05 0.0 4.328845e-05 0.001 4.328850e-05 0.0 4.328855e-05 0.001 4.328860e-05 0.0 4.328865e-05 0.001 4.328870e-05 0.0 4.328875e-05 0.001 4.328880e-05 0.0 4.328885e-05 0.001 4.328890e-05 0.0 4.328895e-05 0.001 4.328900e-05 0.0 4.328905e-05 0.001 4.328910e-05 0.0 4.328915e-05 0.001 4.328920e-05 0.0 4.328925e-05 0.001 4.328930e-05 0.0 4.328935e-05 0.001 4.328940e-05 0.0 4.328945e-05 0.001 4.328950e-05 0.0 4.328955e-05 0.001 4.328960e-05 0.0 4.328965e-05 0.001 4.328970e-05 0.0 4.328975e-05 0.001 4.328980e-05 0.0 4.328985e-05 0.001 4.328990e-05 0.0 4.328995e-05 0.001 4.329000e-05 0.0 4.329005e-05 0.001 4.329010e-05 0.0 4.329015e-05 0.001 4.329020e-05 0.0 4.329025e-05 0.001 4.329030e-05 0.0 4.329035e-05 0.001 4.329040e-05 0.0 4.329045e-05 0.001 4.329050e-05 0.0 4.329055e-05 0.001 4.329060e-05 0.0 4.329065e-05 0.001 4.329070e-05 0.0 4.329075e-05 0.001 4.329080e-05 0.0 4.329085e-05 0.001 4.329090e-05 0.0 4.329095e-05 0.001 4.329100e-05 0.0 4.329105e-05 0.001 4.329110e-05 0.0 4.329115e-05 0.001 4.329120e-05 0.0 4.329125e-05 0.001 4.329130e-05 0.0 4.329135e-05 0.001 4.329140e-05 0.0 4.329145e-05 0.001 4.329150e-05 0.0 4.329155e-05 0.001 4.329160e-05 0.0 4.329165e-05 0.001 4.329170e-05 0.0 4.329175e-05 0.001 4.329180e-05 0.0 4.329185e-05 0.001 4.329190e-05 0.0 4.329195e-05 0.001 4.329200e-05 0.0 4.329205e-05 0.001 4.329210e-05 0.0 4.329215e-05 0.001 4.329220e-05 0.0 4.329225e-05 0.001 4.329230e-05 0.0 4.329235e-05 0.001 4.329240e-05 0.0 4.329245e-05 0.001 4.329250e-05 0.0 4.329255e-05 0.001 4.329260e-05 0.0 4.329265e-05 0.001 4.329270e-05 0.0 4.329275e-05 0.001 4.329280e-05 0.0 4.329285e-05 0.001 4.329290e-05 0.0 4.329295e-05 0.001 4.329300e-05 0.0 4.329305e-05 0.001 4.329310e-05 0.0 4.329315e-05 0.001 4.329320e-05 0.0 4.329325e-05 0.001 4.329330e-05 0.0 4.329335e-05 0.001 4.329340e-05 0.0 4.329345e-05 0.001 4.329350e-05 0.0 4.329355e-05 0.001 4.329360e-05 0.0 4.329365e-05 0.001 4.329370e-05 0.0 4.329375e-05 0.001 4.329380e-05 0.0 4.329385e-05 0.001 4.329390e-05 0.0 4.329395e-05 0.001 4.329400e-05 0.0 4.329405e-05 0.001 4.329410e-05 0.0 4.329415e-05 0.001 4.329420e-05 0.0 4.329425e-05 0.001 4.329430e-05 0.0 4.329435e-05 0.001 4.329440e-05 0.0 4.329445e-05 0.001 4.329450e-05 0.0 4.329455e-05 0.001 4.329460e-05 0.0 4.329465e-05 0.001 4.329470e-05 0.0 4.329475e-05 0.001 4.329480e-05 0.0 4.329485e-05 0.001 4.329490e-05 0.0 4.329495e-05 0.001 4.329500e-05 0.0 4.329505e-05 0.001 4.329510e-05 0.0 4.329515e-05 0.001 4.329520e-05 0.0 4.329525e-05 0.001 4.329530e-05 0.0 4.329535e-05 0.001 4.329540e-05 0.0 4.329545e-05 0.001 4.329550e-05 0.0 4.329555e-05 0.001 4.329560e-05 0.0 4.329565e-05 0.001 4.329570e-05 0.0 4.329575e-05 0.001 4.329580e-05 0.0 4.329585e-05 0.001 4.329590e-05 0.0 4.329595e-05 0.001 4.329600e-05 0.0 4.329605e-05 0.001 4.329610e-05 0.0 4.329615e-05 0.001 4.329620e-05 0.0 4.329625e-05 0.001 4.329630e-05 0.0 4.329635e-05 0.001 4.329640e-05 0.0 4.329645e-05 0.001 4.329650e-05 0.0 4.329655e-05 0.001 4.329660e-05 0.0 4.329665e-05 0.001 4.329670e-05 0.0 4.329675e-05 0.001 4.329680e-05 0.0 4.329685e-05 0.001 4.329690e-05 0.0 4.329695e-05 0.001 4.329700e-05 0.0 4.329705e-05 0.001 4.329710e-05 0.0 4.329715e-05 0.001 4.329720e-05 0.0 4.329725e-05 0.001 4.329730e-05 0.0 4.329735e-05 0.001 4.329740e-05 0.0 4.329745e-05 0.001 4.329750e-05 0.0 4.329755e-05 0.001 4.329760e-05 0.0 4.329765e-05 0.001 4.329770e-05 0.0 4.329775e-05 0.001 4.329780e-05 0.0 4.329785e-05 0.001 4.329790e-05 0.0 4.329795e-05 0.001 4.329800e-05 0.0 4.329805e-05 0.001 4.329810e-05 0.0 4.329815e-05 0.001 4.329820e-05 0.0 4.329825e-05 0.001 4.329830e-05 0.0 4.329835e-05 0.001 4.329840e-05 0.0 4.329845e-05 0.001 4.329850e-05 0.0 4.329855e-05 0.001 4.329860e-05 0.0 4.329865e-05 0.001 4.329870e-05 0.0 4.329875e-05 0.001 4.329880e-05 0.0 4.329885e-05 0.001 4.329890e-05 0.0 4.329895e-05 0.001 4.329900e-05 0.0 4.329905e-05 0.001 4.329910e-05 0.0 4.329915e-05 0.001 4.329920e-05 0.0 4.329925e-05 0.001 4.329930e-05 0.0 4.329935e-05 0.001 4.329940e-05 0.0 4.329945e-05 0.001 4.329950e-05 0.0 4.329955e-05 0.001 4.329960e-05 0.0 4.329965e-05 0.001 4.329970e-05 0.0 4.329975e-05 0.001 4.329980e-05 0.0 4.329985e-05 0.001 4.329990e-05 0.0 4.329995e-05 0.001 4.330000e-05 0.0 4.330005e-05 0.001 4.330010e-05 0.0 4.330015e-05 0.001 4.330020e-05 0.0 4.330025e-05 0.001 4.330030e-05 0.0 4.330035e-05 0.001 4.330040e-05 0.0 4.330045e-05 0.001 4.330050e-05 0.0 4.330055e-05 0.001 4.330060e-05 0.0 4.330065e-05 0.001 4.330070e-05 0.0 4.330075e-05 0.001 4.330080e-05 0.0 4.330085e-05 0.001 4.330090e-05 0.0 4.330095e-05 0.001 4.330100e-05 0.0 4.330105e-05 0.001 4.330110e-05 0.0 4.330115e-05 0.001 4.330120e-05 0.0 4.330125e-05 0.001 4.330130e-05 0.0 4.330135e-05 0.001 4.330140e-05 0.0 4.330145e-05 0.001 4.330150e-05 0.0 4.330155e-05 0.001 4.330160e-05 0.0 4.330165e-05 0.001 4.330170e-05 0.0 4.330175e-05 0.001 4.330180e-05 0.0 4.330185e-05 0.001 4.330190e-05 0.0 4.330195e-05 0.001 4.330200e-05 0.0 4.330205e-05 0.001 4.330210e-05 0.0 4.330215e-05 0.001 4.330220e-05 0.0 4.330225e-05 0.001 4.330230e-05 0.0 4.330235e-05 0.001 4.330240e-05 0.0 4.330245e-05 0.001 4.330250e-05 0.0 4.330255e-05 0.001 4.330260e-05 0.0 4.330265e-05 0.001 4.330270e-05 0.0 4.330275e-05 0.001 4.330280e-05 0.0 4.330285e-05 0.001 4.330290e-05 0.0 4.330295e-05 0.001 4.330300e-05 0.0 4.330305e-05 0.001 4.330310e-05 0.0 4.330315e-05 0.001 4.330320e-05 0.0 4.330325e-05 0.001 4.330330e-05 0.0 4.330335e-05 0.001 4.330340e-05 0.0 4.330345e-05 0.001 4.330350e-05 0.0 4.330355e-05 0.001 4.330360e-05 0.0 4.330365e-05 0.001 4.330370e-05 0.0 4.330375e-05 0.001 4.330380e-05 0.0 4.330385e-05 0.001 4.330390e-05 0.0 4.330395e-05 0.001 4.330400e-05 0.0 4.330405e-05 0.001 4.330410e-05 0.0 4.330415e-05 0.001 4.330420e-05 0.0 4.330425e-05 0.001 4.330430e-05 0.0 4.330435e-05 0.001 4.330440e-05 0.0 4.330445e-05 0.001 4.330450e-05 0.0 4.330455e-05 0.001 4.330460e-05 0.0 4.330465e-05 0.001 4.330470e-05 0.0 4.330475e-05 0.001 4.330480e-05 0.0 4.330485e-05 0.001 4.330490e-05 0.0 4.330495e-05 0.001 4.330500e-05 0.0 4.330505e-05 0.001 4.330510e-05 0.0 4.330515e-05 0.001 4.330520e-05 0.0 4.330525e-05 0.001 4.330530e-05 0.0 4.330535e-05 0.001 4.330540e-05 0.0 4.330545e-05 0.001 4.330550e-05 0.0 4.330555e-05 0.001 4.330560e-05 0.0 4.330565e-05 0.001 4.330570e-05 0.0 4.330575e-05 0.001 4.330580e-05 0.0 4.330585e-05 0.001 4.330590e-05 0.0 4.330595e-05 0.001 4.330600e-05 0.0 4.330605e-05 0.001 4.330610e-05 0.0 4.330615e-05 0.001 4.330620e-05 0.0 4.330625e-05 0.001 4.330630e-05 0.0 4.330635e-05 0.001 4.330640e-05 0.0 4.330645e-05 0.001 4.330650e-05 0.0 4.330655e-05 0.001 4.330660e-05 0.0 4.330665e-05 0.001 4.330670e-05 0.0 4.330675e-05 0.001 4.330680e-05 0.0 4.330685e-05 0.001 4.330690e-05 0.0 4.330695e-05 0.001 4.330700e-05 0.0 4.330705e-05 0.001 4.330710e-05 0.0 4.330715e-05 0.001 4.330720e-05 0.0 4.330725e-05 0.001 4.330730e-05 0.0 4.330735e-05 0.001 4.330740e-05 0.0 4.330745e-05 0.001 4.330750e-05 0.0 4.330755e-05 0.001 4.330760e-05 0.0 4.330765e-05 0.001 4.330770e-05 0.0 4.330775e-05 0.001 4.330780e-05 0.0 4.330785e-05 0.001 4.330790e-05 0.0 4.330795e-05 0.001 4.330800e-05 0.0 4.330805e-05 0.001 4.330810e-05 0.0 4.330815e-05 0.001 4.330820e-05 0.0 4.330825e-05 0.001 4.330830e-05 0.0 4.330835e-05 0.001 4.330840e-05 0.0 4.330845e-05 0.001 4.330850e-05 0.0 4.330855e-05 0.001 4.330860e-05 0.0 4.330865e-05 0.001 4.330870e-05 0.0 4.330875e-05 0.001 4.330880e-05 0.0 4.330885e-05 0.001 4.330890e-05 0.0 4.330895e-05 0.001 4.330900e-05 0.0 4.330905e-05 0.001 4.330910e-05 0.0 4.330915e-05 0.001 4.330920e-05 0.0 4.330925e-05 0.001 4.330930e-05 0.0 4.330935e-05 0.001 4.330940e-05 0.0 4.330945e-05 0.001 4.330950e-05 0.0 4.330955e-05 0.001 4.330960e-05 0.0 4.330965e-05 0.001 4.330970e-05 0.0 4.330975e-05 0.001 4.330980e-05 0.0 4.330985e-05 0.001 4.330990e-05 0.0 4.330995e-05 0.001 4.331000e-05 0.0 4.331005e-05 0.001 4.331010e-05 0.0 4.331015e-05 0.001 4.331020e-05 0.0 4.331025e-05 0.001 4.331030e-05 0.0 4.331035e-05 0.001 4.331040e-05 0.0 4.331045e-05 0.001 4.331050e-05 0.0 4.331055e-05 0.001 4.331060e-05 0.0 4.331065e-05 0.001 4.331070e-05 0.0 4.331075e-05 0.001 4.331080e-05 0.0 4.331085e-05 0.001 4.331090e-05 0.0 4.331095e-05 0.001 4.331100e-05 0.0 4.331105e-05 0.001 4.331110e-05 0.0 4.331115e-05 0.001 4.331120e-05 0.0 4.331125e-05 0.001 4.331130e-05 0.0 4.331135e-05 0.001 4.331140e-05 0.0 4.331145e-05 0.001 4.331150e-05 0.0 4.331155e-05 0.001 4.331160e-05 0.0 4.331165e-05 0.001 4.331170e-05 0.0 4.331175e-05 0.001 4.331180e-05 0.0 4.331185e-05 0.001 4.331190e-05 0.0 4.331195e-05 0.001 4.331200e-05 0.0 4.331205e-05 0.001 4.331210e-05 0.0 4.331215e-05 0.001 4.331220e-05 0.0 4.331225e-05 0.001 4.331230e-05 0.0 4.331235e-05 0.001 4.331240e-05 0.0 4.331245e-05 0.001 4.331250e-05 0.0 4.331255e-05 0.001 4.331260e-05 0.0 4.331265e-05 0.001 4.331270e-05 0.0 4.331275e-05 0.001 4.331280e-05 0.0 4.331285e-05 0.001 4.331290e-05 0.0 4.331295e-05 0.001 4.331300e-05 0.0 4.331305e-05 0.001 4.331310e-05 0.0 4.331315e-05 0.001 4.331320e-05 0.0 4.331325e-05 0.001 4.331330e-05 0.0 4.331335e-05 0.001 4.331340e-05 0.0 4.331345e-05 0.001 4.331350e-05 0.0 4.331355e-05 0.001 4.331360e-05 0.0 4.331365e-05 0.001 4.331370e-05 0.0 4.331375e-05 0.001 4.331380e-05 0.0 4.331385e-05 0.001 4.331390e-05 0.0 4.331395e-05 0.001 4.331400e-05 0.0 4.331405e-05 0.001 4.331410e-05 0.0 4.331415e-05 0.001 4.331420e-05 0.0 4.331425e-05 0.001 4.331430e-05 0.0 4.331435e-05 0.001 4.331440e-05 0.0 4.331445e-05 0.001 4.331450e-05 0.0 4.331455e-05 0.001 4.331460e-05 0.0 4.331465e-05 0.001 4.331470e-05 0.0 4.331475e-05 0.001 4.331480e-05 0.0 4.331485e-05 0.001 4.331490e-05 0.0 4.331495e-05 0.001 4.331500e-05 0.0 4.331505e-05 0.001 4.331510e-05 0.0 4.331515e-05 0.001 4.331520e-05 0.0 4.331525e-05 0.001 4.331530e-05 0.0 4.331535e-05 0.001 4.331540e-05 0.0 4.331545e-05 0.001 4.331550e-05 0.0 4.331555e-05 0.001 4.331560e-05 0.0 4.331565e-05 0.001 4.331570e-05 0.0 4.331575e-05 0.001 4.331580e-05 0.0 4.331585e-05 0.001 4.331590e-05 0.0 4.331595e-05 0.001 4.331600e-05 0.0 4.331605e-05 0.001 4.331610e-05 0.0 4.331615e-05 0.001 4.331620e-05 0.0 4.331625e-05 0.001 4.331630e-05 0.0 4.331635e-05 0.001 4.331640e-05 0.0 4.331645e-05 0.001 4.331650e-05 0.0 4.331655e-05 0.001 4.331660e-05 0.0 4.331665e-05 0.001 4.331670e-05 0.0 4.331675e-05 0.001 4.331680e-05 0.0 4.331685e-05 0.001 4.331690e-05 0.0 4.331695e-05 0.001 4.331700e-05 0.0 4.331705e-05 0.001 4.331710e-05 0.0 4.331715e-05 0.001 4.331720e-05 0.0 4.331725e-05 0.001 4.331730e-05 0.0 4.331735e-05 0.001 4.331740e-05 0.0 4.331745e-05 0.001 4.331750e-05 0.0 4.331755e-05 0.001 4.331760e-05 0.0 4.331765e-05 0.001 4.331770e-05 0.0 4.331775e-05 0.001 4.331780e-05 0.0 4.331785e-05 0.001 4.331790e-05 0.0 4.331795e-05 0.001 4.331800e-05 0.0 4.331805e-05 0.001 4.331810e-05 0.0 4.331815e-05 0.001 4.331820e-05 0.0 4.331825e-05 0.001 4.331830e-05 0.0 4.331835e-05 0.001 4.331840e-05 0.0 4.331845e-05 0.001 4.331850e-05 0.0 4.331855e-05 0.001 4.331860e-05 0.0 4.331865e-05 0.001 4.331870e-05 0.0 4.331875e-05 0.001 4.331880e-05 0.0 4.331885e-05 0.001 4.331890e-05 0.0 4.331895e-05 0.001 4.331900e-05 0.0 4.331905e-05 0.001 4.331910e-05 0.0 4.331915e-05 0.001 4.331920e-05 0.0 4.331925e-05 0.001 4.331930e-05 0.0 4.331935e-05 0.001 4.331940e-05 0.0 4.331945e-05 0.001 4.331950e-05 0.0 4.331955e-05 0.001 4.331960e-05 0.0 4.331965e-05 0.001 4.331970e-05 0.0 4.331975e-05 0.001 4.331980e-05 0.0 4.331985e-05 0.001 4.331990e-05 0.0 4.331995e-05 0.001 4.332000e-05 0.0 4.332005e-05 0.001 4.332010e-05 0.0 4.332015e-05 0.001 4.332020e-05 0.0 4.332025e-05 0.001 4.332030e-05 0.0 4.332035e-05 0.001 4.332040e-05 0.0 4.332045e-05 0.001 4.332050e-05 0.0 4.332055e-05 0.001 4.332060e-05 0.0 4.332065e-05 0.001 4.332070e-05 0.0 4.332075e-05 0.001 4.332080e-05 0.0 4.332085e-05 0.001 4.332090e-05 0.0 4.332095e-05 0.001 4.332100e-05 0.0 4.332105e-05 0.001 4.332110e-05 0.0 4.332115e-05 0.001 4.332120e-05 0.0 4.332125e-05 0.001 4.332130e-05 0.0 4.332135e-05 0.001 4.332140e-05 0.0 4.332145e-05 0.001 4.332150e-05 0.0 4.332155e-05 0.001 4.332160e-05 0.0 4.332165e-05 0.001 4.332170e-05 0.0 4.332175e-05 0.001 4.332180e-05 0.0 4.332185e-05 0.001 4.332190e-05 0.0 4.332195e-05 0.001 4.332200e-05 0.0 4.332205e-05 0.001 4.332210e-05 0.0 4.332215e-05 0.001 4.332220e-05 0.0 4.332225e-05 0.001 4.332230e-05 0.0 4.332235e-05 0.001 4.332240e-05 0.0 4.332245e-05 0.001 4.332250e-05 0.0 4.332255e-05 0.001 4.332260e-05 0.0 4.332265e-05 0.001 4.332270e-05 0.0 4.332275e-05 0.001 4.332280e-05 0.0 4.332285e-05 0.001 4.332290e-05 0.0 4.332295e-05 0.001 4.332300e-05 0.0 4.332305e-05 0.001 4.332310e-05 0.0 4.332315e-05 0.001 4.332320e-05 0.0 4.332325e-05 0.001 4.332330e-05 0.0 4.332335e-05 0.001 4.332340e-05 0.0 4.332345e-05 0.001 4.332350e-05 0.0 4.332355e-05 0.001 4.332360e-05 0.0 4.332365e-05 0.001 4.332370e-05 0.0 4.332375e-05 0.001 4.332380e-05 0.0 4.332385e-05 0.001 4.332390e-05 0.0 4.332395e-05 0.001 4.332400e-05 0.0 4.332405e-05 0.001 4.332410e-05 0.0 4.332415e-05 0.001 4.332420e-05 0.0 4.332425e-05 0.001 4.332430e-05 0.0 4.332435e-05 0.001 4.332440e-05 0.0 4.332445e-05 0.001 4.332450e-05 0.0 4.332455e-05 0.001 4.332460e-05 0.0 4.332465e-05 0.001 4.332470e-05 0.0 4.332475e-05 0.001 4.332480e-05 0.0 4.332485e-05 0.001 4.332490e-05 0.0 4.332495e-05 0.001 4.332500e-05 0.0 4.332505e-05 0.001 4.332510e-05 0.0 4.332515e-05 0.001 4.332520e-05 0.0 4.332525e-05 0.001 4.332530e-05 0.0 4.332535e-05 0.001 4.332540e-05 0.0 4.332545e-05 0.001 4.332550e-05 0.0 4.332555e-05 0.001 4.332560e-05 0.0 4.332565e-05 0.001 4.332570e-05 0.0 4.332575e-05 0.001 4.332580e-05 0.0 4.332585e-05 0.001 4.332590e-05 0.0 4.332595e-05 0.001 4.332600e-05 0.0 4.332605e-05 0.001 4.332610e-05 0.0 4.332615e-05 0.001 4.332620e-05 0.0 4.332625e-05 0.001 4.332630e-05 0.0 4.332635e-05 0.001 4.332640e-05 0.0 4.332645e-05 0.001 4.332650e-05 0.0 4.332655e-05 0.001 4.332660e-05 0.0 4.332665e-05 0.001 4.332670e-05 0.0 4.332675e-05 0.001 4.332680e-05 0.0 4.332685e-05 0.001 4.332690e-05 0.0 4.332695e-05 0.001 4.332700e-05 0.0 4.332705e-05 0.001 4.332710e-05 0.0 4.332715e-05 0.001 4.332720e-05 0.0 4.332725e-05 0.001 4.332730e-05 0.0 4.332735e-05 0.001 4.332740e-05 0.0 4.332745e-05 0.001 4.332750e-05 0.0 4.332755e-05 0.001 4.332760e-05 0.0 4.332765e-05 0.001 4.332770e-05 0.0 4.332775e-05 0.001 4.332780e-05 0.0 4.332785e-05 0.001 4.332790e-05 0.0 4.332795e-05 0.001 4.332800e-05 0.0 4.332805e-05 0.001 4.332810e-05 0.0 4.332815e-05 0.001 4.332820e-05 0.0 4.332825e-05 0.001 4.332830e-05 0.0 4.332835e-05 0.001 4.332840e-05 0.0 4.332845e-05 0.001 4.332850e-05 0.0 4.332855e-05 0.001 4.332860e-05 0.0 4.332865e-05 0.001 4.332870e-05 0.0 4.332875e-05 0.001 4.332880e-05 0.0 4.332885e-05 0.001 4.332890e-05 0.0 4.332895e-05 0.001 4.332900e-05 0.0 4.332905e-05 0.001 4.332910e-05 0.0 4.332915e-05 0.001 4.332920e-05 0.0 4.332925e-05 0.001 4.332930e-05 0.0 4.332935e-05 0.001 4.332940e-05 0.0 4.332945e-05 0.001 4.332950e-05 0.0 4.332955e-05 0.001 4.332960e-05 0.0 4.332965e-05 0.001 4.332970e-05 0.0 4.332975e-05 0.001 4.332980e-05 0.0 4.332985e-05 0.001 4.332990e-05 0.0 4.332995e-05 0.001 4.333000e-05 0.0 4.333005e-05 0.001 4.333010e-05 0.0 4.333015e-05 0.001 4.333020e-05 0.0 4.333025e-05 0.001 4.333030e-05 0.0 4.333035e-05 0.001 4.333040e-05 0.0 4.333045e-05 0.001 4.333050e-05 0.0 4.333055e-05 0.001 4.333060e-05 0.0 4.333065e-05 0.001 4.333070e-05 0.0 4.333075e-05 0.001 4.333080e-05 0.0 4.333085e-05 0.001 4.333090e-05 0.0 4.333095e-05 0.001 4.333100e-05 0.0 4.333105e-05 0.001 4.333110e-05 0.0 4.333115e-05 0.001 4.333120e-05 0.0 4.333125e-05 0.001 4.333130e-05 0.0 4.333135e-05 0.001 4.333140e-05 0.0 4.333145e-05 0.001 4.333150e-05 0.0 4.333155e-05 0.001 4.333160e-05 0.0 4.333165e-05 0.001 4.333170e-05 0.0 4.333175e-05 0.001 4.333180e-05 0.0 4.333185e-05 0.001 4.333190e-05 0.0 4.333195e-05 0.001 4.333200e-05 0.0 4.333205e-05 0.001 4.333210e-05 0.0 4.333215e-05 0.001 4.333220e-05 0.0 4.333225e-05 0.001 4.333230e-05 0.0 4.333235e-05 0.001 4.333240e-05 0.0 4.333245e-05 0.001 4.333250e-05 0.0 4.333255e-05 0.001 4.333260e-05 0.0 4.333265e-05 0.001 4.333270e-05 0.0 4.333275e-05 0.001 4.333280e-05 0.0 4.333285e-05 0.001 4.333290e-05 0.0 4.333295e-05 0.001 4.333300e-05 0.0 4.333305e-05 0.001 4.333310e-05 0.0 4.333315e-05 0.001 4.333320e-05 0.0 4.333325e-05 0.001 4.333330e-05 0.0 4.333335e-05 0.001 4.333340e-05 0.0 4.333345e-05 0.001 4.333350e-05 0.0 4.333355e-05 0.001 4.333360e-05 0.0 4.333365e-05 0.001 4.333370e-05 0.0 4.333375e-05 0.001 4.333380e-05 0.0 4.333385e-05 0.001 4.333390e-05 0.0 4.333395e-05 0.001 4.333400e-05 0.0 4.333405e-05 0.001 4.333410e-05 0.0 4.333415e-05 0.001 4.333420e-05 0.0 4.333425e-05 0.001 4.333430e-05 0.0 4.333435e-05 0.001 4.333440e-05 0.0 4.333445e-05 0.001 4.333450e-05 0.0 4.333455e-05 0.001 4.333460e-05 0.0 4.333465e-05 0.001 4.333470e-05 0.0 4.333475e-05 0.001 4.333480e-05 0.0 4.333485e-05 0.001 4.333490e-05 0.0 4.333495e-05 0.001 4.333500e-05 0.0 4.333505e-05 0.001 4.333510e-05 0.0 4.333515e-05 0.001 4.333520e-05 0.0 4.333525e-05 0.001 4.333530e-05 0.0 4.333535e-05 0.001 4.333540e-05 0.0 4.333545e-05 0.001 4.333550e-05 0.0 4.333555e-05 0.001 4.333560e-05 0.0 4.333565e-05 0.001 4.333570e-05 0.0 4.333575e-05 0.001 4.333580e-05 0.0 4.333585e-05 0.001 4.333590e-05 0.0 4.333595e-05 0.001 4.333600e-05 0.0 4.333605e-05 0.001 4.333610e-05 0.0 4.333615e-05 0.001 4.333620e-05 0.0 4.333625e-05 0.001 4.333630e-05 0.0 4.333635e-05 0.001 4.333640e-05 0.0 4.333645e-05 0.001 4.333650e-05 0.0 4.333655e-05 0.001 4.333660e-05 0.0 4.333665e-05 0.001 4.333670e-05 0.0 4.333675e-05 0.001 4.333680e-05 0.0 4.333685e-05 0.001 4.333690e-05 0.0 4.333695e-05 0.001 4.333700e-05 0.0 4.333705e-05 0.001 4.333710e-05 0.0 4.333715e-05 0.001 4.333720e-05 0.0 4.333725e-05 0.001 4.333730e-05 0.0 4.333735e-05 0.001 4.333740e-05 0.0 4.333745e-05 0.001 4.333750e-05 0.0 4.333755e-05 0.001 4.333760e-05 0.0 4.333765e-05 0.001 4.333770e-05 0.0 4.333775e-05 0.001 4.333780e-05 0.0 4.333785e-05 0.001 4.333790e-05 0.0 4.333795e-05 0.001 4.333800e-05 0.0 4.333805e-05 0.001 4.333810e-05 0.0 4.333815e-05 0.001 4.333820e-05 0.0 4.333825e-05 0.001 4.333830e-05 0.0 4.333835e-05 0.001 4.333840e-05 0.0 4.333845e-05 0.001 4.333850e-05 0.0 4.333855e-05 0.001 4.333860e-05 0.0 4.333865e-05 0.001 4.333870e-05 0.0 4.333875e-05 0.001 4.333880e-05 0.0 4.333885e-05 0.001 4.333890e-05 0.0 4.333895e-05 0.001 4.333900e-05 0.0 4.333905e-05 0.001 4.333910e-05 0.0 4.333915e-05 0.001 4.333920e-05 0.0 4.333925e-05 0.001 4.333930e-05 0.0 4.333935e-05 0.001 4.333940e-05 0.0 4.333945e-05 0.001 4.333950e-05 0.0 4.333955e-05 0.001 4.333960e-05 0.0 4.333965e-05 0.001 4.333970e-05 0.0 4.333975e-05 0.001 4.333980e-05 0.0 4.333985e-05 0.001 4.333990e-05 0.0 4.333995e-05 0.001 4.334000e-05 0.0 4.334005e-05 0.001 4.334010e-05 0.0 4.334015e-05 0.001 4.334020e-05 0.0 4.334025e-05 0.001 4.334030e-05 0.0 4.334035e-05 0.001 4.334040e-05 0.0 4.334045e-05 0.001 4.334050e-05 0.0 4.334055e-05 0.001 4.334060e-05 0.0 4.334065e-05 0.001 4.334070e-05 0.0 4.334075e-05 0.001 4.334080e-05 0.0 4.334085e-05 0.001 4.334090e-05 0.0 4.334095e-05 0.001 4.334100e-05 0.0 4.334105e-05 0.001 4.334110e-05 0.0 4.334115e-05 0.001 4.334120e-05 0.0 4.334125e-05 0.001 4.334130e-05 0.0 4.334135e-05 0.001 4.334140e-05 0.0 4.334145e-05 0.001 4.334150e-05 0.0 4.334155e-05 0.001 4.334160e-05 0.0 4.334165e-05 0.001 4.334170e-05 0.0 4.334175e-05 0.001 4.334180e-05 0.0 4.334185e-05 0.001 4.334190e-05 0.0 4.334195e-05 0.001 4.334200e-05 0.0 4.334205e-05 0.001 4.334210e-05 0.0 4.334215e-05 0.001 4.334220e-05 0.0 4.334225e-05 0.001 4.334230e-05 0.0 4.334235e-05 0.001 4.334240e-05 0.0 4.334245e-05 0.001 4.334250e-05 0.0 4.334255e-05 0.001 4.334260e-05 0.0 4.334265e-05 0.001 4.334270e-05 0.0 4.334275e-05 0.001 4.334280e-05 0.0 4.334285e-05 0.001 4.334290e-05 0.0 4.334295e-05 0.001 4.334300e-05 0.0 4.334305e-05 0.001 4.334310e-05 0.0 4.334315e-05 0.001 4.334320e-05 0.0 4.334325e-05 0.001 4.334330e-05 0.0 4.334335e-05 0.001 4.334340e-05 0.0 4.334345e-05 0.001 4.334350e-05 0.0 4.334355e-05 0.001 4.334360e-05 0.0 4.334365e-05 0.001 4.334370e-05 0.0 4.334375e-05 0.001 4.334380e-05 0.0 4.334385e-05 0.001 4.334390e-05 0.0 4.334395e-05 0.001 4.334400e-05 0.0 4.334405e-05 0.001 4.334410e-05 0.0 4.334415e-05 0.001 4.334420e-05 0.0 4.334425e-05 0.001 4.334430e-05 0.0 4.334435e-05 0.001 4.334440e-05 0.0 4.334445e-05 0.001 4.334450e-05 0.0 4.334455e-05 0.001 4.334460e-05 0.0 4.334465e-05 0.001 4.334470e-05 0.0 4.334475e-05 0.001 4.334480e-05 0.0 4.334485e-05 0.001 4.334490e-05 0.0 4.334495e-05 0.001 4.334500e-05 0.0 4.334505e-05 0.001 4.334510e-05 0.0 4.334515e-05 0.001 4.334520e-05 0.0 4.334525e-05 0.001 4.334530e-05 0.0 4.334535e-05 0.001 4.334540e-05 0.0 4.334545e-05 0.001 4.334550e-05 0.0 4.334555e-05 0.001 4.334560e-05 0.0 4.334565e-05 0.001 4.334570e-05 0.0 4.334575e-05 0.001 4.334580e-05 0.0 4.334585e-05 0.001 4.334590e-05 0.0 4.334595e-05 0.001 4.334600e-05 0.0 4.334605e-05 0.001 4.334610e-05 0.0 4.334615e-05 0.001 4.334620e-05 0.0 4.334625e-05 0.001 4.334630e-05 0.0 4.334635e-05 0.001 4.334640e-05 0.0 4.334645e-05 0.001 4.334650e-05 0.0 4.334655e-05 0.001 4.334660e-05 0.0 4.334665e-05 0.001 4.334670e-05 0.0 4.334675e-05 0.001 4.334680e-05 0.0 4.334685e-05 0.001 4.334690e-05 0.0 4.334695e-05 0.001 4.334700e-05 0.0 4.334705e-05 0.001 4.334710e-05 0.0 4.334715e-05 0.001 4.334720e-05 0.0 4.334725e-05 0.001 4.334730e-05 0.0 4.334735e-05 0.001 4.334740e-05 0.0 4.334745e-05 0.001 4.334750e-05 0.0 4.334755e-05 0.001 4.334760e-05 0.0 4.334765e-05 0.001 4.334770e-05 0.0 4.334775e-05 0.001 4.334780e-05 0.0 4.334785e-05 0.001 4.334790e-05 0.0 4.334795e-05 0.001 4.334800e-05 0.0 4.334805e-05 0.001 4.334810e-05 0.0 4.334815e-05 0.001 4.334820e-05 0.0 4.334825e-05 0.001 4.334830e-05 0.0 4.334835e-05 0.001 4.334840e-05 0.0 4.334845e-05 0.001 4.334850e-05 0.0 4.334855e-05 0.001 4.334860e-05 0.0 4.334865e-05 0.001 4.334870e-05 0.0 4.334875e-05 0.001 4.334880e-05 0.0 4.334885e-05 0.001 4.334890e-05 0.0 4.334895e-05 0.001 4.334900e-05 0.0 4.334905e-05 0.001 4.334910e-05 0.0 4.334915e-05 0.001 4.334920e-05 0.0 4.334925e-05 0.001 4.334930e-05 0.0 4.334935e-05 0.001 4.334940e-05 0.0 4.334945e-05 0.001 4.334950e-05 0.0 4.334955e-05 0.001 4.334960e-05 0.0 4.334965e-05 0.001 4.334970e-05 0.0 4.334975e-05 0.001 4.334980e-05 0.0 4.334985e-05 0.001 4.334990e-05 0.0 4.334995e-05 0.001 4.335000e-05 0.0 4.335005e-05 0.001 4.335010e-05 0.0 4.335015e-05 0.001 4.335020e-05 0.0 4.335025e-05 0.001 4.335030e-05 0.0 4.335035e-05 0.001 4.335040e-05 0.0 4.335045e-05 0.001 4.335050e-05 0.0 4.335055e-05 0.001 4.335060e-05 0.0 4.335065e-05 0.001 4.335070e-05 0.0 4.335075e-05 0.001 4.335080e-05 0.0 4.335085e-05 0.001 4.335090e-05 0.0 4.335095e-05 0.001 4.335100e-05 0.0 4.335105e-05 0.001 4.335110e-05 0.0 4.335115e-05 0.001 4.335120e-05 0.0 4.335125e-05 0.001 4.335130e-05 0.0 4.335135e-05 0.001 4.335140e-05 0.0 4.335145e-05 0.001 4.335150e-05 0.0 4.335155e-05 0.001 4.335160e-05 0.0 4.335165e-05 0.001 4.335170e-05 0.0 4.335175e-05 0.001 4.335180e-05 0.0 4.335185e-05 0.001 4.335190e-05 0.0 4.335195e-05 0.001 4.335200e-05 0.0 4.335205e-05 0.001 4.335210e-05 0.0 4.335215e-05 0.001 4.335220e-05 0.0 4.335225e-05 0.001 4.335230e-05 0.0 4.335235e-05 0.001 4.335240e-05 0.0 4.335245e-05 0.001 4.335250e-05 0.0 4.335255e-05 0.001 4.335260e-05 0.0 4.335265e-05 0.001 4.335270e-05 0.0 4.335275e-05 0.001 4.335280e-05 0.0 4.335285e-05 0.001 4.335290e-05 0.0 4.335295e-05 0.001 4.335300e-05 0.0 4.335305e-05 0.001 4.335310e-05 0.0 4.335315e-05 0.001 4.335320e-05 0.0 4.335325e-05 0.001 4.335330e-05 0.0 4.335335e-05 0.001 4.335340e-05 0.0 4.335345e-05 0.001 4.335350e-05 0.0 4.335355e-05 0.001 4.335360e-05 0.0 4.335365e-05 0.001 4.335370e-05 0.0 4.335375e-05 0.001 4.335380e-05 0.0 4.335385e-05 0.001 4.335390e-05 0.0 4.335395e-05 0.001 4.335400e-05 0.0 4.335405e-05 0.001 4.335410e-05 0.0 4.335415e-05 0.001 4.335420e-05 0.0 4.335425e-05 0.001 4.335430e-05 0.0 4.335435e-05 0.001 4.335440e-05 0.0 4.335445e-05 0.001 4.335450e-05 0.0 4.335455e-05 0.001 4.335460e-05 0.0 4.335465e-05 0.001 4.335470e-05 0.0 4.335475e-05 0.001 4.335480e-05 0.0 4.335485e-05 0.001 4.335490e-05 0.0 4.335495e-05 0.001 4.335500e-05 0.0 4.335505e-05 0.001 4.335510e-05 0.0 4.335515e-05 0.001 4.335520e-05 0.0 4.335525e-05 0.001 4.335530e-05 0.0 4.335535e-05 0.001 4.335540e-05 0.0 4.335545e-05 0.001 4.335550e-05 0.0 4.335555e-05 0.001 4.335560e-05 0.0 4.335565e-05 0.001 4.335570e-05 0.0 4.335575e-05 0.001 4.335580e-05 0.0 4.335585e-05 0.001 4.335590e-05 0.0 4.335595e-05 0.001 4.335600e-05 0.0 4.335605e-05 0.001 4.335610e-05 0.0 4.335615e-05 0.001 4.335620e-05 0.0 4.335625e-05 0.001 4.335630e-05 0.0 4.335635e-05 0.001 4.335640e-05 0.0 4.335645e-05 0.001 4.335650e-05 0.0 4.335655e-05 0.001 4.335660e-05 0.0 4.335665e-05 0.001 4.335670e-05 0.0 4.335675e-05 0.001 4.335680e-05 0.0 4.335685e-05 0.001 4.335690e-05 0.0 4.335695e-05 0.001 4.335700e-05 0.0 4.335705e-05 0.001 4.335710e-05 0.0 4.335715e-05 0.001 4.335720e-05 0.0 4.335725e-05 0.001 4.335730e-05 0.0 4.335735e-05 0.001 4.335740e-05 0.0 4.335745e-05 0.001 4.335750e-05 0.0 4.335755e-05 0.001 4.335760e-05 0.0 4.335765e-05 0.001 4.335770e-05 0.0 4.335775e-05 0.001 4.335780e-05 0.0 4.335785e-05 0.001 4.335790e-05 0.0 4.335795e-05 0.001 4.335800e-05 0.0 4.335805e-05 0.001 4.335810e-05 0.0 4.335815e-05 0.001 4.335820e-05 0.0 4.335825e-05 0.001 4.335830e-05 0.0 4.335835e-05 0.001 4.335840e-05 0.0 4.335845e-05 0.001 4.335850e-05 0.0 4.335855e-05 0.001 4.335860e-05 0.0 4.335865e-05 0.001 4.335870e-05 0.0 4.335875e-05 0.001 4.335880e-05 0.0 4.335885e-05 0.001 4.335890e-05 0.0 4.335895e-05 0.001 4.335900e-05 0.0 4.335905e-05 0.001 4.335910e-05 0.0 4.335915e-05 0.001 4.335920e-05 0.0 4.335925e-05 0.001 4.335930e-05 0.0 4.335935e-05 0.001 4.335940e-05 0.0 4.335945e-05 0.001 4.335950e-05 0.0 4.335955e-05 0.001 4.335960e-05 0.0 4.335965e-05 0.001 4.335970e-05 0.0 4.335975e-05 0.001 4.335980e-05 0.0 4.335985e-05 0.001 4.335990e-05 0.0 4.335995e-05 0.001 4.336000e-05 0.0 4.336005e-05 0.001 4.336010e-05 0.0 4.336015e-05 0.001 4.336020e-05 0.0 4.336025e-05 0.001 4.336030e-05 0.0 4.336035e-05 0.001 4.336040e-05 0.0 4.336045e-05 0.001 4.336050e-05 0.0 4.336055e-05 0.001 4.336060e-05 0.0 4.336065e-05 0.001 4.336070e-05 0.0 4.336075e-05 0.001 4.336080e-05 0.0 4.336085e-05 0.001 4.336090e-05 0.0 4.336095e-05 0.001 4.336100e-05 0.0 4.336105e-05 0.001 4.336110e-05 0.0 4.336115e-05 0.001 4.336120e-05 0.0 4.336125e-05 0.001 4.336130e-05 0.0 4.336135e-05 0.001 4.336140e-05 0.0 4.336145e-05 0.001 4.336150e-05 0.0 4.336155e-05 0.001 4.336160e-05 0.0 4.336165e-05 0.001 4.336170e-05 0.0 4.336175e-05 0.001 4.336180e-05 0.0 4.336185e-05 0.001 4.336190e-05 0.0 4.336195e-05 0.001 4.336200e-05 0.0 4.336205e-05 0.001 4.336210e-05 0.0 4.336215e-05 0.001 4.336220e-05 0.0 4.336225e-05 0.001 4.336230e-05 0.0 4.336235e-05 0.001 4.336240e-05 0.0 4.336245e-05 0.001 4.336250e-05 0.0 4.336255e-05 0.001 4.336260e-05 0.0 4.336265e-05 0.001 4.336270e-05 0.0 4.336275e-05 0.001 4.336280e-05 0.0 4.336285e-05 0.001 4.336290e-05 0.0 4.336295e-05 0.001 4.336300e-05 0.0 4.336305e-05 0.001 4.336310e-05 0.0 4.336315e-05 0.001 4.336320e-05 0.0 4.336325e-05 0.001 4.336330e-05 0.0 4.336335e-05 0.001 4.336340e-05 0.0 4.336345e-05 0.001 4.336350e-05 0.0 4.336355e-05 0.001 4.336360e-05 0.0 4.336365e-05 0.001 4.336370e-05 0.0 4.336375e-05 0.001 4.336380e-05 0.0 4.336385e-05 0.001 4.336390e-05 0.0 4.336395e-05 0.001 4.336400e-05 0.0 4.336405e-05 0.001 4.336410e-05 0.0 4.336415e-05 0.001 4.336420e-05 0.0 4.336425e-05 0.001 4.336430e-05 0.0 4.336435e-05 0.001 4.336440e-05 0.0 4.336445e-05 0.001 4.336450e-05 0.0 4.336455e-05 0.001 4.336460e-05 0.0 4.336465e-05 0.001 4.336470e-05 0.0 4.336475e-05 0.001 4.336480e-05 0.0 4.336485e-05 0.001 4.336490e-05 0.0 4.336495e-05 0.001 4.336500e-05 0.0 4.336505e-05 0.001 4.336510e-05 0.0 4.336515e-05 0.001 4.336520e-05 0.0 4.336525e-05 0.001 4.336530e-05 0.0 4.336535e-05 0.001 4.336540e-05 0.0 4.336545e-05 0.001 4.336550e-05 0.0 4.336555e-05 0.001 4.336560e-05 0.0 4.336565e-05 0.001 4.336570e-05 0.0 4.336575e-05 0.001 4.336580e-05 0.0 4.336585e-05 0.001 4.336590e-05 0.0 4.336595e-05 0.001 4.336600e-05 0.0 4.336605e-05 0.001 4.336610e-05 0.0 4.336615e-05 0.001 4.336620e-05 0.0 4.336625e-05 0.001 4.336630e-05 0.0 4.336635e-05 0.001 4.336640e-05 0.0 4.336645e-05 0.001 4.336650e-05 0.0 4.336655e-05 0.001 4.336660e-05 0.0 4.336665e-05 0.001 4.336670e-05 0.0 4.336675e-05 0.001 4.336680e-05 0.0 4.336685e-05 0.001 4.336690e-05 0.0 4.336695e-05 0.001 4.336700e-05 0.0 4.336705e-05 0.001 4.336710e-05 0.0 4.336715e-05 0.001 4.336720e-05 0.0 4.336725e-05 0.001 4.336730e-05 0.0 4.336735e-05 0.001 4.336740e-05 0.0 4.336745e-05 0.001 4.336750e-05 0.0 4.336755e-05 0.001 4.336760e-05 0.0 4.336765e-05 0.001 4.336770e-05 0.0 4.336775e-05 0.001 4.336780e-05 0.0 4.336785e-05 0.001 4.336790e-05 0.0 4.336795e-05 0.001 4.336800e-05 0.0 4.336805e-05 0.001 4.336810e-05 0.0 4.336815e-05 0.001 4.336820e-05 0.0 4.336825e-05 0.001 4.336830e-05 0.0 4.336835e-05 0.001 4.336840e-05 0.0 4.336845e-05 0.001 4.336850e-05 0.0 4.336855e-05 0.001 4.336860e-05 0.0 4.336865e-05 0.001 4.336870e-05 0.0 4.336875e-05 0.001 4.336880e-05 0.0 4.336885e-05 0.001 4.336890e-05 0.0 4.336895e-05 0.001 4.336900e-05 0.0 4.336905e-05 0.001 4.336910e-05 0.0 4.336915e-05 0.001 4.336920e-05 0.0 4.336925e-05 0.001 4.336930e-05 0.0 4.336935e-05 0.001 4.336940e-05 0.0 4.336945e-05 0.001 4.336950e-05 0.0 4.336955e-05 0.001 4.336960e-05 0.0 4.336965e-05 0.001 4.336970e-05 0.0 4.336975e-05 0.001 4.336980e-05 0.0 4.336985e-05 0.001 4.336990e-05 0.0 4.336995e-05 0.001 4.337000e-05 0.0 4.337005e-05 0.001 4.337010e-05 0.0 4.337015e-05 0.001 4.337020e-05 0.0 4.337025e-05 0.001 4.337030e-05 0.0 4.337035e-05 0.001 4.337040e-05 0.0 4.337045e-05 0.001 4.337050e-05 0.0 4.337055e-05 0.001 4.337060e-05 0.0 4.337065e-05 0.001 4.337070e-05 0.0 4.337075e-05 0.001 4.337080e-05 0.0 4.337085e-05 0.001 4.337090e-05 0.0 4.337095e-05 0.001 4.337100e-05 0.0 4.337105e-05 0.001 4.337110e-05 0.0 4.337115e-05 0.001 4.337120e-05 0.0 4.337125e-05 0.001 4.337130e-05 0.0 4.337135e-05 0.001 4.337140e-05 0.0 4.337145e-05 0.001 4.337150e-05 0.0 4.337155e-05 0.001 4.337160e-05 0.0 4.337165e-05 0.001 4.337170e-05 0.0 4.337175e-05 0.001 4.337180e-05 0.0 4.337185e-05 0.001 4.337190e-05 0.0 4.337195e-05 0.001 4.337200e-05 0.0 4.337205e-05 0.001 4.337210e-05 0.0 4.337215e-05 0.001 4.337220e-05 0.0 4.337225e-05 0.001 4.337230e-05 0.0 4.337235e-05 0.001 4.337240e-05 0.0 4.337245e-05 0.001 4.337250e-05 0.0 4.337255e-05 0.001 4.337260e-05 0.0 4.337265e-05 0.001 4.337270e-05 0.0 4.337275e-05 0.001 4.337280e-05 0.0 4.337285e-05 0.001 4.337290e-05 0.0 4.337295e-05 0.001 4.337300e-05 0.0 4.337305e-05 0.001 4.337310e-05 0.0 4.337315e-05 0.001 4.337320e-05 0.0 4.337325e-05 0.001 4.337330e-05 0.0 4.337335e-05 0.001 4.337340e-05 0.0 4.337345e-05 0.001 4.337350e-05 0.0 4.337355e-05 0.001 4.337360e-05 0.0 4.337365e-05 0.001 4.337370e-05 0.0 4.337375e-05 0.001 4.337380e-05 0.0 4.337385e-05 0.001 4.337390e-05 0.0 4.337395e-05 0.001 4.337400e-05 0.0 4.337405e-05 0.001 4.337410e-05 0.0 4.337415e-05 0.001 4.337420e-05 0.0 4.337425e-05 0.001 4.337430e-05 0.0 4.337435e-05 0.001 4.337440e-05 0.0 4.337445e-05 0.001 4.337450e-05 0.0 4.337455e-05 0.001 4.337460e-05 0.0 4.337465e-05 0.001 4.337470e-05 0.0 4.337475e-05 0.001 4.337480e-05 0.0 4.337485e-05 0.001 4.337490e-05 0.0 4.337495e-05 0.001 4.337500e-05 0.0 4.337505e-05 0.001 4.337510e-05 0.0)
Rgrid grid 0 1G
.control
set noaskquit
tran 1n 4.4175e-05 0 2n
meas tran c_oa when v(c_oa)=0.9 rise=1
meas tran c_ob when v(c_ob)=0.9 rise=1
meas tran q_oa when v(q_oa)=0.9 rise=1
meas tran q_ob when v(q_ob)=0.9 rise=1
meas tran a0_oa when v(a0_oa)=0.9 rise=1
meas tran a0_ob when v(a0_ob)=0.9 rise=1
meas tran a1_oa when v(a1_oa)=0.9 rise=1
meas tran a1_ob when v(a1_ob)=0.9 rise=1
meas tran a2_oa when v(a2_oa)=0.9 rise=1
meas tran a2_ob when v(a2_ob)=0.9 rise=1
meas tran a3_oa when v(a3_oa)=0.9 rise=1
meas tran a3_ob when v(a3_ob)=0.9 rise=1
meas tran a4_oa when v(a4_oa)=0.9 rise=1
meas tran a4_ob when v(a4_ob)=0.9 rise=1
echo RES ff -40 c_oa=$&c_oa
echo RES ff -40 c_ob=$&c_ob
echo RES ff -40 q_oa=$&q_oa
echo RES ff -40 q_ob=$&q_ob
echo RES ff -40 a0_oa=$&a0_oa
echo RES ff -40 a0_ob=$&a0_ob
echo RES ff -40 a1_oa=$&a1_oa
echo RES ff -40 a1_ob=$&a1_ob
echo RES ff -40 a2_oa=$&a2_oa
echo RES ff -40 a2_ob=$&a2_ob
echo RES ff -40 a3_oa=$&a3_oa
echo RES ff -40 a3_ob=$&a3_ob
echo RES ff -40 a4_oa=$&a4_oa
echo RES ff -40 a4_ob=$&a4_ob
quit
.endc
.end
