* NGSPICE file created from xc20w.ext - technology: sky130A

.subckt xc20w SEL0 SEL1 SEL2 SEL3 SEL4 SEL5 SEL6 X GND
X0 a_700_n392# X sky130_fd_pr__diode_pd2nw_05v5 perim=4.8e+06 area=1.4e+12
X1 a_3688_n392# X sky130_fd_pr__diode_pd2nw_05v5 perim=4.8e+06 area=1.4e+12
X2 a_2880_n392# X sky130_fd_pr__diode_pd2nw_05v5 perim=4.8e+06 area=1.4e+12
X3 GND SEL2 a_1400_n392# GND sky130_fd_pr__nfet_01v8 ad=0.252 pd=2.28 as=0.252 ps=2.28 w=0.84 l=0.15
X4 a_2126_n392# X sky130_fd_pr__diode_pd2nw_05v5 perim=4.8e+06 area=1.4e+12
X5 GND SEL0 a_0_n392# GND sky130_fd_pr__nfet_01v8 ad=0.252 pd=2.28 as=0.252 ps=2.28 w=0.84 l=0.15
X6 a_4604_n392# X sky130_fd_pr__diode_pd2nw_05v5 perim=4.8e+06 area=1.4e+12
X7 GND SEL6 a_4604_n392# GND sky130_fd_pr__nfet_01v8 ad=0.252 pd=2.28 as=0.252 ps=2.28 w=0.84 l=0.15
X8 GND SEL4 a_2880_n392# GND sky130_fd_pr__nfet_01v8 ad=0.252 pd=2.28 as=0.252 ps=2.28 w=0.84 l=0.15
X9 GND SEL3 a_2126_n392# GND sky130_fd_pr__nfet_01v8 ad=0.252 pd=2.28 as=0.252 ps=2.28 w=0.84 l=0.15
X10 GND SEL5 a_3688_n392# GND sky130_fd_pr__nfet_01v8 ad=0.252 pd=2.28 as=0.252 ps=2.28 w=0.84 l=0.15
X11 a_0_n392# X sky130_fd_pr__diode_pd2nw_05v5 perim=4.8e+06 area=1.4e+12
X12 GND SEL1 a_700_n392# GND sky130_fd_pr__nfet_01v8 ad=0.252 pd=2.28 as=0.252 ps=2.28 w=0.84 l=0.15
X13 a_1400_n392# X sky130_fd_pr__diode_pd2nw_05v5 perim=4.8e+06 area=1.4e+12
C0 SEL3 a_2126_n392# 0.00602f
C1 SEL1 SEL0 0.02517f
C2 X a_3688_n392# 0.07358f
C3 SEL5 SEL4 0.0217f
C4 X a_2880_n392# 0.07755f
C5 SEL2 SEL1 0.02517f
C6 X SEL1 0.0036f
C7 SEL2 SEL3 0.02424f
C8 X SEL3 0.0036f
C9 SEL1 a_700_n392# 0.00602f
C10 SEL5 SEL6 0.01906f
C11 SEL4 a_3688_n392# 0
C12 a_2880_n392# SEL4 0.00602f
C13 SEL3 SEL4 0.02331f
C14 SEL5 a_3688_n392# 0.00602f
C15 a_1400_n392# SEL1 0
C16 X a_4604_n392# 0.06771f
C17 SEL0 a_0_n392# 0.00602f
C18 a_2880_n392# a_3688_n392# 0.00369f
C19 SEL2 a_2126_n392# 0
C20 X a_2126_n392# 0.08066f
C21 X SEL0 0.0036f
C22 a_2880_n392# SEL3 0
C23 X a_0_n392# 0.06002f
C24 SEL0 a_700_n392# 0
C25 a_0_n392# a_700_n392# 0.00426f
C26 X SEL2 0.0036f
C27 X a_700_n392# 0.08513f
C28 SEL5 a_4604_n392# 0
C29 a_4604_n392# SEL6 0.00602f
C30 a_1400_n392# a_2126_n392# 0.00411f
C31 X SEL4 0.0036f
C32 a_4604_n392# a_3688_n392# 0.00325f
C33 X SEL5 0.0036f
C34 a_1400_n392# SEL2 0.00602f
C35 a_1400_n392# X 0.08273f
C36 a_2880_n392# a_2126_n392# 0.00395f
C37 X SEL6 0.0036f
C38 a_1400_n392# a_700_n392# 0.00426f
C39 SEL6 GND 0.35288f
C40 SEL5 GND 0.3262f
C41 SEL4 GND 0.3217f
C42 SEL3 GND 0.31911f
C43 SEL2 GND 0.31725f
C44 SEL1 GND 0.31633f
C45 SEL0 GND 0.34648f
C46 X GND 8.95948f
C47 a_4604_n392# GND 0.31637f
C48 a_3688_n392# GND 0.3035f
C49 a_2880_n392# GND 0.2983f
C50 a_2126_n392# GND 0.29495f
C51 a_1400_n392# GND 0.29282f
C52 a_700_n392# GND 0.29098f
C53 a_0_n392# GND 0.32187f
.ends
