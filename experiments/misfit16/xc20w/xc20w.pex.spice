* NGSPICE file created from xc20w.ext - technology: sky130A

.subckt xc20w SEL0 SEL1 SEL2 SEL3 SEL4 SEL5 SEL6 X GND
X0 a_700_n392# X sky130_fd_pr__diode_pd2nw_05v5 perim=4.8e+06 area=1.4e+12
X1 GND SEL6 a_4632_n392# GND sky130_fd_pr__nfet_01v8 ad=0.252 pd=2.28 as=0.252 ps=2.28 w=0.84 l=0.15
X2 GND SEL3 a_2154_n392# GND sky130_fd_pr__nfet_01v8 ad=0.252 pd=2.28 as=0.252 ps=2.28 w=0.84 l=0.15
X3 a_3716_n392# X sky130_fd_pr__diode_pd2nw_05v5 perim=4.8e+06 area=1.4e+12
X4 a_2908_n392# X sky130_fd_pr__diode_pd2nw_05v5 perim=4.8e+06 area=1.4e+12
X5 GND SEL2 a_1400_n392# GND sky130_fd_pr__nfet_01v8 ad=0.252 pd=2.28 as=0.252 ps=2.28 w=0.84 l=0.15
X6 GND SEL0 a_0_n392# GND sky130_fd_pr__nfet_01v8 ad=0.252 pd=2.28 as=0.252 ps=2.28 w=0.84 l=0.15
X7 GND SEL5 a_3716_n392# GND sky130_fd_pr__nfet_01v8 ad=0.252 pd=2.28 as=0.252 ps=2.28 w=0.84 l=0.15
X8 a_2154_n392# X sky130_fd_pr__diode_pd2nw_05v5 perim=4.8e+06 area=1.4e+12
X9 a_4632_n392# X sky130_fd_pr__diode_pd2nw_05v5 perim=4.8e+06 area=1.4e+12
X10 GND SEL4 a_2908_n392# GND sky130_fd_pr__nfet_01v8 ad=0.252 pd=2.28 as=0.252 ps=2.28 w=0.84 l=0.15
X11 a_0_n392# X sky130_fd_pr__diode_pd2nw_05v5 perim=4.8e+06 area=1.4e+12
X12 GND SEL1 a_700_n392# GND sky130_fd_pr__nfet_01v8 ad=0.252 pd=2.28 as=0.252 ps=2.28 w=0.84 l=0.15
X13 a_1400_n392# X sky130_fd_pr__diode_pd2nw_05v5 perim=4.8e+06 area=1.4e+12
C0 a_1400_n392# a_2154_n392# 0.00395f
C1 X SEL4 0.0036f
C2 a_4632_n392# a_3716_n392# 0.00325f
C3 X SEL5 0.0036f
C4 a_1400_n392# SEL2 0.00602f
C5 a_1400_n392# X 0.0806f
C6 a_2908_n392# a_2154_n392# 0.00395f
C7 X SEL6 0.0036f
C8 a_1400_n392# a_700_n392# 0.00426f
C9 SEL3 a_2154_n392# 0.00602f
C10 SEL1 SEL0 0.02517f
C11 X a_3716_n392# 0.07358f
C12 SEL5 SEL4 0.0217f
C13 X a_2908_n392# 0.07755f
C14 SEL2 SEL1 0.02517f
C15 X SEL1 0.0036f
C16 SEL2 SEL3 0.02331f
C17 X SEL3 0.0036f
C18 SEL1 a_700_n392# 0.00602f
C19 SEL5 SEL6 0.01906f
C20 SEL4 a_3716_n392# 0
C21 a_2908_n392# SEL4 0.00602f
C22 SEL3 SEL4 0.02331f
C23 SEL5 a_3716_n392# 0.00602f
C24 a_1400_n392# SEL1 0
C25 X a_4632_n392# 0.06771f
C26 SEL0 a_0_n392# 0.00602f
C27 a_2908_n392# a_3716_n392# 0.00369f
C28 SEL2 a_2154_n392# 0
C29 X a_2154_n392# 0.08071f
C30 X SEL0 0.0036f
C31 a_2908_n392# SEL3 0
C32 X a_0_n392# 0.06002f
C33 SEL0 a_700_n392# 0
C34 a_0_n392# a_700_n392# 0.00426f
C35 X SEL2 0.0036f
C36 X a_700_n392# 0.08513f
C37 SEL5 a_4632_n392# 0
C38 a_4632_n392# SEL6 0.00602f
C39 SEL6 GND 0.35288f
C40 SEL5 GND 0.3262f
C41 SEL4 GND 0.3217f
C42 SEL3 GND 0.32004f
C43 SEL2 GND 0.31819f
C44 SEL1 GND 0.31633f
C45 SEL0 GND 0.34648f
C46 X GND 9.0034f
C47 a_4632_n392# GND 0.31637f
C48 a_3716_n392# GND 0.3035f
C49 a_2908_n392# GND 0.2983f
C50 a_2154_n392# GND 0.2953f
C51 a_1400_n392# GND 0.29462f
C52 a_700_n392# GND 0.29098f
C53 a_0_n392# GND 0.32187f
.ends
