* geometrias en borde de bin usadas por los generadores (b20, e53, v4n, b05), esquina fs
.lib /pdk/libs.tech/ngspice/sky130.lib.spice fs
.temp 27
Vg g 0 0.9
Vd d 0 0.05
Vgn gn 0 -0.9
Vdn dn 0 -0.05
Vg5 g5 0 2.5
Vgn5 gn5 0 -2.5
x0 d g 0 0 sky130_fd_pr__nfet_01v8 w=1 l=0.5 ad=0.2900 as=0.2900 pd=2.580 ps=2.580
x1 d g 0 0 sky130_fd_pr__nfet_01v8 w=2 l=0.5 ad=0.5800 as=0.5800 pd=4.580 ps=4.580
x2 d g 0 0 sky130_fd_pr__nfet_01v8 w=2 l=2 ad=0.5800 as=0.5800 pd=4.580 ps=4.580
x3 d g 0 0 sky130_fd_pr__nfet_01v8 w=5 l=1 ad=1.4500 as=1.4500 pd=10.580 ps=10.580
x4 d g 0 0 sky130_fd_pr__nfet_01v8 w=4 l=1 ad=1.1600 as=1.1600 pd=8.580 ps=8.580
x5 d g 0 0 sky130_fd_pr__nfet_01v8 w=4 l=4 ad=1.1600 as=1.1600 pd=8.580 ps=8.580
x6 d g 0 0 sky130_fd_pr__nfet_01v8 w=1 l=0.15 ad=0.2900 as=0.2900 pd=2.580 ps=2.580
x7 d g 0 0 sky130_fd_pr__nfet_01v8 w=0.65 l=0.15 ad=0.1885 as=0.1885 pd=1.880 ps=1.880
x8 d g 0 0 sky130_fd_pr__nfet_01v8 w=0.42 l=0.15 ad=0.1218 as=0.1218 pd=1.420 ps=1.420
x9 d g 0 0 sky130_fd_pr__nfet_01v8 w=4 l=0.5 ad=1.1600 as=1.1600 pd=8.580 ps=8.580
x10 d g 0 0 sky130_fd_pr__nfet_01v8 w=5 l=0.5 ad=1.4500 as=1.4500 pd=10.580 ps=10.580
x11 d g 0 0 sky130_fd_pr__nfet_01v8 w=1 l=1 ad=0.2900 as=0.2900 pd=2.580 ps=2.580
x12 d g 0 0 sky130_fd_pr__nfet_01v8_lvt w=1 l=0.5 ad=0.2900 as=0.2900 pd=2.580 ps=2.580
x13 d g 0 0 sky130_fd_pr__nfet_01v8_lvt w=2 l=0.5 ad=0.5800 as=0.5800 pd=4.580 ps=4.580
x14 d g 0 0 sky130_fd_pr__nfet_01v8_lvt w=2 l=2 ad=0.5800 as=0.5800 pd=4.580 ps=4.580
x15 d g 0 0 sky130_fd_pr__nfet_01v8_lvt w=5 l=1 ad=1.4500 as=1.4500 pd=10.580 ps=10.580
x16 d g 0 0 sky130_fd_pr__nfet_01v8_lvt w=4 l=1 ad=1.1600 as=1.1600 pd=8.580 ps=8.580
x17 d g 0 0 sky130_fd_pr__nfet_01v8_lvt w=4 l=4 ad=1.1600 as=1.1600 pd=8.580 ps=8.580
x18 d g 0 0 sky130_fd_pr__nfet_01v8_lvt w=1 l=0.15 ad=0.2900 as=0.2900 pd=2.580 ps=2.580
x19 d g 0 0 sky130_fd_pr__nfet_01v8_lvt w=0.65 l=0.15 ad=0.1885 as=0.1885 pd=1.880 ps=1.880
x20 d g 0 0 sky130_fd_pr__nfet_01v8_lvt w=0.42 l=0.15 ad=0.1218 as=0.1218 pd=1.420 ps=1.420
x21 d g 0 0 sky130_fd_pr__nfet_01v8_lvt w=4 l=0.5 ad=1.1600 as=1.1600 pd=8.580 ps=8.580
x22 d g 0 0 sky130_fd_pr__nfet_01v8_lvt w=5 l=0.5 ad=1.4500 as=1.4500 pd=10.580 ps=10.580
x23 d g 0 0 sky130_fd_pr__nfet_01v8_lvt w=1 l=1 ad=0.2900 as=0.2900 pd=2.580 ps=2.580
x24 dn gn 0 0 sky130_fd_pr__pfet_01v8 w=1 l=0.5 ad=0.2900 as=0.2900 pd=2.580 ps=2.580
x25 dn gn 0 0 sky130_fd_pr__pfet_01v8 w=2 l=0.5 ad=0.5800 as=0.5800 pd=4.580 ps=4.580
x26 dn gn 0 0 sky130_fd_pr__pfet_01v8 w=2 l=2 ad=0.5800 as=0.5800 pd=4.580 ps=4.580
x27 dn gn 0 0 sky130_fd_pr__pfet_01v8 w=5 l=1 ad=1.4500 as=1.4500 pd=10.580 ps=10.580
x28 dn gn 0 0 sky130_fd_pr__pfet_01v8 w=4 l=1 ad=1.1600 as=1.1600 pd=8.580 ps=8.580
x29 dn gn 0 0 sky130_fd_pr__pfet_01v8 w=4 l=4 ad=1.1600 as=1.1600 pd=8.580 ps=8.580
x30 dn gn 0 0 sky130_fd_pr__pfet_01v8 w=1 l=0.15 ad=0.2900 as=0.2900 pd=2.580 ps=2.580
x31 dn gn 0 0 sky130_fd_pr__pfet_01v8 w=0.65 l=0.15 ad=0.1885 as=0.1885 pd=1.880 ps=1.880
x32 dn gn 0 0 sky130_fd_pr__pfet_01v8 w=0.42 l=0.15 ad=0.1218 as=0.1218 pd=1.420 ps=1.420
x33 dn gn 0 0 sky130_fd_pr__pfet_01v8 w=4 l=0.5 ad=1.1600 as=1.1600 pd=8.580 ps=8.580
x34 dn gn 0 0 sky130_fd_pr__pfet_01v8 w=5 l=0.5 ad=1.4500 as=1.4500 pd=10.580 ps=10.580
x35 dn gn 0 0 sky130_fd_pr__pfet_01v8 w=1 l=1 ad=0.2900 as=0.2900 pd=2.580 ps=2.580
x36 dn gn 0 0 sky130_fd_pr__pfet_01v8_lvt w=1 l=0.5 ad=0.2900 as=0.2900 pd=2.580 ps=2.580
x37 dn gn 0 0 sky130_fd_pr__pfet_01v8_lvt w=2 l=0.5 ad=0.5800 as=0.5800 pd=4.580 ps=4.580
x38 dn gn 0 0 sky130_fd_pr__pfet_01v8_lvt w=2 l=2 ad=0.5800 as=0.5800 pd=4.580 ps=4.580
x39 dn gn 0 0 sky130_fd_pr__pfet_01v8_lvt w=5 l=1 ad=1.4500 as=1.4500 pd=10.580 ps=10.580
x40 dn gn 0 0 sky130_fd_pr__pfet_01v8_lvt w=4 l=1 ad=1.1600 as=1.1600 pd=8.580 ps=8.580
x41 dn gn 0 0 sky130_fd_pr__pfet_01v8_lvt w=4 l=4 ad=1.1600 as=1.1600 pd=8.580 ps=8.580
x42 dn gn 0 0 sky130_fd_pr__pfet_01v8_lvt w=4 l=0.5 ad=1.1600 as=1.1600 pd=8.580 ps=8.580
x43 dn gn 0 0 sky130_fd_pr__pfet_01v8_lvt w=5 l=0.5 ad=1.4500 as=1.4500 pd=10.580 ps=10.580
x44 dn gn 0 0 sky130_fd_pr__pfet_01v8_lvt w=1 l=1 ad=0.2900 as=0.2900 pd=2.580 ps=2.580
x45 dn gn 0 0 sky130_fd_pr__pfet_01v8_hvt w=1 l=0.5 ad=0.2900 as=0.2900 pd=2.580 ps=2.580
x46 dn gn 0 0 sky130_fd_pr__pfet_01v8_hvt w=2 l=0.5 ad=0.5800 as=0.5800 pd=4.580 ps=4.580
x47 dn gn 0 0 sky130_fd_pr__pfet_01v8_hvt w=2 l=2 ad=0.5800 as=0.5800 pd=4.580 ps=4.580
x48 dn gn 0 0 sky130_fd_pr__pfet_01v8_hvt w=5 l=1 ad=1.4500 as=1.4500 pd=10.580 ps=10.580
x49 dn gn 0 0 sky130_fd_pr__pfet_01v8_hvt w=4 l=1 ad=1.1600 as=1.1600 pd=8.580 ps=8.580
x50 dn gn 0 0 sky130_fd_pr__pfet_01v8_hvt w=4 l=4 ad=1.1600 as=1.1600 pd=8.580 ps=8.580
x51 dn gn 0 0 sky130_fd_pr__pfet_01v8_hvt w=1 l=0.15 ad=0.2900 as=0.2900 pd=2.580 ps=2.580
x52 dn gn 0 0 sky130_fd_pr__pfet_01v8_hvt w=0.65 l=0.15 ad=0.1885 as=0.1885 pd=1.880 ps=1.880
x53 dn gn 0 0 sky130_fd_pr__pfet_01v8_hvt w=0.42 l=0.15 ad=0.1218 as=0.1218 pd=1.420 ps=1.420
x54 dn gn 0 0 sky130_fd_pr__pfet_01v8_hvt w=4 l=0.5 ad=1.1600 as=1.1600 pd=8.580 ps=8.580
x55 dn gn 0 0 sky130_fd_pr__pfet_01v8_hvt w=5 l=0.5 ad=1.4500 as=1.4500 pd=10.580 ps=10.580
x56 dn gn 0 0 sky130_fd_pr__pfet_01v8_hvt w=1 l=1 ad=0.2900 as=0.2900 pd=2.580 ps=2.580
x57 d g5 0 0 sky130_fd_pr__nfet_g5v0d10v5 w=1 l=0.5 ad=0.2900 as=0.2900 pd=2.580 ps=2.580
x58 d g5 0 0 sky130_fd_pr__nfet_g5v0d10v5 w=2 l=0.5 ad=0.5800 as=0.5800 pd=4.580 ps=4.580
x59 d g5 0 0 sky130_fd_pr__nfet_g5v0d10v5 w=2 l=2 ad=0.5800 as=0.5800 pd=4.580 ps=4.580
x60 d g5 0 0 sky130_fd_pr__nfet_g5v0d10v5 w=5 l=1 ad=1.4500 as=1.4500 pd=10.580 ps=10.580
x61 d g5 0 0 sky130_fd_pr__nfet_g5v0d10v5 w=4 l=1 ad=1.1600 as=1.1600 pd=8.580 ps=8.580
x62 d g5 0 0 sky130_fd_pr__nfet_g5v0d10v5 w=4 l=4 ad=1.1600 as=1.1600 pd=8.580 ps=8.580
x63 d g5 0 0 sky130_fd_pr__nfet_g5v0d10v5 w=4 l=0.5 ad=1.1600 as=1.1600 pd=8.580 ps=8.580
x64 d g5 0 0 sky130_fd_pr__nfet_g5v0d10v5 w=5 l=0.5 ad=1.4500 as=1.4500 pd=10.580 ps=10.580
x65 d g5 0 0 sky130_fd_pr__nfet_g5v0d10v5 w=1 l=1 ad=0.2900 as=0.2900 pd=2.580 ps=2.580
x66 dn gn5 0 0 sky130_fd_pr__pfet_g5v0d10v5 w=1 l=0.5 ad=0.2900 as=0.2900 pd=2.580 ps=2.580
x67 dn gn5 0 0 sky130_fd_pr__pfet_g5v0d10v5 w=2 l=0.5 ad=0.5800 as=0.5800 pd=4.580 ps=4.580
x68 dn gn5 0 0 sky130_fd_pr__pfet_g5v0d10v5 w=2 l=2 ad=0.5800 as=0.5800 pd=4.580 ps=4.580
x69 dn gn5 0 0 sky130_fd_pr__pfet_g5v0d10v5 w=5 l=1 ad=1.4500 as=1.4500 pd=10.580 ps=10.580
x70 dn gn5 0 0 sky130_fd_pr__pfet_g5v0d10v5 w=4 l=1 ad=1.1600 as=1.1600 pd=8.580 ps=8.580
x71 dn gn5 0 0 sky130_fd_pr__pfet_g5v0d10v5 w=4 l=4 ad=1.1600 as=1.1600 pd=8.580 ps=8.580
x72 dn gn5 0 0 sky130_fd_pr__pfet_g5v0d10v5 w=4 l=0.5 ad=1.1600 as=1.1600 pd=8.580 ps=8.580
x73 dn gn5 0 0 sky130_fd_pr__pfet_g5v0d10v5 w=5 l=0.5 ad=1.4500 as=1.4500 pd=10.580 ps=10.580
x74 dn gn5 0 0 sky130_fd_pr__pfet_g5v0d10v5 w=1 l=1 ad=0.2900 as=0.2900 pd=2.580 ps=2.580
.control
op
echo VT fs nfet_01v8 1 0.5 $&@m.x0.msky130_fd_pr__nfet_01v8[vth] $&@m.x0.msky130_fd_pr__nfet_01v8[id]
echo VT fs nfet_01v8 2 0.5 $&@m.x1.msky130_fd_pr__nfet_01v8[vth] $&@m.x1.msky130_fd_pr__nfet_01v8[id]
echo VT fs nfet_01v8 2 2 $&@m.x2.msky130_fd_pr__nfet_01v8[vth] $&@m.x2.msky130_fd_pr__nfet_01v8[id]
echo VT fs nfet_01v8 5 1 $&@m.x3.msky130_fd_pr__nfet_01v8[vth] $&@m.x3.msky130_fd_pr__nfet_01v8[id]
echo VT fs nfet_01v8 4 1 $&@m.x4.msky130_fd_pr__nfet_01v8[vth] $&@m.x4.msky130_fd_pr__nfet_01v8[id]
echo VT fs nfet_01v8 4 4 $&@m.x5.msky130_fd_pr__nfet_01v8[vth] $&@m.x5.msky130_fd_pr__nfet_01v8[id]
echo VT fs nfet_01v8 1 0.15 $&@m.x6.msky130_fd_pr__nfet_01v8[vth] $&@m.x6.msky130_fd_pr__nfet_01v8[id]
echo VT fs nfet_01v8 0.65 0.15 $&@m.x7.msky130_fd_pr__nfet_01v8[vth] $&@m.x7.msky130_fd_pr__nfet_01v8[id]
echo VT fs nfet_01v8 0.42 0.15 $&@m.x8.msky130_fd_pr__nfet_01v8[vth] $&@m.x8.msky130_fd_pr__nfet_01v8[id]
echo VT fs nfet_01v8 4 0.5 $&@m.x9.msky130_fd_pr__nfet_01v8[vth] $&@m.x9.msky130_fd_pr__nfet_01v8[id]
echo VT fs nfet_01v8 5 0.5 $&@m.x10.msky130_fd_pr__nfet_01v8[vth] $&@m.x10.msky130_fd_pr__nfet_01v8[id]
echo VT fs nfet_01v8 1 1 $&@m.x11.msky130_fd_pr__nfet_01v8[vth] $&@m.x11.msky130_fd_pr__nfet_01v8[id]
echo VT fs nfet_01v8_lvt 1 0.5 $&@m.x12.msky130_fd_pr__nfet_01v8_lvt[vth] $&@m.x12.msky130_fd_pr__nfet_01v8_lvt[id]
echo VT fs nfet_01v8_lvt 2 0.5 $&@m.x13.msky130_fd_pr__nfet_01v8_lvt[vth] $&@m.x13.msky130_fd_pr__nfet_01v8_lvt[id]
echo VT fs nfet_01v8_lvt 2 2 $&@m.x14.msky130_fd_pr__nfet_01v8_lvt[vth] $&@m.x14.msky130_fd_pr__nfet_01v8_lvt[id]
echo VT fs nfet_01v8_lvt 5 1 $&@m.x15.msky130_fd_pr__nfet_01v8_lvt[vth] $&@m.x15.msky130_fd_pr__nfet_01v8_lvt[id]
echo VT fs nfet_01v8_lvt 4 1 $&@m.x16.msky130_fd_pr__nfet_01v8_lvt[vth] $&@m.x16.msky130_fd_pr__nfet_01v8_lvt[id]
echo VT fs nfet_01v8_lvt 4 4 $&@m.x17.msky130_fd_pr__nfet_01v8_lvt[vth] $&@m.x17.msky130_fd_pr__nfet_01v8_lvt[id]
echo VT fs nfet_01v8_lvt 1 0.15 $&@m.x18.msky130_fd_pr__nfet_01v8_lvt[vth] $&@m.x18.msky130_fd_pr__nfet_01v8_lvt[id]
echo VT fs nfet_01v8_lvt 0.65 0.15 $&@m.x19.msky130_fd_pr__nfet_01v8_lvt[vth] $&@m.x19.msky130_fd_pr__nfet_01v8_lvt[id]
echo VT fs nfet_01v8_lvt 0.42 0.15 $&@m.x20.msky130_fd_pr__nfet_01v8_lvt[vth] $&@m.x20.msky130_fd_pr__nfet_01v8_lvt[id]
echo VT fs nfet_01v8_lvt 4 0.5 $&@m.x21.msky130_fd_pr__nfet_01v8_lvt[vth] $&@m.x21.msky130_fd_pr__nfet_01v8_lvt[id]
echo VT fs nfet_01v8_lvt 5 0.5 $&@m.x22.msky130_fd_pr__nfet_01v8_lvt[vth] $&@m.x22.msky130_fd_pr__nfet_01v8_lvt[id]
echo VT fs nfet_01v8_lvt 1 1 $&@m.x23.msky130_fd_pr__nfet_01v8_lvt[vth] $&@m.x23.msky130_fd_pr__nfet_01v8_lvt[id]
echo VT fs pfet_01v8 1 0.5 $&@m.x24.msky130_fd_pr__pfet_01v8[vth] $&@m.x24.msky130_fd_pr__pfet_01v8[id]
echo VT fs pfet_01v8 2 0.5 $&@m.x25.msky130_fd_pr__pfet_01v8[vth] $&@m.x25.msky130_fd_pr__pfet_01v8[id]
echo VT fs pfet_01v8 2 2 $&@m.x26.msky130_fd_pr__pfet_01v8[vth] $&@m.x26.msky130_fd_pr__pfet_01v8[id]
echo VT fs pfet_01v8 5 1 $&@m.x27.msky130_fd_pr__pfet_01v8[vth] $&@m.x27.msky130_fd_pr__pfet_01v8[id]
echo VT fs pfet_01v8 4 1 $&@m.x28.msky130_fd_pr__pfet_01v8[vth] $&@m.x28.msky130_fd_pr__pfet_01v8[id]
echo VT fs pfet_01v8 4 4 $&@m.x29.msky130_fd_pr__pfet_01v8[vth] $&@m.x29.msky130_fd_pr__pfet_01v8[id]
echo VT fs pfet_01v8 1 0.15 $&@m.x30.msky130_fd_pr__pfet_01v8[vth] $&@m.x30.msky130_fd_pr__pfet_01v8[id]
echo VT fs pfet_01v8 0.65 0.15 $&@m.x31.msky130_fd_pr__pfet_01v8[vth] $&@m.x31.msky130_fd_pr__pfet_01v8[id]
echo VT fs pfet_01v8 0.42 0.15 $&@m.x32.msky130_fd_pr__pfet_01v8[vth] $&@m.x32.msky130_fd_pr__pfet_01v8[id]
echo VT fs pfet_01v8 4 0.5 $&@m.x33.msky130_fd_pr__pfet_01v8[vth] $&@m.x33.msky130_fd_pr__pfet_01v8[id]
echo VT fs pfet_01v8 5 0.5 $&@m.x34.msky130_fd_pr__pfet_01v8[vth] $&@m.x34.msky130_fd_pr__pfet_01v8[id]
echo VT fs pfet_01v8 1 1 $&@m.x35.msky130_fd_pr__pfet_01v8[vth] $&@m.x35.msky130_fd_pr__pfet_01v8[id]
echo VT fs pfet_01v8_lvt 1 0.5 $&@m.x36.msky130_fd_pr__pfet_01v8_lvt[vth] $&@m.x36.msky130_fd_pr__pfet_01v8_lvt[id]
echo VT fs pfet_01v8_lvt 2 0.5 $&@m.x37.msky130_fd_pr__pfet_01v8_lvt[vth] $&@m.x37.msky130_fd_pr__pfet_01v8_lvt[id]
echo VT fs pfet_01v8_lvt 2 2 $&@m.x38.msky130_fd_pr__pfet_01v8_lvt[vth] $&@m.x38.msky130_fd_pr__pfet_01v8_lvt[id]
echo VT fs pfet_01v8_lvt 5 1 $&@m.x39.msky130_fd_pr__pfet_01v8_lvt[vth] $&@m.x39.msky130_fd_pr__pfet_01v8_lvt[id]
echo VT fs pfet_01v8_lvt 4 1 $&@m.x40.msky130_fd_pr__pfet_01v8_lvt[vth] $&@m.x40.msky130_fd_pr__pfet_01v8_lvt[id]
echo VT fs pfet_01v8_lvt 4 4 $&@m.x41.msky130_fd_pr__pfet_01v8_lvt[vth] $&@m.x41.msky130_fd_pr__pfet_01v8_lvt[id]
echo VT fs pfet_01v8_lvt 4 0.5 $&@m.x42.msky130_fd_pr__pfet_01v8_lvt[vth] $&@m.x42.msky130_fd_pr__pfet_01v8_lvt[id]
echo VT fs pfet_01v8_lvt 5 0.5 $&@m.x43.msky130_fd_pr__pfet_01v8_lvt[vth] $&@m.x43.msky130_fd_pr__pfet_01v8_lvt[id]
echo VT fs pfet_01v8_lvt 1 1 $&@m.x44.msky130_fd_pr__pfet_01v8_lvt[vth] $&@m.x44.msky130_fd_pr__pfet_01v8_lvt[id]
echo VT fs pfet_01v8_hvt 1 0.5 $&@m.x45.msky130_fd_pr__pfet_01v8_hvt[vth] $&@m.x45.msky130_fd_pr__pfet_01v8_hvt[id]
echo VT fs pfet_01v8_hvt 2 0.5 $&@m.x46.msky130_fd_pr__pfet_01v8_hvt[vth] $&@m.x46.msky130_fd_pr__pfet_01v8_hvt[id]
echo VT fs pfet_01v8_hvt 2 2 $&@m.x47.msky130_fd_pr__pfet_01v8_hvt[vth] $&@m.x47.msky130_fd_pr__pfet_01v8_hvt[id]
echo VT fs pfet_01v8_hvt 5 1 $&@m.x48.msky130_fd_pr__pfet_01v8_hvt[vth] $&@m.x48.msky130_fd_pr__pfet_01v8_hvt[id]
echo VT fs pfet_01v8_hvt 4 1 $&@m.x49.msky130_fd_pr__pfet_01v8_hvt[vth] $&@m.x49.msky130_fd_pr__pfet_01v8_hvt[id]
echo VT fs pfet_01v8_hvt 4 4 $&@m.x50.msky130_fd_pr__pfet_01v8_hvt[vth] $&@m.x50.msky130_fd_pr__pfet_01v8_hvt[id]
echo VT fs pfet_01v8_hvt 1 0.15 $&@m.x51.msky130_fd_pr__pfet_01v8_hvt[vth] $&@m.x51.msky130_fd_pr__pfet_01v8_hvt[id]
echo VT fs pfet_01v8_hvt 0.65 0.15 $&@m.x52.msky130_fd_pr__pfet_01v8_hvt[vth] $&@m.x52.msky130_fd_pr__pfet_01v8_hvt[id]
echo VT fs pfet_01v8_hvt 0.42 0.15 $&@m.x53.msky130_fd_pr__pfet_01v8_hvt[vth] $&@m.x53.msky130_fd_pr__pfet_01v8_hvt[id]
echo VT fs pfet_01v8_hvt 4 0.5 $&@m.x54.msky130_fd_pr__pfet_01v8_hvt[vth] $&@m.x54.msky130_fd_pr__pfet_01v8_hvt[id]
echo VT fs pfet_01v8_hvt 5 0.5 $&@m.x55.msky130_fd_pr__pfet_01v8_hvt[vth] $&@m.x55.msky130_fd_pr__pfet_01v8_hvt[id]
echo VT fs pfet_01v8_hvt 1 1 $&@m.x56.msky130_fd_pr__pfet_01v8_hvt[vth] $&@m.x56.msky130_fd_pr__pfet_01v8_hvt[id]
echo VT fs nfet_g5v0d10v5 1 0.5 $&@m.x57.msky130_fd_pr__nfet_g5v0d10v5[vth] $&@m.x57.msky130_fd_pr__nfet_g5v0d10v5[id]
echo VT fs nfet_g5v0d10v5 2 0.5 $&@m.x58.msky130_fd_pr__nfet_g5v0d10v5[vth] $&@m.x58.msky130_fd_pr__nfet_g5v0d10v5[id]
echo VT fs nfet_g5v0d10v5 2 2 $&@m.x59.msky130_fd_pr__nfet_g5v0d10v5[vth] $&@m.x59.msky130_fd_pr__nfet_g5v0d10v5[id]
echo VT fs nfet_g5v0d10v5 5 1 $&@m.x60.msky130_fd_pr__nfet_g5v0d10v5[vth] $&@m.x60.msky130_fd_pr__nfet_g5v0d10v5[id]
echo VT fs nfet_g5v0d10v5 4 1 $&@m.x61.msky130_fd_pr__nfet_g5v0d10v5[vth] $&@m.x61.msky130_fd_pr__nfet_g5v0d10v5[id]
echo VT fs nfet_g5v0d10v5 4 4 $&@m.x62.msky130_fd_pr__nfet_g5v0d10v5[vth] $&@m.x62.msky130_fd_pr__nfet_g5v0d10v5[id]
echo VT fs nfet_g5v0d10v5 4 0.5 $&@m.x63.msky130_fd_pr__nfet_g5v0d10v5[vth] $&@m.x63.msky130_fd_pr__nfet_g5v0d10v5[id]
echo VT fs nfet_g5v0d10v5 5 0.5 $&@m.x64.msky130_fd_pr__nfet_g5v0d10v5[vth] $&@m.x64.msky130_fd_pr__nfet_g5v0d10v5[id]
echo VT fs nfet_g5v0d10v5 1 1 $&@m.x65.msky130_fd_pr__nfet_g5v0d10v5[vth] $&@m.x65.msky130_fd_pr__nfet_g5v0d10v5[id]
echo VT fs pfet_g5v0d10v5 1 0.5 $&@m.x66.msky130_fd_pr__pfet_g5v0d10v5[vth] $&@m.x66.msky130_fd_pr__pfet_g5v0d10v5[id]
echo VT fs pfet_g5v0d10v5 2 0.5 $&@m.x67.msky130_fd_pr__pfet_g5v0d10v5[vth] $&@m.x67.msky130_fd_pr__pfet_g5v0d10v5[id]
echo VT fs pfet_g5v0d10v5 2 2 $&@m.x68.msky130_fd_pr__pfet_g5v0d10v5[vth] $&@m.x68.msky130_fd_pr__pfet_g5v0d10v5[id]
echo VT fs pfet_g5v0d10v5 5 1 $&@m.x69.msky130_fd_pr__pfet_g5v0d10v5[vth] $&@m.x69.msky130_fd_pr__pfet_g5v0d10v5[id]
echo VT fs pfet_g5v0d10v5 4 1 $&@m.x70.msky130_fd_pr__pfet_g5v0d10v5[vth] $&@m.x70.msky130_fd_pr__pfet_g5v0d10v5[id]
echo VT fs pfet_g5v0d10v5 4 4 $&@m.x71.msky130_fd_pr__pfet_g5v0d10v5[vth] $&@m.x71.msky130_fd_pr__pfet_g5v0d10v5[id]
echo VT fs pfet_g5v0d10v5 4 0.5 $&@m.x72.msky130_fd_pr__pfet_g5v0d10v5[vth] $&@m.x72.msky130_fd_pr__pfet_g5v0d10v5[id]
echo VT fs pfet_g5v0d10v5 5 0.5 $&@m.x73.msky130_fd_pr__pfet_g5v0d10v5[vth] $&@m.x73.msky130_fd_pr__pfet_g5v0d10v5[id]
echo VT fs pfet_g5v0d10v5 1 1 $&@m.x74.msky130_fd_pr__pfet_g5v0d10v5[vth] $&@m.x74.msky130_fd_pr__pfet_g5v0d10v5[id]
quit
.endc
.end
