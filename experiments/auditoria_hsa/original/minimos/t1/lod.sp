* pfet: que parametro de instancia reacciona a hs
.lib /pdk/libs.tech/ngspice/sky130.lib.spice tt
.temp 27
Vgn gn 0 -0.9
Vdn dn 0 -0.05
Vg g 0 0.9
Vd d 0 0.05
xpfet01v8hvt04205sch dn gn 0 0 sky130_fd_pr__pfet_01v8_hvt w=0.42 l=0.5
xpfet01v8hvt04205adps dn gn 0 0 sky130_fd_pr__pfet_01v8_hvt w=0.42 l=0.5 ad=0.126 pd=1.44 as=0.126 ps=1.44
xpfet01v8hvt04205sa03 dn gn 0 0 sky130_fd_pr__pfet_01v8_hvt w=0.42 l=0.5 sa=0.3 sb=0.3
xpfet01v8hvt04205sa026 dn gn 0 0 sky130_fd_pr__pfet_01v8_hvt w=0.42 l=0.5 sa=0.26 sb=0.26
xpfet01v8hvt04205sa3 dn gn 0 0 sky130_fd_pr__pfet_01v8_hvt w=0.42 l=0.5 sa=3 sb=3
xpfet01v8hvt04205both dn gn 0 0 sky130_fd_pr__pfet_01v8_hvt w=0.42 l=0.5 ad=0.126 pd=1.44 as=0.126 ps=1.44 sa=0.3 sb=0.3
xpfet01v8hvt04205sd dn gn 0 0 sky130_fd_pr__pfet_01v8_hvt w=0.42 l=0.5 sa=0.3 sb=0.3 sd=0.3 nf=2
xpfet01v8hvt1015sch dn gn 0 0 sky130_fd_pr__pfet_01v8_hvt w=1 l=0.15
xpfet01v8hvt1015adps dn gn 0 0 sky130_fd_pr__pfet_01v8_hvt w=1 l=0.15 ad=0.126 pd=1.44 as=0.126 ps=1.44
xpfet01v8hvt1015sa03 dn gn 0 0 sky130_fd_pr__pfet_01v8_hvt w=1 l=0.15 sa=0.3 sb=0.3
xpfet01v8hvt1015sa026 dn gn 0 0 sky130_fd_pr__pfet_01v8_hvt w=1 l=0.15 sa=0.26 sb=0.26
xpfet01v8hvt1015sa3 dn gn 0 0 sky130_fd_pr__pfet_01v8_hvt w=1 l=0.15 sa=3 sb=3
xpfet01v8hvt1015both dn gn 0 0 sky130_fd_pr__pfet_01v8_hvt w=1 l=0.15 ad=0.126 pd=1.44 as=0.126 ps=1.44 sa=0.3 sb=0.3
xpfet01v8hvt1015sd dn gn 0 0 sky130_fd_pr__pfet_01v8_hvt w=1 l=0.15 sa=0.3 sb=0.3 sd=0.3 nf=2
xpfet01v8hvt042015sch dn gn 0 0 sky130_fd_pr__pfet_01v8_hvt w=0.42 l=0.15
xpfet01v8hvt042015adps dn gn 0 0 sky130_fd_pr__pfet_01v8_hvt w=0.42 l=0.15 ad=0.126 pd=1.44 as=0.126 ps=1.44
xpfet01v8hvt042015sa03 dn gn 0 0 sky130_fd_pr__pfet_01v8_hvt w=0.42 l=0.15 sa=0.3 sb=0.3
xpfet01v8hvt042015sa026 dn gn 0 0 sky130_fd_pr__pfet_01v8_hvt w=0.42 l=0.15 sa=0.26 sb=0.26
xpfet01v8hvt042015sa3 dn gn 0 0 sky130_fd_pr__pfet_01v8_hvt w=0.42 l=0.15 sa=3 sb=3
xpfet01v8hvt042015both dn gn 0 0 sky130_fd_pr__pfet_01v8_hvt w=0.42 l=0.15 ad=0.126 pd=1.44 as=0.126 ps=1.44 sa=0.3 sb=0.3
xpfet01v8hvt042015sd dn gn 0 0 sky130_fd_pr__pfet_01v8_hvt w=0.42 l=0.15 sa=0.3 sb=0.3 sd=0.3 nf=2
xpfet01v804205sch dn gn 0 0 sky130_fd_pr__pfet_01v8 w=0.42 l=0.5
xpfet01v804205adps dn gn 0 0 sky130_fd_pr__pfet_01v8 w=0.42 l=0.5 ad=0.126 pd=1.44 as=0.126 ps=1.44
xpfet01v804205sa03 dn gn 0 0 sky130_fd_pr__pfet_01v8 w=0.42 l=0.5 sa=0.3 sb=0.3
xpfet01v804205sa026 dn gn 0 0 sky130_fd_pr__pfet_01v8 w=0.42 l=0.5 sa=0.26 sb=0.26
xpfet01v804205sa3 dn gn 0 0 sky130_fd_pr__pfet_01v8 w=0.42 l=0.5 sa=3 sb=3
xpfet01v804205both dn gn 0 0 sky130_fd_pr__pfet_01v8 w=0.42 l=0.5 ad=0.126 pd=1.44 as=0.126 ps=1.44 sa=0.3 sb=0.3
xpfet01v804205sd dn gn 0 0 sky130_fd_pr__pfet_01v8 w=0.42 l=0.5 sa=0.3 sb=0.3 sd=0.3 nf=2
xpfet01v81015sch dn gn 0 0 sky130_fd_pr__pfet_01v8 w=1 l=0.15
xpfet01v81015adps dn gn 0 0 sky130_fd_pr__pfet_01v8 w=1 l=0.15 ad=0.126 pd=1.44 as=0.126 ps=1.44
xpfet01v81015sa03 dn gn 0 0 sky130_fd_pr__pfet_01v8 w=1 l=0.15 sa=0.3 sb=0.3
xpfet01v81015sa026 dn gn 0 0 sky130_fd_pr__pfet_01v8 w=1 l=0.15 sa=0.26 sb=0.26
xpfet01v81015sa3 dn gn 0 0 sky130_fd_pr__pfet_01v8 w=1 l=0.15 sa=3 sb=3
xpfet01v81015both dn gn 0 0 sky130_fd_pr__pfet_01v8 w=1 l=0.15 ad=0.126 pd=1.44 as=0.126 ps=1.44 sa=0.3 sb=0.3
xpfet01v81015sd dn gn 0 0 sky130_fd_pr__pfet_01v8 w=1 l=0.15 sa=0.3 sb=0.3 sd=0.3 nf=2
xpfet01v8042015sch dn gn 0 0 sky130_fd_pr__pfet_01v8 w=0.42 l=0.15
xpfet01v8042015adps dn gn 0 0 sky130_fd_pr__pfet_01v8 w=0.42 l=0.15 ad=0.126 pd=1.44 as=0.126 ps=1.44
xpfet01v8042015sa03 dn gn 0 0 sky130_fd_pr__pfet_01v8 w=0.42 l=0.15 sa=0.3 sb=0.3
xpfet01v8042015sa026 dn gn 0 0 sky130_fd_pr__pfet_01v8 w=0.42 l=0.15 sa=0.26 sb=0.26
xpfet01v8042015sa3 dn gn 0 0 sky130_fd_pr__pfet_01v8 w=0.42 l=0.15 sa=3 sb=3
xpfet01v8042015both dn gn 0 0 sky130_fd_pr__pfet_01v8 w=0.42 l=0.15 ad=0.126 pd=1.44 as=0.126 ps=1.44 sa=0.3 sb=0.3
xpfet01v8042015sd dn gn 0 0 sky130_fd_pr__pfet_01v8 w=0.42 l=0.15 sa=0.3 sb=0.3 sd=0.3 nf=2
xnfet01v804205sch d g 0 0 sky130_fd_pr__nfet_01v8 w=0.42 l=0.5
xnfet01v804205adps d g 0 0 sky130_fd_pr__nfet_01v8 w=0.42 l=0.5 ad=0.126 pd=1.44 as=0.126 ps=1.44
xnfet01v804205sa03 d g 0 0 sky130_fd_pr__nfet_01v8 w=0.42 l=0.5 sa=0.3 sb=0.3
xnfet01v804205sa026 d g 0 0 sky130_fd_pr__nfet_01v8 w=0.42 l=0.5 sa=0.26 sb=0.26
xnfet01v804205sa3 d g 0 0 sky130_fd_pr__nfet_01v8 w=0.42 l=0.5 sa=3 sb=3
xnfet01v804205both d g 0 0 sky130_fd_pr__nfet_01v8 w=0.42 l=0.5 ad=0.126 pd=1.44 as=0.126 ps=1.44 sa=0.3 sb=0.3
xnfet01v804205sd d g 0 0 sky130_fd_pr__nfet_01v8 w=0.42 l=0.5 sa=0.3 sb=0.3 sd=0.3 nf=2
xnfet01v81015sch d g 0 0 sky130_fd_pr__nfet_01v8 w=1 l=0.15
xnfet01v81015adps d g 0 0 sky130_fd_pr__nfet_01v8 w=1 l=0.15 ad=0.126 pd=1.44 as=0.126 ps=1.44
xnfet01v81015sa03 d g 0 0 sky130_fd_pr__nfet_01v8 w=1 l=0.15 sa=0.3 sb=0.3
xnfet01v81015sa026 d g 0 0 sky130_fd_pr__nfet_01v8 w=1 l=0.15 sa=0.26 sb=0.26
xnfet01v81015sa3 d g 0 0 sky130_fd_pr__nfet_01v8 w=1 l=0.15 sa=3 sb=3
xnfet01v81015both d g 0 0 sky130_fd_pr__nfet_01v8 w=1 l=0.15 ad=0.126 pd=1.44 as=0.126 ps=1.44 sa=0.3 sb=0.3
xnfet01v81015sd d g 0 0 sky130_fd_pr__nfet_01v8 w=1 l=0.15 sa=0.3 sb=0.3 sd=0.3 nf=2
xnfet01v8042015sch d g 0 0 sky130_fd_pr__nfet_01v8 w=0.42 l=0.15
xnfet01v8042015adps d g 0 0 sky130_fd_pr__nfet_01v8 w=0.42 l=0.15 ad=0.126 pd=1.44 as=0.126 ps=1.44
xnfet01v8042015sa03 d g 0 0 sky130_fd_pr__nfet_01v8 w=0.42 l=0.15 sa=0.3 sb=0.3
xnfet01v8042015sa026 d g 0 0 sky130_fd_pr__nfet_01v8 w=0.42 l=0.15 sa=0.26 sb=0.26
xnfet01v8042015sa3 d g 0 0 sky130_fd_pr__nfet_01v8 w=0.42 l=0.15 sa=3 sb=3
xnfet01v8042015both d g 0 0 sky130_fd_pr__nfet_01v8 w=0.42 l=0.15 ad=0.126 pd=1.44 as=0.126 ps=1.44 sa=0.3 sb=0.3
xnfet01v8042015sd d g 0 0 sky130_fd_pr__nfet_01v8 w=0.42 l=0.15 sa=0.3 sb=0.3 sd=0.3 nf=2
xpfet01v8lvt04205sch dn gn 0 0 sky130_fd_pr__pfet_01v8_lvt w=0.42 l=0.5
xpfet01v8lvt04205adps dn gn 0 0 sky130_fd_pr__pfet_01v8_lvt w=0.42 l=0.5 ad=0.126 pd=1.44 as=0.126 ps=1.44
xpfet01v8lvt04205sa03 dn gn 0 0 sky130_fd_pr__pfet_01v8_lvt w=0.42 l=0.5 sa=0.3 sb=0.3
xpfet01v8lvt04205sa026 dn gn 0 0 sky130_fd_pr__pfet_01v8_lvt w=0.42 l=0.5 sa=0.26 sb=0.26
xpfet01v8lvt04205sa3 dn gn 0 0 sky130_fd_pr__pfet_01v8_lvt w=0.42 l=0.5 sa=3 sb=3
xpfet01v8lvt04205both dn gn 0 0 sky130_fd_pr__pfet_01v8_lvt w=0.42 l=0.5 ad=0.126 pd=1.44 as=0.126 ps=1.44 sa=0.3 sb=0.3
xpfet01v8lvt04205sd dn gn 0 0 sky130_fd_pr__pfet_01v8_lvt w=0.42 l=0.5 sa=0.3 sb=0.3 sd=0.3 nf=2
.control
op
echo VT pfet_01v8_hvt 0.42 0.5 sch $&@m.xpfet01v8hvt04205sch.msky130_fd_pr__pfet_01v8_hvt[vth] $&@m.xpfet01v8hvt04205sch.msky130_fd_pr__pfet_01v8_hvt[id]
echo VT pfet_01v8_hvt 0.42 0.5 adps $&@m.xpfet01v8hvt04205adps.msky130_fd_pr__pfet_01v8_hvt[vth] $&@m.xpfet01v8hvt04205adps.msky130_fd_pr__pfet_01v8_hvt[id]
echo VT pfet_01v8_hvt 0.42 0.5 sa03 $&@m.xpfet01v8hvt04205sa03.msky130_fd_pr__pfet_01v8_hvt[vth] $&@m.xpfet01v8hvt04205sa03.msky130_fd_pr__pfet_01v8_hvt[id]
echo VT pfet_01v8_hvt 0.42 0.5 sa026 $&@m.xpfet01v8hvt04205sa026.msky130_fd_pr__pfet_01v8_hvt[vth] $&@m.xpfet01v8hvt04205sa026.msky130_fd_pr__pfet_01v8_hvt[id]
echo VT pfet_01v8_hvt 0.42 0.5 sa3 $&@m.xpfet01v8hvt04205sa3.msky130_fd_pr__pfet_01v8_hvt[vth] $&@m.xpfet01v8hvt04205sa3.msky130_fd_pr__pfet_01v8_hvt[id]
echo VT pfet_01v8_hvt 0.42 0.5 both $&@m.xpfet01v8hvt04205both.msky130_fd_pr__pfet_01v8_hvt[vth] $&@m.xpfet01v8hvt04205both.msky130_fd_pr__pfet_01v8_hvt[id]
echo VT pfet_01v8_hvt 0.42 0.5 sd $&@m.xpfet01v8hvt04205sd.msky130_fd_pr__pfet_01v8_hvt[vth] $&@m.xpfet01v8hvt04205sd.msky130_fd_pr__pfet_01v8_hvt[id]
echo VT pfet_01v8_hvt 1 0.15 sch $&@m.xpfet01v8hvt1015sch.msky130_fd_pr__pfet_01v8_hvt[vth] $&@m.xpfet01v8hvt1015sch.msky130_fd_pr__pfet_01v8_hvt[id]
echo VT pfet_01v8_hvt 1 0.15 adps $&@m.xpfet01v8hvt1015adps.msky130_fd_pr__pfet_01v8_hvt[vth] $&@m.xpfet01v8hvt1015adps.msky130_fd_pr__pfet_01v8_hvt[id]
echo VT pfet_01v8_hvt 1 0.15 sa03 $&@m.xpfet01v8hvt1015sa03.msky130_fd_pr__pfet_01v8_hvt[vth] $&@m.xpfet01v8hvt1015sa03.msky130_fd_pr__pfet_01v8_hvt[id]
echo VT pfet_01v8_hvt 1 0.15 sa026 $&@m.xpfet01v8hvt1015sa026.msky130_fd_pr__pfet_01v8_hvt[vth] $&@m.xpfet01v8hvt1015sa026.msky130_fd_pr__pfet_01v8_hvt[id]
echo VT pfet_01v8_hvt 1 0.15 sa3 $&@m.xpfet01v8hvt1015sa3.msky130_fd_pr__pfet_01v8_hvt[vth] $&@m.xpfet01v8hvt1015sa3.msky130_fd_pr__pfet_01v8_hvt[id]
echo VT pfet_01v8_hvt 1 0.15 both $&@m.xpfet01v8hvt1015both.msky130_fd_pr__pfet_01v8_hvt[vth] $&@m.xpfet01v8hvt1015both.msky130_fd_pr__pfet_01v8_hvt[id]
echo VT pfet_01v8_hvt 1 0.15 sd $&@m.xpfet01v8hvt1015sd.msky130_fd_pr__pfet_01v8_hvt[vth] $&@m.xpfet01v8hvt1015sd.msky130_fd_pr__pfet_01v8_hvt[id]
echo VT pfet_01v8_hvt 0.42 0.15 sch $&@m.xpfet01v8hvt042015sch.msky130_fd_pr__pfet_01v8_hvt[vth] $&@m.xpfet01v8hvt042015sch.msky130_fd_pr__pfet_01v8_hvt[id]
echo VT pfet_01v8_hvt 0.42 0.15 adps $&@m.xpfet01v8hvt042015adps.msky130_fd_pr__pfet_01v8_hvt[vth] $&@m.xpfet01v8hvt042015adps.msky130_fd_pr__pfet_01v8_hvt[id]
echo VT pfet_01v8_hvt 0.42 0.15 sa03 $&@m.xpfet01v8hvt042015sa03.msky130_fd_pr__pfet_01v8_hvt[vth] $&@m.xpfet01v8hvt042015sa03.msky130_fd_pr__pfet_01v8_hvt[id]
echo VT pfet_01v8_hvt 0.42 0.15 sa026 $&@m.xpfet01v8hvt042015sa026.msky130_fd_pr__pfet_01v8_hvt[vth] $&@m.xpfet01v8hvt042015sa026.msky130_fd_pr__pfet_01v8_hvt[id]
echo VT pfet_01v8_hvt 0.42 0.15 sa3 $&@m.xpfet01v8hvt042015sa3.msky130_fd_pr__pfet_01v8_hvt[vth] $&@m.xpfet01v8hvt042015sa3.msky130_fd_pr__pfet_01v8_hvt[id]
echo VT pfet_01v8_hvt 0.42 0.15 both $&@m.xpfet01v8hvt042015both.msky130_fd_pr__pfet_01v8_hvt[vth] $&@m.xpfet01v8hvt042015both.msky130_fd_pr__pfet_01v8_hvt[id]
echo VT pfet_01v8_hvt 0.42 0.15 sd $&@m.xpfet01v8hvt042015sd.msky130_fd_pr__pfet_01v8_hvt[vth] $&@m.xpfet01v8hvt042015sd.msky130_fd_pr__pfet_01v8_hvt[id]
echo VT pfet_01v8 0.42 0.5 sch $&@m.xpfet01v804205sch.msky130_fd_pr__pfet_01v8[vth] $&@m.xpfet01v804205sch.msky130_fd_pr__pfet_01v8[id]
echo VT pfet_01v8 0.42 0.5 adps $&@m.xpfet01v804205adps.msky130_fd_pr__pfet_01v8[vth] $&@m.xpfet01v804205adps.msky130_fd_pr__pfet_01v8[id]
echo VT pfet_01v8 0.42 0.5 sa03 $&@m.xpfet01v804205sa03.msky130_fd_pr__pfet_01v8[vth] $&@m.xpfet01v804205sa03.msky130_fd_pr__pfet_01v8[id]
echo VT pfet_01v8 0.42 0.5 sa026 $&@m.xpfet01v804205sa026.msky130_fd_pr__pfet_01v8[vth] $&@m.xpfet01v804205sa026.msky130_fd_pr__pfet_01v8[id]
echo VT pfet_01v8 0.42 0.5 sa3 $&@m.xpfet01v804205sa3.msky130_fd_pr__pfet_01v8[vth] $&@m.xpfet01v804205sa3.msky130_fd_pr__pfet_01v8[id]
echo VT pfet_01v8 0.42 0.5 both $&@m.xpfet01v804205both.msky130_fd_pr__pfet_01v8[vth] $&@m.xpfet01v804205both.msky130_fd_pr__pfet_01v8[id]
echo VT pfet_01v8 0.42 0.5 sd $&@m.xpfet01v804205sd.msky130_fd_pr__pfet_01v8[vth] $&@m.xpfet01v804205sd.msky130_fd_pr__pfet_01v8[id]
echo VT pfet_01v8 1 0.15 sch $&@m.xpfet01v81015sch.msky130_fd_pr__pfet_01v8[vth] $&@m.xpfet01v81015sch.msky130_fd_pr__pfet_01v8[id]
echo VT pfet_01v8 1 0.15 adps $&@m.xpfet01v81015adps.msky130_fd_pr__pfet_01v8[vth] $&@m.xpfet01v81015adps.msky130_fd_pr__pfet_01v8[id]
echo VT pfet_01v8 1 0.15 sa03 $&@m.xpfet01v81015sa03.msky130_fd_pr__pfet_01v8[vth] $&@m.xpfet01v81015sa03.msky130_fd_pr__pfet_01v8[id]
echo VT pfet_01v8 1 0.15 sa026 $&@m.xpfet01v81015sa026.msky130_fd_pr__pfet_01v8[vth] $&@m.xpfet01v81015sa026.msky130_fd_pr__pfet_01v8[id]
echo VT pfet_01v8 1 0.15 sa3 $&@m.xpfet01v81015sa3.msky130_fd_pr__pfet_01v8[vth] $&@m.xpfet01v81015sa3.msky130_fd_pr__pfet_01v8[id]
echo VT pfet_01v8 1 0.15 both $&@m.xpfet01v81015both.msky130_fd_pr__pfet_01v8[vth] $&@m.xpfet01v81015both.msky130_fd_pr__pfet_01v8[id]
echo VT pfet_01v8 1 0.15 sd $&@m.xpfet01v81015sd.msky130_fd_pr__pfet_01v8[vth] $&@m.xpfet01v81015sd.msky130_fd_pr__pfet_01v8[id]
echo VT pfet_01v8 0.42 0.15 sch $&@m.xpfet01v8042015sch.msky130_fd_pr__pfet_01v8[vth] $&@m.xpfet01v8042015sch.msky130_fd_pr__pfet_01v8[id]
echo VT pfet_01v8 0.42 0.15 adps $&@m.xpfet01v8042015adps.msky130_fd_pr__pfet_01v8[vth] $&@m.xpfet01v8042015adps.msky130_fd_pr__pfet_01v8[id]
echo VT pfet_01v8 0.42 0.15 sa03 $&@m.xpfet01v8042015sa03.msky130_fd_pr__pfet_01v8[vth] $&@m.xpfet01v8042015sa03.msky130_fd_pr__pfet_01v8[id]
echo VT pfet_01v8 0.42 0.15 sa026 $&@m.xpfet01v8042015sa026.msky130_fd_pr__pfet_01v8[vth] $&@m.xpfet01v8042015sa026.msky130_fd_pr__pfet_01v8[id]
echo VT pfet_01v8 0.42 0.15 sa3 $&@m.xpfet01v8042015sa3.msky130_fd_pr__pfet_01v8[vth] $&@m.xpfet01v8042015sa3.msky130_fd_pr__pfet_01v8[id]
echo VT pfet_01v8 0.42 0.15 both $&@m.xpfet01v8042015both.msky130_fd_pr__pfet_01v8[vth] $&@m.xpfet01v8042015both.msky130_fd_pr__pfet_01v8[id]
echo VT pfet_01v8 0.42 0.15 sd $&@m.xpfet01v8042015sd.msky130_fd_pr__pfet_01v8[vth] $&@m.xpfet01v8042015sd.msky130_fd_pr__pfet_01v8[id]
echo VT nfet_01v8 0.42 0.5 sch $&@m.xnfet01v804205sch.msky130_fd_pr__nfet_01v8[vth] $&@m.xnfet01v804205sch.msky130_fd_pr__nfet_01v8[id]
echo VT nfet_01v8 0.42 0.5 adps $&@m.xnfet01v804205adps.msky130_fd_pr__nfet_01v8[vth] $&@m.xnfet01v804205adps.msky130_fd_pr__nfet_01v8[id]
echo VT nfet_01v8 0.42 0.5 sa03 $&@m.xnfet01v804205sa03.msky130_fd_pr__nfet_01v8[vth] $&@m.xnfet01v804205sa03.msky130_fd_pr__nfet_01v8[id]
echo VT nfet_01v8 0.42 0.5 sa026 $&@m.xnfet01v804205sa026.msky130_fd_pr__nfet_01v8[vth] $&@m.xnfet01v804205sa026.msky130_fd_pr__nfet_01v8[id]
echo VT nfet_01v8 0.42 0.5 sa3 $&@m.xnfet01v804205sa3.msky130_fd_pr__nfet_01v8[vth] $&@m.xnfet01v804205sa3.msky130_fd_pr__nfet_01v8[id]
echo VT nfet_01v8 0.42 0.5 both $&@m.xnfet01v804205both.msky130_fd_pr__nfet_01v8[vth] $&@m.xnfet01v804205both.msky130_fd_pr__nfet_01v8[id]
echo VT nfet_01v8 0.42 0.5 sd $&@m.xnfet01v804205sd.msky130_fd_pr__nfet_01v8[vth] $&@m.xnfet01v804205sd.msky130_fd_pr__nfet_01v8[id]
echo VT nfet_01v8 1 0.15 sch $&@m.xnfet01v81015sch.msky130_fd_pr__nfet_01v8[vth] $&@m.xnfet01v81015sch.msky130_fd_pr__nfet_01v8[id]
echo VT nfet_01v8 1 0.15 adps $&@m.xnfet01v81015adps.msky130_fd_pr__nfet_01v8[vth] $&@m.xnfet01v81015adps.msky130_fd_pr__nfet_01v8[id]
echo VT nfet_01v8 1 0.15 sa03 $&@m.xnfet01v81015sa03.msky130_fd_pr__nfet_01v8[vth] $&@m.xnfet01v81015sa03.msky130_fd_pr__nfet_01v8[id]
echo VT nfet_01v8 1 0.15 sa026 $&@m.xnfet01v81015sa026.msky130_fd_pr__nfet_01v8[vth] $&@m.xnfet01v81015sa026.msky130_fd_pr__nfet_01v8[id]
echo VT nfet_01v8 1 0.15 sa3 $&@m.xnfet01v81015sa3.msky130_fd_pr__nfet_01v8[vth] $&@m.xnfet01v81015sa3.msky130_fd_pr__nfet_01v8[id]
echo VT nfet_01v8 1 0.15 both $&@m.xnfet01v81015both.msky130_fd_pr__nfet_01v8[vth] $&@m.xnfet01v81015both.msky130_fd_pr__nfet_01v8[id]
echo VT nfet_01v8 1 0.15 sd $&@m.xnfet01v81015sd.msky130_fd_pr__nfet_01v8[vth] $&@m.xnfet01v81015sd.msky130_fd_pr__nfet_01v8[id]
echo VT nfet_01v8 0.42 0.15 sch $&@m.xnfet01v8042015sch.msky130_fd_pr__nfet_01v8[vth] $&@m.xnfet01v8042015sch.msky130_fd_pr__nfet_01v8[id]
echo VT nfet_01v8 0.42 0.15 adps $&@m.xnfet01v8042015adps.msky130_fd_pr__nfet_01v8[vth] $&@m.xnfet01v8042015adps.msky130_fd_pr__nfet_01v8[id]
echo VT nfet_01v8 0.42 0.15 sa03 $&@m.xnfet01v8042015sa03.msky130_fd_pr__nfet_01v8[vth] $&@m.xnfet01v8042015sa03.msky130_fd_pr__nfet_01v8[id]
echo VT nfet_01v8 0.42 0.15 sa026 $&@m.xnfet01v8042015sa026.msky130_fd_pr__nfet_01v8[vth] $&@m.xnfet01v8042015sa026.msky130_fd_pr__nfet_01v8[id]
echo VT nfet_01v8 0.42 0.15 sa3 $&@m.xnfet01v8042015sa3.msky130_fd_pr__nfet_01v8[vth] $&@m.xnfet01v8042015sa3.msky130_fd_pr__nfet_01v8[id]
echo VT nfet_01v8 0.42 0.15 both $&@m.xnfet01v8042015both.msky130_fd_pr__nfet_01v8[vth] $&@m.xnfet01v8042015both.msky130_fd_pr__nfet_01v8[id]
echo VT nfet_01v8 0.42 0.15 sd $&@m.xnfet01v8042015sd.msky130_fd_pr__nfet_01v8[vth] $&@m.xnfet01v8042015sd.msky130_fd_pr__nfet_01v8[id]
echo VT pfet_01v8_lvt 0.42 0.5 sch $&@m.xpfet01v8lvt04205sch.msky130_fd_pr__pfet_01v8_lvt[vth] $&@m.xpfet01v8lvt04205sch.msky130_fd_pr__pfet_01v8_lvt[id]
echo VT pfet_01v8_lvt 0.42 0.5 adps $&@m.xpfet01v8lvt04205adps.msky130_fd_pr__pfet_01v8_lvt[vth] $&@m.xpfet01v8lvt04205adps.msky130_fd_pr__pfet_01v8_lvt[id]
echo VT pfet_01v8_lvt 0.42 0.5 sa03 $&@m.xpfet01v8lvt04205sa03.msky130_fd_pr__pfet_01v8_lvt[vth] $&@m.xpfet01v8lvt04205sa03.msky130_fd_pr__pfet_01v8_lvt[id]
echo VT pfet_01v8_lvt 0.42 0.5 sa026 $&@m.xpfet01v8lvt04205sa026.msky130_fd_pr__pfet_01v8_lvt[vth] $&@m.xpfet01v8lvt04205sa026.msky130_fd_pr__pfet_01v8_lvt[id]
echo VT pfet_01v8_lvt 0.42 0.5 sa3 $&@m.xpfet01v8lvt04205sa3.msky130_fd_pr__pfet_01v8_lvt[vth] $&@m.xpfet01v8lvt04205sa3.msky130_fd_pr__pfet_01v8_lvt[id]
echo VT pfet_01v8_lvt 0.42 0.5 both $&@m.xpfet01v8lvt04205both.msky130_fd_pr__pfet_01v8_lvt[vth] $&@m.xpfet01v8lvt04205both.msky130_fd_pr__pfet_01v8_lvt[id]
echo VT pfet_01v8_lvt 0.42 0.5 sd $&@m.xpfet01v8lvt04205sd.msky130_fd_pr__pfet_01v8_lvt[vth] $&@m.xpfet01v8lvt04205sd.msky130_fd_pr__pfet_01v8_lvt[id]
quit
.endc
.end
