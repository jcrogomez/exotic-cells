* Reference for LVS, generated from table 'u128'. Do not edit by hand.
.subckt u128 X VB GND SEL0 SEL1 SEL2 SEL3 SEL4 SEL5 SEL6 SEL7 SEL8 SEL9 SEL10 SEL11 SEL12 SEL13 SEL14 SEL15 SEL16 SEL17 SEL18 SEL19 SEL20 SEL21 SEL22 SEL23 SEL24 SEL25 SEL26 SEL27 SEL28 SEL29 SEL30 SEL31 SEL32 SEL33 SEL34 SEL35 SEL36 SEL37 SEL38 SEL39 SEL40 SEL41 SEL42 SEL43 SEL44 SEL45 SEL46 SEL47 SEL48 SEL49 SEL50 SEL51 SEL52 SEL53 SEL54 SEL55 SEL56 SEL57 SEL58 SEL59 SEL60 SEL61 SEL62 SEL63 SEL64 SEL65 SEL66 SEL67 SEL68 SEL69 SEL70 SEL71 SEL72 SEL73 SEL74 SEL75 SEL76 SEL77 SEL78 SEL79 SEL80 SEL81 SEL82 SEL83 SEL84 SEL85 SEL86 SEL87 SEL88 SEL89 SEL90 SEL91 SEL92 SEL93 SEL94 SEL95 SEL96 SEL97 SEL98 SEL99 SEL100 SEL101 SEL102 SEL103 SEL104 SEL105 SEL106 SEL107 SEL108 SEL109 SEL110 SEL111 SEL112 SEL113 SEL114 SEL115 SEL116 SEL117 SEL118 SEL119 SEL120 SEL121 SEL122 SEL123 SEL124 SEL125 SEL126 SEL127
XD0 X VB s0 GND sky130_fd_pr__nfet_01v8 w=0.42 l=0.15
XS0 s0 SEL0 GND GND sky130_fd_pr__nfet_01v8 w=0.84 l=0.15
XD1 X VB s1 GND sky130_fd_pr__nfet_01v8 w=0.42 l=0.15
XS1 s1 SEL1 GND GND sky130_fd_pr__nfet_01v8 w=0.84 l=0.15
XD2 X VB s2 GND sky130_fd_pr__nfet_01v8 w=0.42 l=0.15
XS2 s2 SEL2 GND GND sky130_fd_pr__nfet_01v8 w=0.84 l=0.15
XD3 X VB s3 GND sky130_fd_pr__nfet_01v8 w=0.42 l=0.15
XS3 s3 SEL3 GND GND sky130_fd_pr__nfet_01v8 w=0.84 l=0.15
XD4 X VB s4 GND sky130_fd_pr__nfet_01v8 w=0.42 l=0.15
XS4 s4 SEL4 GND GND sky130_fd_pr__nfet_01v8 w=0.84 l=0.15
XD5 X VB s5 GND sky130_fd_pr__nfet_01v8 w=0.42 l=0.15
XS5 s5 SEL5 GND GND sky130_fd_pr__nfet_01v8 w=0.84 l=0.15
XD6 X VB s6 GND sky130_fd_pr__nfet_01v8 w=0.42 l=0.15
XS6 s6 SEL6 GND GND sky130_fd_pr__nfet_01v8 w=0.84 l=0.15
XD7 X VB s7 GND sky130_fd_pr__nfet_01v8 w=0.42 l=0.15
XS7 s7 SEL7 GND GND sky130_fd_pr__nfet_01v8 w=0.84 l=0.15
XD8 X VB s8 GND sky130_fd_pr__nfet_01v8 w=0.42 l=0.15
XS8 s8 SEL8 GND GND sky130_fd_pr__nfet_01v8 w=0.84 l=0.15
XD9 X VB s9 GND sky130_fd_pr__nfet_01v8 w=0.42 l=0.15
XS9 s9 SEL9 GND GND sky130_fd_pr__nfet_01v8 w=0.84 l=0.15
XD10 X VB s10 GND sky130_fd_pr__nfet_01v8 w=0.42 l=0.15
XS10 s10 SEL10 GND GND sky130_fd_pr__nfet_01v8 w=0.84 l=0.15
XD11 X VB s11 GND sky130_fd_pr__nfet_01v8 w=0.42 l=0.15
XS11 s11 SEL11 GND GND sky130_fd_pr__nfet_01v8 w=0.84 l=0.15
XD12 X VB s12 GND sky130_fd_pr__nfet_01v8 w=0.42 l=0.15
XS12 s12 SEL12 GND GND sky130_fd_pr__nfet_01v8 w=0.84 l=0.15
XD13 X VB s13 GND sky130_fd_pr__nfet_01v8 w=0.42 l=0.15
XS13 s13 SEL13 GND GND sky130_fd_pr__nfet_01v8 w=0.84 l=0.15
XD14 X VB s14 GND sky130_fd_pr__nfet_01v8 w=0.42 l=0.15
XS14 s14 SEL14 GND GND sky130_fd_pr__nfet_01v8 w=0.84 l=0.15
XD15 X VB s15 GND sky130_fd_pr__nfet_01v8 w=0.42 l=0.15
XS15 s15 SEL15 GND GND sky130_fd_pr__nfet_01v8 w=0.84 l=0.15
XD16 X VB s16 GND sky130_fd_pr__nfet_01v8 w=0.42 l=0.15
XS16 s16 SEL16 GND GND sky130_fd_pr__nfet_01v8 w=0.84 l=0.15
XD17 X VB s17 GND sky130_fd_pr__nfet_01v8 w=0.42 l=0.15
XS17 s17 SEL17 GND GND sky130_fd_pr__nfet_01v8 w=0.84 l=0.15
XD18 X VB s18 GND sky130_fd_pr__nfet_01v8 w=0.42 l=0.15
XS18 s18 SEL18 GND GND sky130_fd_pr__nfet_01v8 w=0.84 l=0.15
XD19 X VB s19 GND sky130_fd_pr__nfet_01v8 w=0.42 l=0.15
XS19 s19 SEL19 GND GND sky130_fd_pr__nfet_01v8 w=0.84 l=0.15
XD20 X VB s20 GND sky130_fd_pr__nfet_01v8 w=0.42 l=0.15
XS20 s20 SEL20 GND GND sky130_fd_pr__nfet_01v8 w=0.84 l=0.15
XD21 X VB s21 GND sky130_fd_pr__nfet_01v8 w=0.42 l=0.15
XS21 s21 SEL21 GND GND sky130_fd_pr__nfet_01v8 w=0.84 l=0.15
XD22 X VB s22 GND sky130_fd_pr__nfet_01v8 w=0.42 l=0.15
XS22 s22 SEL22 GND GND sky130_fd_pr__nfet_01v8 w=0.84 l=0.15
XD23 X VB s23 GND sky130_fd_pr__nfet_01v8 w=0.42 l=0.15
XS23 s23 SEL23 GND GND sky130_fd_pr__nfet_01v8 w=0.84 l=0.15
XD24 X VB s24 GND sky130_fd_pr__nfet_01v8 w=0.42 l=0.15
XS24 s24 SEL24 GND GND sky130_fd_pr__nfet_01v8 w=0.84 l=0.15
XD25 X VB s25 GND sky130_fd_pr__nfet_01v8 w=0.42 l=0.15
XS25 s25 SEL25 GND GND sky130_fd_pr__nfet_01v8 w=0.84 l=0.15
XD26 X VB s26 GND sky130_fd_pr__nfet_01v8 w=0.42 l=0.15
XS26 s26 SEL26 GND GND sky130_fd_pr__nfet_01v8 w=0.84 l=0.15
XD27 X VB s27 GND sky130_fd_pr__nfet_01v8 w=0.42 l=0.15
XS27 s27 SEL27 GND GND sky130_fd_pr__nfet_01v8 w=0.84 l=0.15
XD28 X VB s28 GND sky130_fd_pr__nfet_01v8 w=0.42 l=0.15
XS28 s28 SEL28 GND GND sky130_fd_pr__nfet_01v8 w=0.84 l=0.15
XD29 X VB s29 GND sky130_fd_pr__nfet_01v8 w=0.42 l=0.15
XS29 s29 SEL29 GND GND sky130_fd_pr__nfet_01v8 w=0.84 l=0.15
XD30 X VB s30 GND sky130_fd_pr__nfet_01v8 w=0.42 l=0.15
XS30 s30 SEL30 GND GND sky130_fd_pr__nfet_01v8 w=0.84 l=0.15
XD31 X VB s31 GND sky130_fd_pr__nfet_01v8 w=0.42 l=0.15
XS31 s31 SEL31 GND GND sky130_fd_pr__nfet_01v8 w=0.84 l=0.15
XD32 X VB s32 GND sky130_fd_pr__nfet_01v8 w=0.42 l=0.15
XS32 s32 SEL32 GND GND sky130_fd_pr__nfet_01v8 w=0.84 l=0.15
XD33 X VB s33 GND sky130_fd_pr__nfet_01v8 w=0.42 l=0.15
XS33 s33 SEL33 GND GND sky130_fd_pr__nfet_01v8 w=0.84 l=0.15
XD34 X VB s34 GND sky130_fd_pr__nfet_01v8 w=0.42 l=0.15
XS34 s34 SEL34 GND GND sky130_fd_pr__nfet_01v8 w=0.84 l=0.15
XD35 X VB s35 GND sky130_fd_pr__nfet_01v8 w=0.42 l=0.15
XS35 s35 SEL35 GND GND sky130_fd_pr__nfet_01v8 w=0.84 l=0.15
XD36 X VB s36 GND sky130_fd_pr__nfet_01v8 w=0.42 l=0.15
XS36 s36 SEL36 GND GND sky130_fd_pr__nfet_01v8 w=0.84 l=0.15
XD37 X VB s37 GND sky130_fd_pr__nfet_01v8 w=0.42 l=0.15
XS37 s37 SEL37 GND GND sky130_fd_pr__nfet_01v8 w=0.84 l=0.15
XD38 X VB s38 GND sky130_fd_pr__nfet_01v8 w=0.42 l=0.15
XS38 s38 SEL38 GND GND sky130_fd_pr__nfet_01v8 w=0.84 l=0.15
XD39 X VB s39 GND sky130_fd_pr__nfet_01v8 w=0.42 l=0.15
XS39 s39 SEL39 GND GND sky130_fd_pr__nfet_01v8 w=0.84 l=0.15
XD40 X VB s40 GND sky130_fd_pr__nfet_01v8 w=0.42 l=0.15
XS40 s40 SEL40 GND GND sky130_fd_pr__nfet_01v8 w=0.84 l=0.15
XD41 X VB s41 GND sky130_fd_pr__nfet_01v8 w=0.42 l=0.15
XS41 s41 SEL41 GND GND sky130_fd_pr__nfet_01v8 w=0.84 l=0.15
XD42 X VB s42 GND sky130_fd_pr__nfet_01v8 w=0.42 l=0.15
XS42 s42 SEL42 GND GND sky130_fd_pr__nfet_01v8 w=0.84 l=0.15
XD43 X VB s43 GND sky130_fd_pr__nfet_01v8 w=0.42 l=0.15
XS43 s43 SEL43 GND GND sky130_fd_pr__nfet_01v8 w=0.84 l=0.15
XD44 X VB s44 GND sky130_fd_pr__nfet_01v8 w=0.42 l=0.15
XS44 s44 SEL44 GND GND sky130_fd_pr__nfet_01v8 w=0.84 l=0.15
XD45 X VB s45 GND sky130_fd_pr__nfet_01v8 w=0.42 l=0.15
XS45 s45 SEL45 GND GND sky130_fd_pr__nfet_01v8 w=0.84 l=0.15
XD46 X VB s46 GND sky130_fd_pr__nfet_01v8 w=0.42 l=0.15
XS46 s46 SEL46 GND GND sky130_fd_pr__nfet_01v8 w=0.84 l=0.15
XD47 X VB s47 GND sky130_fd_pr__nfet_01v8 w=0.42 l=0.15
XS47 s47 SEL47 GND GND sky130_fd_pr__nfet_01v8 w=0.84 l=0.15
XD48 X VB s48 GND sky130_fd_pr__nfet_01v8 w=0.42 l=0.15
XS48 s48 SEL48 GND GND sky130_fd_pr__nfet_01v8 w=0.84 l=0.15
XD49 X VB s49 GND sky130_fd_pr__nfet_01v8 w=0.42 l=0.15
XS49 s49 SEL49 GND GND sky130_fd_pr__nfet_01v8 w=0.84 l=0.15
XD50 X VB s50 GND sky130_fd_pr__nfet_01v8 w=0.42 l=0.15
XS50 s50 SEL50 GND GND sky130_fd_pr__nfet_01v8 w=0.84 l=0.15
XD51 X VB s51 GND sky130_fd_pr__nfet_01v8 w=0.42 l=0.15
XS51 s51 SEL51 GND GND sky130_fd_pr__nfet_01v8 w=0.84 l=0.15
XD52 X VB s52 GND sky130_fd_pr__nfet_01v8 w=0.42 l=0.15
XS52 s52 SEL52 GND GND sky130_fd_pr__nfet_01v8 w=0.84 l=0.15
XD53 X VB s53 GND sky130_fd_pr__nfet_01v8 w=0.42 l=0.15
XS53 s53 SEL53 GND GND sky130_fd_pr__nfet_01v8 w=0.84 l=0.15
XD54 X VB s54 GND sky130_fd_pr__nfet_01v8 w=0.42 l=0.15
XS54 s54 SEL54 GND GND sky130_fd_pr__nfet_01v8 w=0.84 l=0.15
XD55 X VB s55 GND sky130_fd_pr__nfet_01v8 w=0.42 l=0.15
XS55 s55 SEL55 GND GND sky130_fd_pr__nfet_01v8 w=0.84 l=0.15
XD56 X VB s56 GND sky130_fd_pr__nfet_01v8 w=0.42 l=0.15
XS56 s56 SEL56 GND GND sky130_fd_pr__nfet_01v8 w=0.84 l=0.15
XD57 X VB s57 GND sky130_fd_pr__nfet_01v8 w=0.42 l=0.15
XS57 s57 SEL57 GND GND sky130_fd_pr__nfet_01v8 w=0.84 l=0.15
XD58 X VB s58 GND sky130_fd_pr__nfet_01v8 w=0.42 l=0.15
XS58 s58 SEL58 GND GND sky130_fd_pr__nfet_01v8 w=0.84 l=0.15
XD59 X VB s59 GND sky130_fd_pr__nfet_01v8 w=0.42 l=0.15
XS59 s59 SEL59 GND GND sky130_fd_pr__nfet_01v8 w=0.84 l=0.15
XD60 X VB s60 GND sky130_fd_pr__nfet_01v8 w=0.42 l=0.15
XS60 s60 SEL60 GND GND sky130_fd_pr__nfet_01v8 w=0.84 l=0.15
XD61 X VB s61 GND sky130_fd_pr__nfet_01v8 w=0.42 l=0.15
XS61 s61 SEL61 GND GND sky130_fd_pr__nfet_01v8 w=0.84 l=0.15
XD62 X VB s62 GND sky130_fd_pr__nfet_01v8 w=0.42 l=0.15
XS62 s62 SEL62 GND GND sky130_fd_pr__nfet_01v8 w=0.84 l=0.15
XD63 X VB s63 GND sky130_fd_pr__nfet_01v8 w=0.42 l=0.15
XS63 s63 SEL63 GND GND sky130_fd_pr__nfet_01v8 w=0.84 l=0.15
XD64 X VB s64 GND sky130_fd_pr__nfet_01v8 w=0.42 l=0.15
XS64 s64 SEL64 GND GND sky130_fd_pr__nfet_01v8 w=0.84 l=0.15
XD65 X VB s65 GND sky130_fd_pr__nfet_01v8 w=0.42 l=0.15
XS65 s65 SEL65 GND GND sky130_fd_pr__nfet_01v8 w=0.84 l=0.15
XD66 X VB s66 GND sky130_fd_pr__nfet_01v8 w=0.42 l=0.15
XS66 s66 SEL66 GND GND sky130_fd_pr__nfet_01v8 w=0.84 l=0.15
XD67 X VB s67 GND sky130_fd_pr__nfet_01v8 w=0.42 l=0.15
XS67 s67 SEL67 GND GND sky130_fd_pr__nfet_01v8 w=0.84 l=0.15
XD68 X VB s68 GND sky130_fd_pr__nfet_01v8 w=0.42 l=0.15
XS68 s68 SEL68 GND GND sky130_fd_pr__nfet_01v8 w=0.84 l=0.15
XD69 X VB s69 GND sky130_fd_pr__nfet_01v8 w=0.42 l=0.15
XS69 s69 SEL69 GND GND sky130_fd_pr__nfet_01v8 w=0.84 l=0.15
XD70 X VB s70 GND sky130_fd_pr__nfet_01v8 w=0.42 l=0.15
XS70 s70 SEL70 GND GND sky130_fd_pr__nfet_01v8 w=0.84 l=0.15
XD71 X VB s71 GND sky130_fd_pr__nfet_01v8 w=0.42 l=0.15
XS71 s71 SEL71 GND GND sky130_fd_pr__nfet_01v8 w=0.84 l=0.15
XD72 X VB s72 GND sky130_fd_pr__nfet_01v8 w=0.42 l=0.15
XS72 s72 SEL72 GND GND sky130_fd_pr__nfet_01v8 w=0.84 l=0.15
XD73 X VB s73 GND sky130_fd_pr__nfet_01v8 w=0.42 l=0.15
XS73 s73 SEL73 GND GND sky130_fd_pr__nfet_01v8 w=0.84 l=0.15
XD74 X VB s74 GND sky130_fd_pr__nfet_01v8 w=0.42 l=0.15
XS74 s74 SEL74 GND GND sky130_fd_pr__nfet_01v8 w=0.84 l=0.15
XD75 X VB s75 GND sky130_fd_pr__nfet_01v8 w=0.42 l=0.15
XS75 s75 SEL75 GND GND sky130_fd_pr__nfet_01v8 w=0.84 l=0.15
XD76 X VB s76 GND sky130_fd_pr__nfet_01v8 w=0.42 l=0.15
XS76 s76 SEL76 GND GND sky130_fd_pr__nfet_01v8 w=0.84 l=0.15
XD77 X VB s77 GND sky130_fd_pr__nfet_01v8 w=0.42 l=0.15
XS77 s77 SEL77 GND GND sky130_fd_pr__nfet_01v8 w=0.84 l=0.15
XD78 X VB s78 GND sky130_fd_pr__nfet_01v8 w=0.42 l=0.15
XS78 s78 SEL78 GND GND sky130_fd_pr__nfet_01v8 w=0.84 l=0.15
XD79 X VB s79 GND sky130_fd_pr__nfet_01v8 w=0.42 l=0.15
XS79 s79 SEL79 GND GND sky130_fd_pr__nfet_01v8 w=0.84 l=0.15
XD80 X VB s80 GND sky130_fd_pr__nfet_01v8 w=0.42 l=0.15
XS80 s80 SEL80 GND GND sky130_fd_pr__nfet_01v8 w=0.84 l=0.15
XD81 X VB s81 GND sky130_fd_pr__nfet_01v8 w=0.42 l=0.15
XS81 s81 SEL81 GND GND sky130_fd_pr__nfet_01v8 w=0.84 l=0.15
XD82 X VB s82 GND sky130_fd_pr__nfet_01v8 w=0.42 l=0.15
XS82 s82 SEL82 GND GND sky130_fd_pr__nfet_01v8 w=0.84 l=0.15
XD83 X VB s83 GND sky130_fd_pr__nfet_01v8 w=0.42 l=0.15
XS83 s83 SEL83 GND GND sky130_fd_pr__nfet_01v8 w=0.84 l=0.15
XD84 X VB s84 GND sky130_fd_pr__nfet_01v8 w=0.42 l=0.15
XS84 s84 SEL84 GND GND sky130_fd_pr__nfet_01v8 w=0.84 l=0.15
XD85 X VB s85 GND sky130_fd_pr__nfet_01v8 w=0.42 l=0.15
XS85 s85 SEL85 GND GND sky130_fd_pr__nfet_01v8 w=0.84 l=0.15
XD86 X VB s86 GND sky130_fd_pr__nfet_01v8 w=0.42 l=0.15
XS86 s86 SEL86 GND GND sky130_fd_pr__nfet_01v8 w=0.84 l=0.15
XD87 X VB s87 GND sky130_fd_pr__nfet_01v8 w=0.42 l=0.15
XS87 s87 SEL87 GND GND sky130_fd_pr__nfet_01v8 w=0.84 l=0.15
XD88 X VB s88 GND sky130_fd_pr__nfet_01v8 w=0.42 l=0.15
XS88 s88 SEL88 GND GND sky130_fd_pr__nfet_01v8 w=0.84 l=0.15
XD89 X VB s89 GND sky130_fd_pr__nfet_01v8 w=0.42 l=0.15
XS89 s89 SEL89 GND GND sky130_fd_pr__nfet_01v8 w=0.84 l=0.15
XD90 X VB s90 GND sky130_fd_pr__nfet_01v8 w=0.42 l=0.15
XS90 s90 SEL90 GND GND sky130_fd_pr__nfet_01v8 w=0.84 l=0.15
XD91 X VB s91 GND sky130_fd_pr__nfet_01v8 w=0.42 l=0.15
XS91 s91 SEL91 GND GND sky130_fd_pr__nfet_01v8 w=0.84 l=0.15
XD92 X VB s92 GND sky130_fd_pr__nfet_01v8 w=0.42 l=0.15
XS92 s92 SEL92 GND GND sky130_fd_pr__nfet_01v8 w=0.84 l=0.15
XD93 X VB s93 GND sky130_fd_pr__nfet_01v8 w=0.42 l=0.15
XS93 s93 SEL93 GND GND sky130_fd_pr__nfet_01v8 w=0.84 l=0.15
XD94 X VB s94 GND sky130_fd_pr__nfet_01v8 w=0.42 l=0.15
XS94 s94 SEL94 GND GND sky130_fd_pr__nfet_01v8 w=0.84 l=0.15
XD95 X VB s95 GND sky130_fd_pr__nfet_01v8 w=0.42 l=0.15
XS95 s95 SEL95 GND GND sky130_fd_pr__nfet_01v8 w=0.84 l=0.15
XD96 X VB s96 GND sky130_fd_pr__nfet_01v8 w=0.42 l=0.15
XS96 s96 SEL96 GND GND sky130_fd_pr__nfet_01v8 w=0.84 l=0.15
XD97 X VB s97 GND sky130_fd_pr__nfet_01v8 w=0.42 l=0.15
XS97 s97 SEL97 GND GND sky130_fd_pr__nfet_01v8 w=0.84 l=0.15
XD98 X VB s98 GND sky130_fd_pr__nfet_01v8 w=0.42 l=0.15
XS98 s98 SEL98 GND GND sky130_fd_pr__nfet_01v8 w=0.84 l=0.15
XD99 X VB s99 GND sky130_fd_pr__nfet_01v8 w=0.42 l=0.15
XS99 s99 SEL99 GND GND sky130_fd_pr__nfet_01v8 w=0.84 l=0.15
XD100 X VB s100 GND sky130_fd_pr__nfet_01v8 w=0.42 l=0.15
XS100 s100 SEL100 GND GND sky130_fd_pr__nfet_01v8 w=0.84 l=0.15
XD101 X VB s101 GND sky130_fd_pr__nfet_01v8 w=0.42 l=0.15
XS101 s101 SEL101 GND GND sky130_fd_pr__nfet_01v8 w=0.84 l=0.15
XD102 X VB s102 GND sky130_fd_pr__nfet_01v8 w=0.42 l=0.15
XS102 s102 SEL102 GND GND sky130_fd_pr__nfet_01v8 w=0.84 l=0.15
XD103 X VB s103 GND sky130_fd_pr__nfet_01v8 w=0.42 l=0.15
XS103 s103 SEL103 GND GND sky130_fd_pr__nfet_01v8 w=0.84 l=0.15
XD104 X VB s104 GND sky130_fd_pr__nfet_01v8 w=0.42 l=0.15
XS104 s104 SEL104 GND GND sky130_fd_pr__nfet_01v8 w=0.84 l=0.15
XD105 X VB s105 GND sky130_fd_pr__nfet_01v8 w=0.42 l=0.15
XS105 s105 SEL105 GND GND sky130_fd_pr__nfet_01v8 w=0.84 l=0.15
XD106 X VB s106 GND sky130_fd_pr__nfet_01v8 w=0.42 l=0.15
XS106 s106 SEL106 GND GND sky130_fd_pr__nfet_01v8 w=0.84 l=0.15
XD107 X VB s107 GND sky130_fd_pr__nfet_01v8 w=0.42 l=0.15
XS107 s107 SEL107 GND GND sky130_fd_pr__nfet_01v8 w=0.84 l=0.15
XD108 X VB s108 GND sky130_fd_pr__nfet_01v8 w=0.42 l=0.15
XS108 s108 SEL108 GND GND sky130_fd_pr__nfet_01v8 w=0.84 l=0.15
XD109 X VB s109 GND sky130_fd_pr__nfet_01v8 w=0.42 l=0.15
XS109 s109 SEL109 GND GND sky130_fd_pr__nfet_01v8 w=0.84 l=0.15
XD110 X VB s110 GND sky130_fd_pr__nfet_01v8 w=0.42 l=0.15
XS110 s110 SEL110 GND GND sky130_fd_pr__nfet_01v8 w=0.84 l=0.15
XD111 X VB s111 GND sky130_fd_pr__nfet_01v8 w=0.42 l=0.15
XS111 s111 SEL111 GND GND sky130_fd_pr__nfet_01v8 w=0.84 l=0.15
XD112 X VB s112 GND sky130_fd_pr__nfet_01v8 w=0.42 l=0.15
XS112 s112 SEL112 GND GND sky130_fd_pr__nfet_01v8 w=0.84 l=0.15
XD113 X VB s113 GND sky130_fd_pr__nfet_01v8 w=0.42 l=0.15
XS113 s113 SEL113 GND GND sky130_fd_pr__nfet_01v8 w=0.84 l=0.15
XD114 X VB s114 GND sky130_fd_pr__nfet_01v8 w=0.42 l=0.15
XS114 s114 SEL114 GND GND sky130_fd_pr__nfet_01v8 w=0.84 l=0.15
XD115 X VB s115 GND sky130_fd_pr__nfet_01v8 w=0.42 l=0.15
XS115 s115 SEL115 GND GND sky130_fd_pr__nfet_01v8 w=0.84 l=0.15
XD116 X VB s116 GND sky130_fd_pr__nfet_01v8 w=0.42 l=0.15
XS116 s116 SEL116 GND GND sky130_fd_pr__nfet_01v8 w=0.84 l=0.15
XD117 X VB s117 GND sky130_fd_pr__nfet_01v8 w=0.42 l=0.15
XS117 s117 SEL117 GND GND sky130_fd_pr__nfet_01v8 w=0.84 l=0.15
XD118 X VB s118 GND sky130_fd_pr__nfet_01v8 w=0.42 l=0.15
XS118 s118 SEL118 GND GND sky130_fd_pr__nfet_01v8 w=0.84 l=0.15
XD119 X VB s119 GND sky130_fd_pr__nfet_01v8 w=0.42 l=0.15
XS119 s119 SEL119 GND GND sky130_fd_pr__nfet_01v8 w=0.84 l=0.15
XD120 X VB s120 GND sky130_fd_pr__nfet_01v8 w=0.42 l=0.15
XS120 s120 SEL120 GND GND sky130_fd_pr__nfet_01v8 w=0.84 l=0.15
XD121 X VB s121 GND sky130_fd_pr__nfet_01v8 w=0.42 l=0.15
XS121 s121 SEL121 GND GND sky130_fd_pr__nfet_01v8 w=0.84 l=0.15
XD122 X VB s122 GND sky130_fd_pr__nfet_01v8 w=0.42 l=0.15
XS122 s122 SEL122 GND GND sky130_fd_pr__nfet_01v8 w=0.84 l=0.15
XD123 X VB s123 GND sky130_fd_pr__nfet_01v8 w=0.42 l=0.15
XS123 s123 SEL123 GND GND sky130_fd_pr__nfet_01v8 w=0.84 l=0.15
XD124 X VB s124 GND sky130_fd_pr__nfet_01v8 w=0.42 l=0.15
XS124 s124 SEL124 GND GND sky130_fd_pr__nfet_01v8 w=0.84 l=0.15
XD125 X VB s125 GND sky130_fd_pr__nfet_01v8 w=0.42 l=0.15
XS125 s125 SEL125 GND GND sky130_fd_pr__nfet_01v8 w=0.84 l=0.15
XD126 X VB s126 GND sky130_fd_pr__nfet_01v8 w=0.42 l=0.15
XS126 s126 SEL126 GND GND sky130_fd_pr__nfet_01v8 w=0.84 l=0.15
XD127 X VB s127 GND sky130_fd_pr__nfet_01v8 w=0.42 l=0.15
XS127 s127 SEL127 GND GND sky130_fd_pr__nfet_01v8 w=0.84 l=0.15
.ends
