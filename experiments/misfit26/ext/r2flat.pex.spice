* NGSPICE file created from r2flat.ext - technology: sky130A

.subckt r2flat VGND VPWR en pre prenh prenl src[0] src[1] x xa xb
X0 VGND VPWR VGND VGND sky130_fd_pr__nfet_01v8 ad=0.143 pd=1.62 as=104.97485 ps=1.13919k w=0.55 l=0.59
X1 VPWR VGND VPWR VPWR sky130_fd_pr__pfet_01v8_hvt ad=0.2262 pd=2.26 as=158.19749 ps=1.56884k w=0.87 l=0.59
X2 a_7903_7497# a_7387_7125# a_7808_7485# VGND sky130_fd_pr__special_nfet_01v8 ad=0.0594 pd=0.69 as=0.066 ps=0.745 w=0.36 l=0.15
X3 VGND _28_.A _28_.Y VGND sky130_fd_pr__nfet_01v8 ad=0.169 pd=1.82 as=0.08775 ps=0.92 w=0.65 l=0.15
X4 a_8577_5321# a_7387_4949# a_8468_5321# VGND sky130_fd_pr__special_nfet_01v8 ad=0.0669 pd=0.75 as=0.0711 ps=0.755 w=0.36 l=0.15
X5 VPWR VGND VPWR VPWR sky130_fd_pr__pfet_01v8_hvt ad=0.2262 pd=2.26 as=0 ps=0 w=0.87 l=0.59
X6 VGND VPWR VGND VGND sky130_fd_pr__nfet_01v8 ad=0.143 pd=1.62 as=0 ps=0 w=0.55 l=0.59
X7 VPWR pre _20_.Y VPWR sky130_fd_pr__pfet_01v8_hvt ad=0.26 pd=2.52 as=0.135 ps=1.27 w=1 l=0.15
X8 _28_.A a_3491_5247# VGND VGND sky130_fd_pr__nfet_01v8 ad=0.08775 pd=0.92 as=0.2087 ps=2.02 w=0.65 l=0.15
X9 VPWR VGND VPWR VPWR sky130_fd_pr__pfet_01v8_hvt ad=0.2262 pd=2.26 as=0 ps=0 w=0.87 l=0.59
X10 _42_.Y _55_.Q VPWR VPWR sky130_fd_pr__pfet_01v8_hvt ad=0.135 pd=1.27 as=0.26 ps=2.52 w=1 l=0.15
X11 VPWR VGND VPWR VPWR sky130_fd_pr__pfet_01v8_hvt ad=0.2262 pd=2.26 as=0 ps=0 w=0.87 l=0.59
X12 VGND a_1499_6575# u_loop.u_gh.C VGND sky130_fd_pr__nfet_01v8 ad=0.23075 pd=2.01 as=0.091 ps=0.93 w=0.65 l=0.15
X13 a_2905_4399# a_2526_4765# a_2833_4399# VGND sky130_fd_pr__nfet_01v8 ad=0.1401 pd=1.1 as=0.0441 ps=0.63 w=0.42 l=0.15
X14 VGND _45_.A a_5377_7439# VGND sky130_fd_pr__nfet_01v8 ad=0.08775 pd=0.92 as=0.08775 ps=0.92 w=0.65 l=0.15
X15 a_7999_5321# a_7553_4949# a_7903_5321# VGND sky130_fd_pr__special_nfet_01v8 ad=0.1401 pd=1.1 as=0.0594 ps=0.69 w=0.36 l=0.15
X16 VPWR VGND VPWR VPWR sky130_fd_pr__pfet_01v8_hvt ad=0.2262 pd=2.26 as=0 ps=0 w=0.87 l=0.59
X17 VGND _25_.A _25_.Y VGND sky130_fd_pr__nfet_01v8 ad=0.169 pd=1.82 as=0.08775 ps=0.92 w=0.65 l=0.15
X18 a_2397_4399# a_1835_4373# VGND VGND sky130_fd_pr__nfet_01v8 ad=0.0669 pd=0.75 as=0.12495 ps=1.015 w=0.42 l=0.15
X19 VPWR VGND VPWR VPWR sky130_fd_pr__pfet_01v8_hvt ad=0.2262 pd=2.26 as=0 ps=0 w=0.87 l=0.59
X20 a_4867_9673# a_4351_9301# a_4772_9661# VGND sky130_fd_pr__special_nfet_01v8 ad=0.0594 pd=0.69 as=0.066 ps=0.745 w=0.36 l=0.15
X21 VPWR VGND VPWR VPWR sky130_fd_pr__pfet_01v8_hvt ad=0.2262 pd=2.26 as=0 ps=0 w=0.87 l=0.59
X22 _20_.Y pre VGND VGND sky130_fd_pr__nfet_01v8 ad=0.08775 pd=0.92 as=0.169 ps=1.82 w=0.65 l=0.15
X23 VGND VPWR VGND VGND sky130_fd_pr__nfet_01v8 ad=0.143 pd=1.62 as=0 ps=0 w=0.55 l=0.59
X24 a_5805_2767# a_5569_2767# VPWR VPWR sky130_fd_pr__pfet_01v8_hvt ad=0.1092 pd=1.36 as=0.0567 ps=0.69 w=0.42 l=0.5
X25 VPWR a_5085_9269# a_4975_9295# VPWR sky130_fd_pr__pfet_01v8_hvt ad=0.07035 pd=0.755 as=0.1155 ps=0.97 w=0.42 l=0.15
X26 VPWR VGND VPWR VPWR sky130_fd_pr__pfet_01v8_hvt ad=0.2262 pd=2.26 as=0 ps=0 w=0.87 l=0.59
X27 VPWR VGND VPWR VPWR sky130_fd_pr__pfet_01v8_hvt ad=0.2262 pd=2.26 as=0 ps=0 w=0.87 l=0.59
X28 u_loop.u_d6.X a_5911_2767# VPWR VPWR sky130_fd_pr__pfet_01v8_hvt ad=0.26 pd=2.52 as=0.14075 ps=1.325 w=1 l=0.15
X29 a_7553_4949# a_7387_4949# VGND VGND sky130_fd_pr__nfet_01v8 ad=0.1092 pd=1.36 as=0.0567 ps=0.69 w=0.42 l=0.15
X30 _53_.Y _53_.A VGND VGND sky130_fd_pr__nfet_01v8 ad=0.08775 pd=0.92 as=0.169 ps=1.82 w=0.65 l=0.15
X31 a_2755_7637# a_2580_7663# a_2934_7663# VGND sky130_fd_pr__nfet_01v8 ad=0.1092 pd=1.36 as=0.06405 ps=0.725 w=0.42 l=0.15
X32 VPWR VGND VPWR VPWR sky130_fd_pr__pfet_01v8_hvt ad=0.2262 pd=2.26 as=0 ps=0 w=0.87 l=0.59
X33 a_6557_8993# a_6339_8751# VGND VGND sky130_fd_pr__nfet_01v8 ad=0.0999 pd=0.985 as=0.1346 ps=1.15 w=0.64 l=0.15
X34 a_6633_2767# a_6397_2767# VPWR VPWR sky130_fd_pr__pfet_01v8_hvt ad=0.1092 pd=1.36 as=0.0567 ps=0.69 w=0.42 l=0.5
X35 VGND VPWR VGND VGND sky130_fd_pr__nfet_01v8 ad=0.143 pd=1.62 as=0 ps=0 w=0.55 l=0.59
X36 a_3578_6397# u_loop.u_gh.C VGND VGND sky130_fd_pr__nfet_01v8 ad=0.06405 pd=0.725 as=0.12495 ps=1.015 w=0.42 l=0.15
X37 a_7810_6397# u_loop.u_gh.C VGND VGND sky130_fd_pr__nfet_01v8 ad=0.06405 pd=0.725 as=0.12495 ps=1.015 w=0.42 l=0.15
X38 VPWR VGND VPWR VPWR sky130_fd_pr__pfet_01v8_hvt ad=0.2262 pd=2.26 as=0 ps=0 w=0.87 l=0.59
X39 VPWR VGND VPWR VPWR sky130_fd_pr__pfet_01v8_hvt ad=0.2262 pd=2.26 as=0 ps=0 w=0.87 l=0.59
X40 VGND VPWR VGND VGND sky130_fd_pr__nfet_01v8 ad=0.143 pd=1.62 as=0 ps=0 w=0.55 l=0.59
X41 VGND VPWR VGND VGND sky130_fd_pr__nfet_01v8 ad=0.143 pd=1.62 as=0 ps=0 w=0.55 l=0.59
X42 a_2861_2767# a_2625_2767# VGND VGND sky130_fd_pr__nfet_01v8 ad=0.1092 pd=1.36 as=0.0567 ps=0.69 w=0.42 l=0.5
X43 prenl u_loop.u_gl.B1 VGND VGND sky130_fd_pr__nfet_01v8 ad=0.091 pd=0.93 as=0.17225 ps=1.83 w=0.65 l=0.15
X44 VGND VPWR VGND VGND sky130_fd_pr__nfet_01v8 ad=0.143 pd=1.62 as=0 ps=0 w=0.55 l=0.59
X45 VPWR VGND VPWR VPWR sky130_fd_pr__pfet_01v8_hvt ad=0.2262 pd=2.26 as=0 ps=0 w=0.87 l=0.59
X46 VPWR _40_.B _49_.Y VPWR sky130_fd_pr__pfet_01v8_hvt ad=0.26 pd=2.52 as=0.135 ps=1.27 w=1 l=0.15
X47 VGND VPWR VGND VGND sky130_fd_pr__nfet_01v8 ad=0.143 pd=1.62 as=0 ps=0 w=0.55 l=0.59
X48 VPWR VGND VPWR VPWR sky130_fd_pr__pfet_01v8_hvt ad=0.2262 pd=2.26 as=0 ps=0 w=0.87 l=0.59
X49 VPWR a_8468_7497# a_8643_7423# VPWR sky130_fd_pr__pfet_01v8_hvt ad=0.1134 pd=1.38 as=0.0567 ps=0.69 w=0.42 l=0.15
X50 VPWR _28_.A _52_.Y VPWR sky130_fd_pr__pfet_01v8_hvt ad=0.26 pd=2.52 as=0.135 ps=1.27 w=1 l=0.15
X51 _62_.D _40_.B VGND VGND sky130_fd_pr__nfet_01v8 ad=0.08775 pd=0.92 as=0.169 ps=1.82 w=0.65 l=0.15
X52 _21_.Y _39_.B2 VGND VGND sky130_fd_pr__nfet_01v8 ad=0.08775 pd=0.92 as=0.169 ps=1.82 w=0.65 l=0.15
X53 VGND u_loop.u_gh.C a_8165_7485# VGND sky130_fd_pr__nfet_01v8 ad=0.1346 pd=1.15 as=0.0441 ps=0.63 w=0.42 l=0.15
X54 _57_.CLK _45_.A VPWR VPWR sky130_fd_pr__pfet_01v8_hvt ad=0.135 pd=1.27 as=0.26 ps=2.52 w=1 l=0.15
X55 VPWR VGND VPWR VPWR sky130_fd_pr__pfet_01v8_hvt ad=0.2262 pd=2.26 as=0 ps=0 w=0.87 l=0.59
X56 u_loop.u_d3.X a_3703_2767# VGND VGND sky130_fd_pr__nfet_01v8 ad=0.169 pd=1.82 as=0.097 ps=0.975 w=0.65 l=0.15
X57 a_4769_4175# u_loop.u_gh.B a_4351_4175# VGND sky130_fd_pr__nfet_01v8 ad=0.08775 pd=0.92 as=0.08775 ps=0.92 w=0.65 l=0.15
X58 VPWR src[0] a_4075_6825# VPWR sky130_fd_pr__pfet_01v8_hvt ad=0.135 pd=1.27 as=0.275 ps=2.55 w=1 l=0.15
X59 VGND a_3491_5247# a_3425_5321# VGND sky130_fd_pr__nfet_01v8 ad=0.12495 pd=1.015 as=0.0669 ps=0.75 w=0.42 l=0.15
X60 VPWR VGND VPWR VPWR sky130_fd_pr__pfet_01v8_hvt ad=0.2262 pd=2.26 as=0 ps=0 w=0.87 l=0.59
X61 VGND VPWR VGND VGND sky130_fd_pr__nfet_01v8 ad=0.143 pd=1.62 as=0 ps=0 w=0.55 l=0.59
X62 VGND VPWR VGND VGND sky130_fd_pr__nfet_01v8 ad=0.143 pd=1.62 as=0 ps=0 w=0.55 l=0.59
X63 a_6799_7663# a_6283_7663# a_6704_7663# VGND sky130_fd_pr__special_nfet_01v8 ad=0.0594 pd=0.69 as=0.066 ps=0.745 w=0.36 l=0.15
X64 VGND a_5190_5487# _41_.X VGND sky130_fd_pr__nfet_01v8 ad=0.169 pd=1.82 as=0.08775 ps=0.92 w=0.65 l=0.15
X65 a_3348_7235# _64_.Q VGND VGND sky130_fd_pr__nfet_01v8 ad=0.0567 pd=0.69 as=0.0567 ps=0.69 w=0.42 l=0.15
X66 VGND src[1] a_3992_7235# VGND sky130_fd_pr__nfet_01v8 ad=0.10187 pd=0.99 as=0.0567 ps=0.69 w=0.42 l=0.15
X67 VPWR VGND VPWR VPWR sky130_fd_pr__pfet_01v8_hvt ad=0.2262 pd=2.26 as=0 ps=0 w=0.87 l=0.59
X68 VGND VPWR VGND VGND sky130_fd_pr__nfet_01v8 ad=0.143 pd=1.62 as=0 ps=0 w=0.55 l=0.59
X69 VPWR VGND VPWR VPWR sky130_fd_pr__pfet_01v8_hvt ad=0.2262 pd=2.26 as=0 ps=0 w=0.87 l=0.59
X70 VPWR a_3684_8585# a_3859_8511# VPWR sky130_fd_pr__pfet_01v8_hvt ad=0.1134 pd=1.38 as=0.0567 ps=0.69 w=0.42 l=0.15
X71 _55_.CLK _56_.Q VGND VGND sky130_fd_pr__nfet_01v8 ad=0.08775 pd=0.92 as=0.169 ps=1.82 w=0.65 l=0.15
X72 u_loop.u_d0.X a_2231_2767# VPWR VPWR sky130_fd_pr__pfet_01v8_hvt ad=0.26 pd=2.52 as=0.14075 ps=1.325 w=1 l=0.15
X73 VPWR _45_.A _22_.Y VPWR sky130_fd_pr__pfet_01v8_hvt ad=0.26 pd=2.52 as=0.135 ps=1.27 w=1 l=0.15
X74 a_1499_6575# en VPWR VPWR sky130_fd_pr__pfet_01v8_hvt ad=0.3675 pd=1.735 as=0.14 ps=1.28 w=1 l=0.15
X75 VPWR _55_.CLK a_6651_3861# VPWR sky130_fd_pr__pfet_01v8_hvt ad=0.0864 pd=0.91 as=0.1664 ps=1.8 w=0.64 l=0.15
X76 VGND VPWR VGND VGND sky130_fd_pr__nfet_01v8 ad=0.143 pd=1.62 as=0 ps=0 w=0.55 l=0.59
X77 VGND VPWR VGND VGND sky130_fd_pr__nfet_01v8 ad=0.143 pd=1.62 as=0 ps=0 w=0.55 l=0.59
X78 VPWR a_7539_7637# a_7526_8029# VPWR sky130_fd_pr__pfet_01v8_hvt ad=0.0819 pd=0.81 as=0.0567 ps=0.69 w=0.42 l=0.15
X79 a_8121_7093# a_7903_7497# VPWR VPWR sky130_fd_pr__pfet_01v8_hvt ad=0.12915 pd=1.185 as=0.2184 ps=2.2 w=0.84 l=0.15
X80 a_7618_6031# a_6541_6037# a_7456_6409# VPWR sky130_fd_pr__pfet_01v8_hvt ad=0.0567 pd=0.69 as=0.0588 ps=0.7 w=0.42 l=0.15
X81 VGND VPWR VGND VGND sky130_fd_pr__nfet_01v8 ad=0.143 pd=1.62 as=0 ps=0 w=0.55 l=0.59
X82 VGND _39_.B2 _47_.Y VGND sky130_fd_pr__nfet_01v8 ad=0.169 pd=1.82 as=0.08775 ps=0.92 w=0.65 l=0.15
X83 _50_.Y _63_.Q VPWR VPWR sky130_fd_pr__pfet_01v8_hvt ad=0.135 pd=1.27 as=0.26 ps=2.52 w=1 l=0.15
X84 VPWR u_loop.u_gh.B prenh VPWR sky130_fd_pr__pfet_01v8_hvt ad=0.135 pd=1.27 as=0.135 ps=1.27 w=1 l=0.15
X85 a_7017_7905# a_6799_7663# VGND VGND sky130_fd_pr__nfet_01v8 ad=0.0999 pd=0.985 as=0.1346 ps=1.15 w=0.64 l=0.15
X86 u_loop.u_d5.X a_5175_2767# VPWR VPWR sky130_fd_pr__pfet_01v8_hvt ad=0.26 pd=2.52 as=0.14075 ps=1.325 w=1 l=0.15
X87 a_6447_9117# u_loop.u_gh.C VPWR VPWR sky130_fd_pr__pfet_01v8_hvt ad=0.1092 pd=1.36 as=0.07035 ps=0.755 w=0.42 l=0.15
X88 VPWR u_loop.u_d0.X a_2533_2223# VPWR sky130_fd_pr__pfet_01v8_hvt ad=0.0567 pd=0.69 as=0.1092 ps=1.36 w=0.42 l=0.15
X89 a_6904_8751# a_5989_8751# a_6557_8993# VGND sky130_fd_pr__special_nfet_01v8 ad=0.0711 pd=0.755 as=0.0999 ps=0.985 w=0.36 l=0.15
X90 VGND VPWR VGND VGND sky130_fd_pr__nfet_01v8 ad=0.143 pd=1.62 as=0 ps=0 w=0.55 l=0.59
X91 VPWR u_loop.u_d0.A a_4076_3561# VPWR sky130_fd_pr__pfet_01v8_hvt ad=0.14 pd=1.28 as=0.14 ps=1.28 w=1 l=0.15
X92 _41_.B1 src[1] a_4518_6575# VGND sky130_fd_pr__nfet_01v8 ad=0.10563 pd=0.975 as=0.08775 ps=0.92 w=0.65 l=0.15
X93 VGND VPWR VGND VGND sky130_fd_pr__nfet_01v8 ad=0.143 pd=1.62 as=0 ps=0 w=0.55 l=0.59
X94 a_5432_9673# a_4517_9301# a_5085_9269# VGND sky130_fd_pr__special_nfet_01v8 ad=0.0711 pd=0.755 as=0.0999 ps=0.985 w=0.36 l=0.15
X95 a_8468_7497# a_7387_7125# a_8121_7093# VPWR sky130_fd_pr__pfet_01v8_hvt ad=0.0588 pd=0.7 as=0.12915 ps=1.185 w=0.42 l=0.15
X96 a_6541_6037# a_6375_6037# VPWR VPWR sky130_fd_pr__pfet_01v8_hvt ad=0.1664 pd=1.8 as=0.0864 ps=0.91 w=0.64 l=0.15
X97 VGND src[1] a_4160_6575# VGND sky130_fd_pr__nfet_01v8 ad=0.169 pd=1.82 as=0.08775 ps=0.92 w=0.65 l=0.15
X98 a_7348_5487# _67_.D VGND VGND sky130_fd_pr__nfet_01v8 ad=0.066 pd=0.745 as=0.2205 ps=1.89 w=0.42 l=0.15
X99 a_7167_4233# a_6651_3861# a_7072_4221# VGND sky130_fd_pr__special_nfet_01v8 ad=0.0594 pd=0.69 as=0.066 ps=0.745 w=0.36 l=0.15
X100 VGND a_2439_4541# a_2400_4667# VGND sky130_fd_pr__nfet_01v8 ad=0.0567 pd=0.69 as=0.1092 ps=1.36 w=0.42 l=0.15
X101 VGND VPWR VGND VGND sky130_fd_pr__nfet_01v8 ad=0.143 pd=1.62 as=0 ps=0 w=0.55 l=0.59
X102 VPWR VGND VPWR VPWR sky130_fd_pr__pfet_01v8_hvt ad=0.2262 pd=2.26 as=0 ps=0 w=0.87 l=0.59
X103 VPWR _32_.A _32_.Y VPWR sky130_fd_pr__pfet_01v8_hvt ad=0.26 pd=2.52 as=0.135 ps=1.27 w=1 l=0.15
X104 a_4076_3561# u_loop.u_d0.A VPWR VPWR sky130_fd_pr__pfet_01v8_hvt ad=0.14 pd=1.28 as=0.145 ps=1.29 w=1 l=0.15
X105 VPWR VGND VPWR VPWR sky130_fd_pr__pfet_01v8_hvt ad=0.2262 pd=2.26 as=0 ps=0 w=0.87 l=0.59
X106 VGND a_8643_5247# a_8577_5321# VGND sky130_fd_pr__nfet_01v8 ad=0.12495 pd=1.015 as=0.0669 ps=0.75 w=0.42 l=0.15
X107 a_5529_4399# a_5363_4399# VGND VGND sky130_fd_pr__nfet_01v8 ad=0.1092 pd=1.36 as=0.0567 ps=0.69 w=0.42 l=0.15
X108 a_3491_5247# u_loop.u_gh.C VPWR VPWR sky130_fd_pr__pfet_01v8_hvt ad=0.0567 pd=0.69 as=0.0819 ps=0.81 w=0.42 l=0.15
X109 a_8165_5309# a_8121_4917# a_7999_5321# VGND sky130_fd_pr__nfet_01v8 ad=0.0441 pd=0.63 as=0.1401 ps=1.1 w=0.42 l=0.15
X110 a_4517_9301# a_4351_9301# VGND VGND sky130_fd_pr__nfet_01v8 ad=0.1092 pd=1.36 as=0.0567 ps=0.69 w=0.42 l=0.15
X111 VGND VPWR VGND VGND sky130_fd_pr__nfet_01v8 ad=0.143 pd=1.62 as=0 ps=0 w=0.55 l=0.59
X112 a_4369_6351# a_4167_6147# _36_.A VGND sky130_fd_pr__nfet_01v8 ad=0.08775 pd=0.92 as=0.08775 ps=0.92 w=0.65 l=0.15
X113 VGND a_2861_2767# a_2967_2767# VGND sky130_fd_pr__nfet_01v8 ad=0.097 pd=0.975 as=0.1092 ps=1.36 w=0.42 l=0.5
X114 VPWR VGND VPWR VPWR sky130_fd_pr__pfet_01v8_hvt ad=0.2262 pd=2.26 as=0 ps=0 w=0.87 l=0.59
X115 VPWR VGND VPWR VPWR sky130_fd_pr__pfet_01v8_hvt ad=0.2262 pd=2.26 as=0 ps=0 w=0.87 l=0.59
X116 u_loop.u_d0.A u_loop.u_q.B VGND VGND sky130_fd_pr__nfet_01v8 ad=0.08775 pd=0.92 as=0.169 ps=1.82 w=0.65 l=0.15
X117 a_6339_8751# a_5823_8751# a_6244_8751# VGND sky130_fd_pr__special_nfet_01v8 ad=0.0594 pd=0.69 as=0.066 ps=0.745 w=0.36 l=0.15
X118 VGND _46_.A _46_.Y VGND sky130_fd_pr__nfet_01v8 ad=0.169 pd=1.82 as=0.08775 ps=0.92 w=0.65 l=0.15
X119 VGND _63_.Q _63_.D VGND sky130_fd_pr__nfet_01v8 ad=0.169 pd=1.82 as=0.08775 ps=0.92 w=0.65 l=0.15
X120 a_6907_8029# u_loop.u_gh.C VPWR VPWR sky130_fd_pr__pfet_01v8_hvt ad=0.1092 pd=1.36 as=0.07035 ps=0.755 w=0.42 l=0.15
X121 VGND a_4160_6575# _41_.B1 VGND sky130_fd_pr__nfet_01v8 ad=0.169 pd=1.82 as=0.08775 ps=0.92 w=0.65 l=0.15
X122 VPWR a_1835_4373# _53_.A VPWR sky130_fd_pr__pfet_01v8_hvt ad=0.3012 pd=2.66 as=0.135 ps=1.27 w=1 l=0.15
X123 a_7364_7663# a_6449_7663# a_7017_7905# VGND sky130_fd_pr__special_nfet_01v8 ad=0.0711 pd=0.755 as=0.0999 ps=0.985 w=0.36 l=0.15
X124 VGND VPWR VGND VGND sky130_fd_pr__nfet_01v8 ad=0.143 pd=1.62 as=0 ps=0 w=0.55 l=0.59
X125 VGND VPWR VGND VGND sky130_fd_pr__nfet_01v8 ad=0.143 pd=1.62 as=0 ps=0 w=0.55 l=0.59
X126 a_7551_5853# u_loop.u_gh.C VPWR VPWR sky130_fd_pr__pfet_01v8_hvt ad=0.1092 pd=1.36 as=0.07035 ps=0.755 w=0.42 l=0.15
X127 VGND VPWR VGND VGND sky130_fd_pr__nfet_01v8 ad=0.143 pd=1.62 as=0 ps=0 w=0.55 l=0.59
X128 VGND VPWR VGND VGND sky130_fd_pr__nfet_01v8 ad=0.143 pd=1.62 as=0 ps=0 w=0.55 l=0.59
X129 a_4867_9673# a_4517_9301# a_4772_9661# VPWR sky130_fd_pr__pfet_01v8_hvt ad=0.07245 pd=0.765 as=0.0651 ps=0.73 w=0.42 l=0.15
X130 a_4518_6575# src[1] _41_.B1 VGND sky130_fd_pr__nfet_01v8 ad=0.169 pd=1.82 as=0.10563 ps=0.975 w=0.65 l=0.15
X131 VPWR VGND VPWR VPWR sky130_fd_pr__pfet_01v8_hvt ad=0.2262 pd=2.26 as=0 ps=0 w=0.87 l=0.59
X132 VPWR _30_.Y a_3802_9295# VPWR sky130_fd_pr__pfet_01v8_hvt ad=0.1092 pd=1.36 as=0.0651 ps=0.73 w=0.42 l=0.15
X133 VPWR a_7079_8725# a_7066_9117# VPWR sky130_fd_pr__pfet_01v8_hvt ad=0.0819 pd=0.81 as=0.0567 ps=0.69 w=0.42 l=0.15
X134 VGND VPWR VGND VGND sky130_fd_pr__nfet_01v8 ad=0.143 pd=1.62 as=0 ps=0 w=0.55 l=0.59
X135 a_3491_5247# a_3316_5321# a_3670_5309# VGND sky130_fd_pr__nfet_01v8 ad=0.1092 pd=1.36 as=0.06405 ps=0.725 w=0.42 l=0.15
X136 VGND VPWR VGND VGND sky130_fd_pr__nfet_01v8 ad=0.143 pd=1.62 as=0 ps=0 w=0.55 l=0.59
X137 u_loop.u_q.B u_loop.u_d0.A a_6381_3561# VPWR sky130_fd_pr__pfet_01v8_hvt ad=0.26 pd=2.52 as=0.105 ps=1.21 w=1 l=0.15
X138 _30_.Y _30_.A VPWR VPWR sky130_fd_pr__pfet_01v8_hvt ad=0.135 pd=1.27 as=0.26 ps=2.52 w=1 l=0.15
X139 VGND VPWR VGND VGND sky130_fd_pr__nfet_01v8 ad=0.143 pd=1.62 as=0 ps=0 w=0.55 l=0.59
X140 VGND u_loop.u_gl.B1 prenl VGND sky130_fd_pr__nfet_01v8 ad=0.091 pd=0.93 as=0.091 ps=0.93 w=0.65 l=0.15
X141 VPWR VGND VPWR VPWR sky130_fd_pr__pfet_01v8_hvt ad=0.2262 pd=2.26 as=0 ps=0 w=0.87 l=0.59
X142 VPWR VGND VPWR VPWR sky130_fd_pr__pfet_01v8_hvt ad=0.2262 pd=2.26 as=0 ps=0 w=0.87 l=0.59
X143 _55_.D _55_.Q VPWR VPWR sky130_fd_pr__pfet_01v8_hvt ad=0.135 pd=1.27 as=0.26 ps=2.52 w=1 l=0.15
X144 a_4975_9295# a_4351_9301# a_4867_9673# VPWR sky130_fd_pr__pfet_01v8_hvt ad=0.1155 pd=0.97 as=0.07245 ps=0.765 w=0.42 l=0.15
X145 a_8183_5461# u_loop.u_gh.C VPWR VPWR sky130_fd_pr__pfet_01v8_hvt ad=0.0567 pd=0.69 as=0.0819 ps=0.81 w=0.42 l=0.15
X146 VPWR VGND VPWR VPWR sky130_fd_pr__pfet_01v8_hvt ad=0.2262 pd=2.26 as=0 ps=0 w=0.87 l=0.59
X147 VPWR VGND VPWR VPWR sky130_fd_pr__pfet_01v8_hvt ad=0.2262 pd=2.26 as=0 ps=0 w=0.87 l=0.59
X148 VGND VPWR VGND VGND sky130_fd_pr__nfet_01v8 ad=0.143 pd=1.62 as=0 ps=0 w=0.55 l=0.59
X149 VPWR VGND VPWR VPWR sky130_fd_pr__pfet_01v8_hvt ad=0.2262 pd=2.26 as=0 ps=0 w=0.87 l=0.59
X150 a_4769_4175# u_loop.u_gh.B a_4351_4175# VGND sky130_fd_pr__nfet_01v8 ad=0.08775 pd=0.92 as=0.08775 ps=0.92 w=0.65 l=0.15
X151 a_2479_9269# a_2766_9427# VPWR VPWR sky130_fd_pr__pfet_01v8_hvt ad=0.0567 pd=0.69 as=0.1134 ps=1.38 w=0.42 l=0.15
X152 VPWR a_3491_5247# a_3478_4943# VPWR sky130_fd_pr__pfet_01v8_hvt ad=0.0819 pd=0.81 as=0.0567 ps=0.69 w=0.42 l=0.15
X153 VPWR VGND VPWR VPWR sky130_fd_pr__pfet_01v8_hvt ad=0.2262 pd=2.26 as=0 ps=0 w=0.87 l=0.59
X154 VPWR a_5069_2767# a_5175_2767# VPWR sky130_fd_pr__pfet_01v8_hvt ad=0.14075 pd=1.325 as=0.1092 ps=1.36 w=0.42 l=0.5
X155 VPWR VGND VPWR VPWR sky130_fd_pr__pfet_01v8_hvt ad=0.2262 pd=2.26 as=0 ps=0 w=0.87 l=0.59
X156 a_7167_4233# a_6817_3861# a_7072_4221# VPWR sky130_fd_pr__pfet_01v8_hvt ad=0.07245 pd=0.765 as=0.0651 ps=0.73 w=0.42 l=0.15
X157 VPWR VGND VPWR VPWR sky130_fd_pr__pfet_01v8_hvt ad=0.2262 pd=2.26 as=0 ps=0 w=0.87 l=0.59
X158 VGND a_4032_7351# a_3992_7235# VGND sky130_fd_pr__nfet_01v8 ad=0.0567 pd=0.69 as=0.1092 ps=1.36 w=0.42 l=0.15
X159 VPWR VGND VPWR VPWR sky130_fd_pr__pfet_01v8_hvt ad=0.2262 pd=2.26 as=0 ps=0 w=0.87 l=0.59
X160 VGND a_3992_7235# _41_.C1 VGND sky130_fd_pr__nfet_01v8 ad=0.10025 pd=0.985 as=0.08775 ps=0.92 w=0.65 l=0.15
X161 VGND VPWR VGND VGND sky130_fd_pr__nfet_01v8 ad=0.143 pd=1.62 as=0 ps=0 w=0.55 l=0.59
X162 VPWR VGND VPWR VPWR sky130_fd_pr__pfet_01v8_hvt ad=0.2262 pd=2.26 as=0 ps=0 w=0.87 l=0.59
X163 VPWR VGND VPWR VPWR sky130_fd_pr__pfet_01v8_hvt ad=0.2262 pd=2.26 as=0 ps=0 w=0.87 l=0.59
X164 a_7275_3855# a_6651_3861# a_7167_4233# VPWR sky130_fd_pr__pfet_01v8_hvt ad=0.1155 pd=0.97 as=0.07245 ps=0.765 w=0.42 l=0.15
X165 VGND VPWR VGND VGND sky130_fd_pr__nfet_01v8 ad=0.143 pd=1.62 as=0 ps=0 w=0.55 l=0.59
X166 VPWR _48_.Y a_4351_9301# VPWR sky130_fd_pr__pfet_01v8_hvt ad=0.0864 pd=0.91 as=0.1664 ps=1.8 w=0.64 l=0.15
X167 VGND VPWR VGND VGND sky130_fd_pr__nfet_01v8 ad=0.143 pd=1.62 as=0 ps=0 w=0.55 l=0.59
X168 VPWR u_loop.u_gh.C prenh VPWR sky130_fd_pr__pfet_01v8_hvt ad=0.135 pd=1.27 as=0.135 ps=1.27 w=1 l=0.15
X169 VPWR VGND VPWR VPWR sky130_fd_pr__pfet_01v8_hvt ad=0.2262 pd=2.26 as=0 ps=0 w=0.87 l=0.59
X170 VPWR u_loop.u_d2.X a_3361_2767# VPWR sky130_fd_pr__pfet_01v8_hvt ad=0.0567 pd=0.69 as=0.1092 ps=1.36 w=0.42 l=0.15
X171 VGND a_2125_2767# a_2231_2767# VGND sky130_fd_pr__nfet_01v8 ad=0.097 pd=0.975 as=0.1092 ps=1.36 w=0.42 l=0.5
X172 VPWR VGND VPWR VPWR sky130_fd_pr__pfet_01v8_hvt ad=0.2262 pd=2.26 as=0 ps=0 w=0.87 l=0.59
X173 VGND VPWR VGND VGND sky130_fd_pr__nfet_01v8 ad=0.143 pd=1.62 as=0 ps=0 w=0.55 l=0.59
X174 VGND VPWR VGND VGND sky130_fd_pr__nfet_01v8 ad=0.143 pd=1.62 as=0 ps=0 w=0.55 l=0.59
X175 a_4076_3561# u_loop.u_gl.A2 VPWR VPWR sky130_fd_pr__pfet_01v8_hvt ad=0.14 pd=1.28 as=0.14 ps=1.28 w=1 l=0.15
X176 _64_.Q a_3399_6335# VPWR VPWR sky130_fd_pr__pfet_01v8_hvt ad=0.135 pd=1.27 as=0.3012 ps=2.66 w=1 l=0.15
X177 a_7443_5487# a_6927_5487# a_7348_5487# VGND sky130_fd_pr__special_nfet_01v8 ad=0.0594 pd=0.69 as=0.066 ps=0.745 w=0.36 l=0.15
X178 VPWR a_8183_5461# a_8170_5853# VPWR sky130_fd_pr__pfet_01v8_hvt ad=0.0819 pd=0.81 as=0.0567 ps=0.69 w=0.42 l=0.15
X179 VGND VPWR VGND VGND sky130_fd_pr__nfet_01v8 ad=0.143 pd=1.62 as=0 ps=0 w=0.55 l=0.59
X180 VPWR _40_.B _62_.D VPWR sky130_fd_pr__pfet_01v8_hvt ad=0.26 pd=2.52 as=0.135 ps=1.27 w=1 l=0.15
X181 VGND VPWR VGND VGND sky130_fd_pr__nfet_01v8 ad=0.143 pd=1.62 as=0 ps=0 w=0.55 l=0.59
X182 a_3333_6409# a_2143_6037# a_3224_6409# VGND sky130_fd_pr__special_nfet_01v8 ad=0.0669 pd=0.75 as=0.0711 ps=0.755 w=0.36 l=0.15
X183 VGND VPWR VGND VGND sky130_fd_pr__nfet_01v8 ad=0.143 pd=1.62 as=0 ps=0 w=0.55 l=0.59
X184 VPWR VGND VPWR VPWR sky130_fd_pr__pfet_01v8_hvt ad=0.2262 pd=2.26 as=0 ps=0 w=0.87 l=0.59
X185 VPWR VGND VPWR VPWR sky130_fd_pr__pfet_01v8_hvt ad=0.2262 pd=2.26 as=0 ps=0 w=0.87 l=0.59
X186 a_8630_7119# a_7553_7125# a_8468_7497# VPWR sky130_fd_pr__pfet_01v8_hvt ad=0.0567 pd=0.69 as=0.0588 ps=0.7 w=0.42 l=0.15
X187 _55_.Q a_7907_4159# VGND VGND sky130_fd_pr__nfet_01v8 ad=0.08775 pd=0.92 as=0.2087 ps=2.02 w=0.65 l=0.15
X188 VPWR u_loop.u_d0.A prenh VPWR sky130_fd_pr__pfet_01v8_hvt ad=0.27 pd=2.54 as=0.135 ps=1.27 w=1 l=0.15
X189 VPWR a_5607_9599# _39_.B2 VPWR sky130_fd_pr__pfet_01v8_hvt ad=0.26 pd=2.52 as=0.135 ps=1.27 w=1 l=0.15
X190 VPWR VGND VPWR VPWR sky130_fd_pr__pfet_01v8_hvt ad=0.2262 pd=2.26 as=0 ps=0 w=0.87 l=0.59
X191 VGND VPWR VGND VGND sky130_fd_pr__nfet_01v8 ad=0.143 pd=1.62 as=0 ps=0 w=0.55 l=0.59
X192 VGND VPWR VGND VGND sky130_fd_pr__nfet_01v8 ad=0.143 pd=1.62 as=0 ps=0 w=0.55 l=0.59
X193 VPWR VGND VPWR VPWR sky130_fd_pr__pfet_01v8_hvt ad=0.2262 pd=2.26 as=0 ps=0 w=0.87 l=0.59
X194 a_2755_6409# a_2309_6037# a_2659_6409# VGND sky130_fd_pr__special_nfet_01v8 ad=0.1401 pd=1.1 as=0.0594 ps=0.69 w=0.36 l=0.15
X195 a_5129_9661# a_5085_9269# a_4963_9673# VGND sky130_fd_pr__nfet_01v8 ad=0.0441 pd=0.63 as=0.1401 ps=1.1 w=0.42 l=0.15
X196 VPWR a_3859_8511# a_3846_8207# VPWR sky130_fd_pr__pfet_01v8_hvt ad=0.0819 pd=0.81 as=0.0567 ps=0.69 w=0.42 l=0.15
X197 VPWR VGND VPWR VPWR sky130_fd_pr__pfet_01v8_hvt ad=0.2262 pd=2.26 as=0 ps=0 w=0.87 l=0.59
X198 VPWR VGND VPWR VPWR sky130_fd_pr__pfet_01v8_hvt ad=0.2262 pd=2.26 as=0 ps=0 w=0.87 l=0.59
X199 VPWR a_4333_2767# a_4439_2767# VPWR sky130_fd_pr__pfet_01v8_hvt ad=0.14075 pd=1.325 as=0.1092 ps=1.36 w=0.42 l=0.5
X200 VPWR u_loop.u_d0.A a_4076_3561# VPWR sky130_fd_pr__pfet_01v8_hvt ad=0.14 pd=1.28 as=0.14 ps=1.28 w=1 l=0.15
X201 VGND VPWR VGND VGND sky130_fd_pr__nfet_01v8 ad=0.143 pd=1.62 as=0 ps=0 w=0.55 l=0.59
X202 VPWR VGND VPWR VPWR sky130_fd_pr__pfet_01v8_hvt ad=0.2262 pd=2.26 as=0 ps=0 w=0.87 l=0.59
X203 _36_.A a_4167_6147# VPWR VPWR sky130_fd_pr__pfet_01v8_hvt ad=0.165 pd=1.33 as=0.1468 ps=1.34 w=1 l=0.15
X204 u_loop.u_d2.X a_2967_2767# VGND VGND sky130_fd_pr__nfet_01v8 ad=0.169 pd=1.82 as=0.097 ps=0.975 w=0.65 l=0.15
X205 a_6141_4399# a_6097_4641# a_5975_4399# VGND sky130_fd_pr__nfet_01v8 ad=0.0441 pd=0.63 as=0.1401 ps=1.1 w=0.42 l=0.15
X206 VGND VPWR VGND VGND sky130_fd_pr__nfet_01v8 ad=0.143 pd=1.62 as=0 ps=0 w=0.55 l=0.59
X207 xa a_8643_7423# VGND VGND sky130_fd_pr__nfet_01v8 ad=0.08775 pd=0.92 as=0.2087 ps=2.02 w=0.65 l=0.15
X208 VPWR a_7109_6005# a_6999_6031# VPWR sky130_fd_pr__pfet_01v8_hvt ad=0.07035 pd=0.755 as=0.1155 ps=0.97 w=0.42 l=0.15
X209 VPWR VGND VPWR VPWR sky130_fd_pr__pfet_01v8_hvt ad=0.2262 pd=2.26 as=0 ps=0 w=0.87 l=0.59
X210 VPWR VGND VPWR VPWR sky130_fd_pr__pfet_01v8_hvt ad=0.2262 pd=2.26 as=0 ps=0 w=0.87 l=0.59
X211 VPWR VGND VPWR VPWR sky130_fd_pr__pfet_01v8_hvt ad=0.2262 pd=2.26 as=0 ps=0 w=0.87 l=0.59
X212 a_7456_6409# a_6541_6037# a_7109_6005# VGND sky130_fd_pr__special_nfet_01v8 ad=0.0711 pd=0.755 as=0.0999 ps=0.985 w=0.36 l=0.15
X213 VPWR VGND VPWR VPWR sky130_fd_pr__pfet_01v8_hvt ad=0.2262 pd=2.26 as=0 ps=0 w=0.87 l=0.59
X214 VGND u_loop.u_gh.C a_2801_9661# VGND sky130_fd_pr__nfet_01v8 ad=0.12495 pd=1.015 as=0.06405 ps=0.725 w=0.42 l=0.15
X215 VGND a_3859_8511# _40_.B VGND sky130_fd_pr__nfet_01v8 ad=0.169 pd=1.82 as=0.08775 ps=0.92 w=0.65 l=0.15
X216 VGND VPWR VGND VGND sky130_fd_pr__nfet_01v8 ad=0.143 pd=1.62 as=0 ps=0 w=0.55 l=0.59
X217 VPWR VGND VPWR VPWR sky130_fd_pr__pfet_01v8_hvt ad=0.2262 pd=2.26 as=0 ps=0 w=0.87 l=0.59
X218 a_3083_9537# _49_.Y VGND VGND sky130_fd_pr__nfet_01v8 ad=0.1092 pd=1.36 as=0.0567 ps=0.69 w=0.42 l=0.15
X219 _39_.B2 a_5607_9599# VGND VGND sky130_fd_pr__nfet_01v8 ad=0.08775 pd=0.92 as=0.2087 ps=2.02 w=0.65 l=0.15
X220 _49_.Y _40_.B VGND VGND sky130_fd_pr__nfet_01v8 ad=0.08775 pd=0.92 as=0.169 ps=1.82 w=0.65 l=0.15
X221 VGND _30_.A _30_.Y VGND sky130_fd_pr__nfet_01v8 ad=0.169 pd=1.82 as=0.08775 ps=0.92 w=0.65 l=0.15
X222 _64_.D _64_.Q VPWR VPWR sky130_fd_pr__pfet_01v8_hvt ad=0.135 pd=1.27 as=0.26 ps=2.52 w=1 l=0.15
X223 a_6796_6397# _32_.Y VGND VGND sky130_fd_pr__nfet_01v8 ad=0.066 pd=0.745 as=0.2205 ps=1.89 w=0.42 l=0.15
X224 VPWR a_2479_9269# _30_.A VPWR sky130_fd_pr__pfet_01v8_hvt ad=0.3012 pd=2.66 as=0.135 ps=1.27 w=1 l=0.15
X225 VPWR a_3239_9269# a_3170_9295# VPWR sky130_fd_pr__pfet_01v8_hvt ad=0.2184 pd=2.2 as=0.12915 ps=1.185 w=0.84 l=0.15
X226 VGND a_5190_7439# _39_.X VGND sky130_fd_pr__nfet_01v8 ad=0.169 pd=1.82 as=0.08775 ps=0.92 w=0.65 l=0.15
X227 VGND u_loop.u_gh.C a_3013_5309# VGND sky130_fd_pr__nfet_01v8 ad=0.1346 pd=1.15 as=0.0441 ps=0.63 w=0.42 l=0.15
X228 a_3793_8585# a_2603_8213# a_3684_8585# VGND sky130_fd_pr__special_nfet_01v8 ad=0.0669 pd=0.75 as=0.0711 ps=0.755 w=0.36 l=0.15
X229 VGND VPWR VGND VGND sky130_fd_pr__nfet_01v8 ad=0.143 pd=1.62 as=0 ps=0 w=0.55 l=0.59
X230 prenl u_loop.u_gl.B1 VGND VGND sky130_fd_pr__nfet_01v8 ad=0.091 pd=0.93 as=0.091 ps=0.93 w=0.65 l=0.15
X231 VGND VPWR VGND VGND sky130_fd_pr__nfet_01v8 ad=0.143 pd=1.62 as=0 ps=0 w=0.55 l=0.59
X232 VPWR a_2755_7637# a_2742_8029# VPWR sky130_fd_pr__pfet_01v8_hvt ad=0.0819 pd=0.81 as=0.0567 ps=0.69 w=0.42 l=0.15
X233 VPWR a_8121_4917# a_8011_4943# VPWR sky130_fd_pr__pfet_01v8_hvt ad=0.07035 pd=0.755 as=0.1155 ps=0.97 w=0.42 l=0.15
X234 a_5987_4765# u_loop.u_gh.C VPWR VPWR sky130_fd_pr__pfet_01v8_hvt ad=0.1092 pd=1.36 as=0.07035 ps=0.755 w=0.42 l=0.15
X235 _56_.CLK _32_.A VGND VGND sky130_fd_pr__nfet_01v8 ad=0.08775 pd=0.92 as=0.169 ps=1.82 w=0.65 l=0.15
X236 a_2751_5321# a_2235_4949# a_2656_5309# VGND sky130_fd_pr__special_nfet_01v8 ad=0.0594 pd=0.69 as=0.066 ps=0.745 w=0.36 l=0.15
X237 VPWR u_loop.u_d7.X a_6457_2473# VPWR sky130_fd_pr__pfet_01v8_hvt ad=0.26 pd=2.52 as=0.105 ps=1.21 w=1 l=0.15
X238 VGND u_loop.u_d5.X a_5569_2767# VGND sky130_fd_pr__nfet_01v8 ad=0.0567 pd=0.69 as=0.1092 ps=1.36 w=0.42 l=0.15
X239 a_7385_3829# a_7167_4233# VGND VGND sky130_fd_pr__nfet_01v8 ad=0.0999 pd=0.985 as=0.1346 ps=1.15 w=0.64 l=0.15
X240 _31_.Y _46_.A VPWR VPWR sky130_fd_pr__pfet_01v8_hvt ad=0.135 pd=1.27 as=0.26 ps=2.52 w=1 l=0.15
X241 VPWR _53_.Y a_2235_4949# VPWR sky130_fd_pr__pfet_01v8_hvt ad=0.0864 pd=0.91 as=0.1664 ps=1.8 w=0.64 l=0.15
X242 VPWR a_6444_4399# a_6619_4373# VPWR sky130_fd_pr__pfet_01v8_hvt ad=0.1134 pd=1.38 as=0.0567 ps=0.69 w=0.42 l=0.15
X243 a_5989_8751# a_5823_8751# VGND VGND sky130_fd_pr__nfet_01v8 ad=0.1092 pd=1.36 as=0.0567 ps=0.69 w=0.42 l=0.15
X244 _51_.Y _64_.Q VPWR VPWR sky130_fd_pr__pfet_01v8_hvt ad=0.135 pd=1.27 as=0.26 ps=2.52 w=1 l=0.15
X245 a_4518_6825# src[0] VPWR VPWR sky130_fd_pr__pfet_01v8_hvt ad=0.135 pd=1.27 as=0.135 ps=1.27 w=1 l=0.15
X246 VPWR VGND VPWR VPWR sky130_fd_pr__pfet_01v8_hvt ad=0.2262 pd=2.26 as=0 ps=0 w=0.87 l=0.59
X247 u_loop.u_s2.A u_loop.u_cmp.Y VPWR VPWR sky130_fd_pr__pfet_01v8_hvt ad=0.26 pd=2.52 as=0.26 ps=2.52 w=1 l=0.15
X248 VPWR VGND VPWR VPWR sky130_fd_pr__pfet_01v8_hvt ad=0.2262 pd=2.26 as=0 ps=0 w=0.87 l=0.59
X249 VGND VPWR VGND VGND sky130_fd_pr__nfet_01v8 ad=0.143 pd=1.62 as=0 ps=0 w=0.55 l=0.59
X250 a_3859_8511# u_loop.u_gh.C VPWR VPWR sky130_fd_pr__pfet_01v8_hvt ad=0.0567 pd=0.69 as=0.0819 ps=0.81 w=0.42 l=0.15
X251 a_8643_7423# a_8468_7497# a_8822_7485# VGND sky130_fd_pr__nfet_01v8 ad=0.1092 pd=1.36 as=0.06405 ps=0.725 w=0.42 l=0.15
X252 VPWR a_3224_6409# a_3399_6335# VPWR sky130_fd_pr__pfet_01v8_hvt ad=0.1134 pd=1.38 as=0.0567 ps=0.69 w=0.42 l=0.15
X253 u_loop.u_s2.Y u_loop.u_s2.A VGND VGND sky130_fd_pr__nfet_01v8 ad=0.169 pd=1.82 as=0.169 ps=1.82 w=0.65 l=0.15
X254 prenh u_loop.u_d0.A a_4769_4175# VGND sky130_fd_pr__nfet_01v8 ad=0.08775 pd=0.92 as=0.08775 ps=0.92 w=0.65 l=0.15
X255 a_5293_5487# _56_.Q a_5377_5487# VGND sky130_fd_pr__nfet_01v8 ad=0.169 pd=1.82 as=0.08775 ps=0.92 w=0.65 l=0.15
X256 VPWR u_loop.u_gh.C prenh VPWR sky130_fd_pr__pfet_01v8_hvt ad=0.135 pd=1.27 as=0.135 ps=1.27 w=1 l=0.15
X257 a_5784_4399# _56_.D VPWR VPWR sky130_fd_pr__pfet_01v8_hvt ad=0.0651 pd=0.73 as=0.1092 ps=1.36 w=0.42 l=0.15
X258 VPWR VGND VPWR VPWR sky130_fd_pr__pfet_01v8_hvt ad=0.2262 pd=2.26 as=0 ps=0 w=0.87 l=0.59
X259 VPWR u_loop.u_gl.A2 a_4076_3561# VPWR sky130_fd_pr__pfet_01v8_hvt ad=0.14 pd=1.28 as=0.14 ps=1.28 w=1 l=0.15
X260 VGND a_3597_2767# a_3703_2767# VGND sky130_fd_pr__nfet_01v8 ad=0.097 pd=0.975 as=0.1092 ps=1.36 w=0.42 l=0.5
X261 a_7275_3855# u_loop.u_gh.C VPWR VPWR sky130_fd_pr__pfet_01v8_hvt ad=0.1092 pd=1.36 as=0.07035 ps=0.755 w=0.42 l=0.15
X262 a_2564_6397# _64_.D VPWR VPWR sky130_fd_pr__pfet_01v8_hvt ad=0.0651 pd=0.73 as=0.1092 ps=1.36 w=0.42 l=0.15
X263 a_6619_4373# a_6444_4399# a_6798_4399# VGND sky130_fd_pr__nfet_01v8 ad=0.1092 pd=1.36 as=0.06405 ps=0.725 w=0.42 l=0.15
X264 a_5607_9599# a_5432_9673# a_5786_9661# VGND sky130_fd_pr__nfet_01v8 ad=0.1092 pd=1.36 as=0.06405 ps=0.725 w=0.42 l=0.15
X265 VPWR VGND VPWR VPWR sky130_fd_pr__pfet_01v8_hvt ad=0.2262 pd=2.26 as=0 ps=0 w=0.87 l=0.59
X266 _32_.A a_7631_6335# VPWR VPWR sky130_fd_pr__pfet_01v8_hvt ad=0.135 pd=1.27 as=0.3012 ps=2.66 w=1 l=0.15
X267 VGND VPWR VGND VGND sky130_fd_pr__nfet_01v8 ad=0.143 pd=1.62 as=0 ps=0 w=0.55 l=0.59
X268 VPWR u_loop.u_d0.A prenh VPWR sky130_fd_pr__pfet_01v8_hvt ad=0.135 pd=1.27 as=0.135 ps=1.27 w=1 l=0.15
X269 VPWR _56_.CLK a_5363_4399# VPWR sky130_fd_pr__pfet_01v8_hvt ad=0.0864 pd=0.91 as=0.1664 ps=1.8 w=0.64 l=0.15
X270 a_5085_9269# a_4867_9673# VGND VGND sky130_fd_pr__nfet_01v8 ad=0.0999 pd=0.985 as=0.1346 ps=1.15 w=0.64 l=0.15
X271 VGND u_loop.u_gh.C a_8165_5309# VGND sky130_fd_pr__nfet_01v8 ad=0.1346 pd=1.15 as=0.0441 ps=0.63 w=0.42 l=0.15
X272 VGND a_8643_5247# _25_.A VGND sky130_fd_pr__nfet_01v8 ad=0.169 pd=1.82 as=0.08775 ps=0.92 w=0.65 l=0.15
X273 VGND VPWR VGND VGND sky130_fd_pr__nfet_01v8 ad=0.143 pd=1.62 as=0 ps=0 w=0.55 l=0.59
X274 _46_.Y _46_.A VPWR VPWR sky130_fd_pr__pfet_01v8_hvt ad=0.135 pd=1.27 as=0.26 ps=2.52 w=1 l=0.15
X275 VPWR _20_.Y a_1499_6575# VPWR sky130_fd_pr__pfet_01v8_hvt ad=0.14 pd=1.28 as=0.265 ps=2.53 w=1 l=0.15
X276 _52_.Y _28_.A VGND VGND sky130_fd_pr__nfet_01v8 ad=0.08775 pd=0.92 as=0.169 ps=1.82 w=0.65 l=0.15
X277 u_loop.u_d1.X a_2875_2223# VPWR VPWR sky130_fd_pr__pfet_01v8_hvt ad=0.26 pd=2.52 as=0.14075 ps=1.325 w=1 l=0.15
X278 VPWR u_loop.u_gh.B prenh VPWR sky130_fd_pr__pfet_01v8_hvt ad=0.26 pd=2.52 as=0.135 ps=1.27 w=1 l=0.15
X279 VGND _39_.X a_7387_7125# VGND sky130_fd_pr__nfet_01v8 ad=0.0567 pd=0.69 as=0.1092 ps=1.36 w=0.42 l=0.15
X280 VGND VPWR VGND VGND sky130_fd_pr__nfet_01v8 ad=0.143 pd=1.62 as=0 ps=0 w=0.55 l=0.59
X281 VPWR VGND VPWR VPWR sky130_fd_pr__pfet_01v8_hvt ad=0.2262 pd=2.26 as=0 ps=0 w=0.87 l=0.59
X282 VPWR VGND VPWR VPWR sky130_fd_pr__pfet_01v8_hvt ad=0.2262 pd=2.26 as=0 ps=0 w=0.87 l=0.59
X283 VGND u_loop.u_d0.A a_1889_2767# VGND sky130_fd_pr__nfet_01v8 ad=0.0567 pd=0.69 as=0.1092 ps=1.36 w=0.42 l=0.15
X284 VGND _55_.CLK a_6651_3861# VGND sky130_fd_pr__nfet_01v8 ad=0.0567 pd=0.69 as=0.1092 ps=1.36 w=0.42 l=0.15
X285 VGND _55_.Q _55_.D VGND sky130_fd_pr__nfet_01v8 ad=0.169 pd=1.82 as=0.08775 ps=0.92 w=0.65 l=0.15
X286 VPWR VGND VPWR VPWR sky130_fd_pr__pfet_01v8_hvt ad=0.2262 pd=2.26 as=0 ps=0 w=0.87 l=0.59
X287 VPWR VGND VPWR VPWR sky130_fd_pr__pfet_01v8_hvt ad=0.2262 pd=2.26 as=0 ps=0 w=0.87 l=0.59
X288 _41_.B1 a_4160_6575# a_4518_6825# VPWR sky130_fd_pr__pfet_01v8_hvt ad=0.135 pd=1.27 as=0.26 ps=2.52 w=1 l=0.15
X289 a_2751_5321# a_2401_4949# a_2656_5309# VPWR sky130_fd_pr__pfet_01v8_hvt ad=0.07245 pd=0.765 as=0.0651 ps=0.73 w=0.42 l=0.15
X290 a_3597_2767# a_3361_2767# VGND VGND sky130_fd_pr__nfet_01v8 ad=0.1092 pd=1.36 as=0.0567 ps=0.69 w=0.42 l=0.5
X291 a_6704_7663# _22_.Y VGND VGND sky130_fd_pr__nfet_01v8 ad=0.066 pd=0.745 as=0.2205 ps=1.89 w=0.42 l=0.15
X292 VPWR VGND VPWR VPWR sky130_fd_pr__pfet_01v8_hvt ad=0.2262 pd=2.26 as=0 ps=0 w=0.87 l=0.59
X293 a_3024_8573# _62_.D VGND VGND sky130_fd_pr__nfet_01v8 ad=0.066 pd=0.745 as=0.2205 ps=1.89 w=0.42 l=0.15
X294 a_6449_7663# a_6283_7663# VGND VGND sky130_fd_pr__nfet_01v8 ad=0.1092 pd=1.36 as=0.0567 ps=0.69 w=0.42 l=0.15
X295 VGND a_2769_2223# a_2875_2223# VGND sky130_fd_pr__nfet_01v8 ad=0.097 pd=0.975 as=0.1092 ps=1.36 w=0.42 l=0.5
X296 a_7385_3829# a_7167_4233# VPWR VPWR sky130_fd_pr__pfet_01v8_hvt ad=0.12915 pd=1.185 as=0.2184 ps=2.2 w=0.84 l=0.15
X297 a_2769_8213# a_2603_8213# VGND VGND sky130_fd_pr__nfet_01v8 ad=0.1092 pd=1.36 as=0.0567 ps=0.69 w=0.42 l=0.15
X298 VGND VPWR VGND VGND sky130_fd_pr__nfet_01v8 ad=0.143 pd=1.62 as=0 ps=0 w=0.55 l=0.59
X299 VGND VPWR VGND VGND sky130_fd_pr__nfet_01v8 ad=0.143 pd=1.62 as=0 ps=0 w=0.55 l=0.59
X300 VPWR VGND VPWR VPWR sky130_fd_pr__pfet_01v8_hvt ad=0.2262 pd=2.26 as=0 ps=0 w=0.87 l=0.59
X301 VPWR VGND VPWR VPWR sky130_fd_pr__pfet_01v8_hvt ad=0.2262 pd=2.26 as=0 ps=0 w=0.87 l=0.59
X302 VPWR _42_.Y a_7387_4949# VPWR sky130_fd_pr__pfet_01v8_hvt ad=0.0864 pd=0.91 as=0.1664 ps=1.8 w=0.64 l=0.15
X303 VPWR a_5805_2767# a_5911_2767# VPWR sky130_fd_pr__pfet_01v8_hvt ad=0.14075 pd=1.325 as=0.1092 ps=1.36 w=0.42 l=0.5
X304 VPWR VGND VPWR VPWR sky130_fd_pr__pfet_01v8_hvt ad=0.2262 pd=2.26 as=0 ps=0 w=0.87 l=0.59
X305 VGND VPWR VGND VGND sky130_fd_pr__nfet_01v8 ad=0.143 pd=1.62 as=0 ps=0 w=0.55 l=0.59
X306 VPWR VGND VPWR VPWR sky130_fd_pr__pfet_01v8_hvt ad=0.2262 pd=2.26 as=0 ps=0 w=0.87 l=0.59
X307 a_3316_5321# a_2401_4949# a_2969_4917# VGND sky130_fd_pr__special_nfet_01v8 ad=0.0711 pd=0.755 as=0.0999 ps=0.985 w=0.36 l=0.15
X308 a_2122_4651# a_2400_4667# a_2356_4765# VPWR sky130_fd_pr__pfet_01v8_hvt ad=0.0588 pd=0.7 as=0.0567 ps=0.69 w=0.42 l=0.15
X309 u_loop.u_d4.X a_4439_2767# VGND VGND sky130_fd_pr__nfet_01v8 ad=0.169 pd=1.82 as=0.097 ps=0.975 w=0.65 l=0.15
X310 VPWR VGND VPWR VPWR sky130_fd_pr__pfet_01v8_hvt ad=0.2262 pd=2.26 as=0 ps=0 w=0.87 l=0.59
X311 _25_.A a_8643_5247# VPWR VPWR sky130_fd_pr__pfet_01v8_hvt ad=0.135 pd=1.27 as=0.3012 ps=2.66 w=1 l=0.15
X312 VPWR VGND VPWR VPWR sky130_fd_pr__pfet_01v8_hvt ad=0.2262 pd=2.26 as=0 ps=0 w=0.87 l=0.59
X313 VPWR VGND VPWR VPWR sky130_fd_pr__pfet_01v8_hvt ad=0.2262 pd=2.26 as=0 ps=0 w=0.87 l=0.59
X314 a_8121_7093# a_7903_7497# VGND VGND sky130_fd_pr__nfet_01v8 ad=0.0999 pd=0.985 as=0.1346 ps=1.15 w=0.64 l=0.15
X315 VPWR a_6633_2767# a_6739_2767# VPWR sky130_fd_pr__pfet_01v8_hvt ad=0.14075 pd=1.325 as=0.1092 ps=1.36 w=0.42 l=0.5
X316 a_7732_4233# a_6651_3861# a_7385_3829# VPWR sky130_fd_pr__pfet_01v8_hvt ad=0.0588 pd=0.7 as=0.12915 ps=1.185 w=0.42 l=0.15
X317 VPWR VGND VPWR VPWR sky130_fd_pr__pfet_01v8_hvt ad=0.2262 pd=2.26 as=0 ps=0 w=0.87 l=0.59
X318 VGND VPWR VGND VGND sky130_fd_pr__nfet_01v8 ad=0.143 pd=1.62 as=0 ps=0 w=0.55 l=0.59
X319 VPWR a_8183_5461# xb VPWR sky130_fd_pr__pfet_01v8_hvt ad=0.26 pd=2.52 as=0.135 ps=1.27 w=1 l=0.15
X320 VGND VPWR VGND VGND sky130_fd_pr__nfet_01v8 ad=0.143 pd=1.62 as=0 ps=0 w=0.55 l=0.59
X321 VPWR VGND VPWR VPWR sky130_fd_pr__pfet_01v8_hvt ad=0.2262 pd=2.26 as=0 ps=0 w=0.87 l=0.59
X322 VPWR VGND VPWR VPWR sky130_fd_pr__pfet_01v8_hvt ad=0.2262 pd=2.26 as=0 ps=0 w=0.87 l=0.59
X323 VPWR VGND VPWR VPWR sky130_fd_pr__pfet_01v8_hvt ad=0.2262 pd=2.26 as=0 ps=0 w=0.87 l=0.59
X324 VGND VPWR VGND VGND sky130_fd_pr__nfet_01v8 ad=0.143 pd=1.62 as=0 ps=0 w=0.55 l=0.59
X325 a_2769_2223# a_2533_2223# VGND VGND sky130_fd_pr__nfet_01v8 ad=0.1092 pd=1.36 as=0.0567 ps=0.69 w=0.42 l=0.5
X326 VGND u_loop.u_gl.B1 prenl VGND sky130_fd_pr__nfet_01v8 ad=0.104 pd=0.97 as=0.091 ps=0.93 w=0.65 l=0.15
X327 a_7443_5487# a_7093_5487# a_7348_5487# VPWR sky130_fd_pr__pfet_01v8_hvt ad=0.07245 pd=0.765 as=0.0651 ps=0.73 w=0.42 l=0.15
X328 VPWR VGND VPWR VPWR sky130_fd_pr__pfet_01v8_hvt ad=0.2262 pd=2.26 as=0 ps=0 w=0.87 l=0.59
X329 VGND VPWR VGND VGND sky130_fd_pr__nfet_01v8 ad=0.143 pd=1.62 as=0 ps=0 w=0.55 l=0.59
X330 a_4369_6351# src[1] VGND VGND sky130_fd_pr__nfet_01v8 ad=0.169 pd=1.82 as=0.08775 ps=0.92 w=0.65 l=0.15
X331 VGND VPWR VGND VGND sky130_fd_pr__nfet_01v8 ad=0.143 pd=1.62 as=0 ps=0 w=0.55 l=0.59
X332 VGND VPWR VGND VGND sky130_fd_pr__nfet_01v8 ad=0.143 pd=1.62 as=0 ps=0 w=0.55 l=0.59
X333 VGND VPWR VGND VGND sky130_fd_pr__nfet_01v8 ad=0.143 pd=1.62 as=0 ps=0 w=0.55 l=0.59
X334 VGND _53_.A _27_.Y VGND sky130_fd_pr__nfet_01v8 ad=0.169 pd=1.82 as=0.08775 ps=0.92 w=0.65 l=0.15
X335 VPWR VGND VPWR VPWR sky130_fd_pr__pfet_01v8_hvt ad=0.2262 pd=2.26 as=0 ps=0 w=0.87 l=0.59
X336 _38_.X a_3348_7235# VPWR VPWR sky130_fd_pr__pfet_01v8_hvt ad=0.135 pd=1.27 as=0.14825 ps=1.34 w=1 l=0.15
X337 prenl u_loop.u_d0.A a_4510_3311# VGND sky130_fd_pr__nfet_01v8 ad=0.091 pd=0.93 as=0.091 ps=0.93 w=0.65 l=0.15
X338 VGND VPWR VGND VGND sky130_fd_pr__nfet_01v8 ad=0.143 pd=1.62 as=0 ps=0 w=0.55 l=0.59
X339 a_7551_5853# a_6927_5487# a_7443_5487# VPWR sky130_fd_pr__pfet_01v8_hvt ad=0.1155 pd=0.97 as=0.07245 ps=0.765 w=0.42 l=0.15
X340 a_5377_5487# _36_.A VGND VGND sky130_fd_pr__nfet_01v8 ad=0.08775 pd=0.92 as=0.169 ps=1.82 w=0.65 l=0.15
X341 VGND u_loop.u_gh.C a_4351_4175# VGND sky130_fd_pr__nfet_01v8 ad=0.08775 pd=0.92 as=0.169 ps=1.82 w=0.65 l=0.15
X342 a_5389_5737# _41_.B1 VPWR VPWR sky130_fd_pr__pfet_01v8_hvt ad=0.1125 pd=1.225 as=0.165 ps=1.33 w=1 l=0.15
X343 VPWR VGND VPWR VPWR sky130_fd_pr__pfet_01v8_hvt ad=0.2262 pd=2.26 as=0 ps=0 w=0.87 l=0.59
X344 VGND VPWR VGND VGND sky130_fd_pr__nfet_01v8 ad=0.143 pd=1.62 as=0 ps=0 w=0.55 l=0.59
X345 VGND a_7539_7637# _45_.A VGND sky130_fd_pr__nfet_01v8 ad=0.169 pd=1.82 as=0.08775 ps=0.92 w=0.65 l=0.15
X346 VPWR VGND VPWR VPWR sky130_fd_pr__pfet_01v8_hvt ad=0.2262 pd=2.26 as=0 ps=0 w=0.87 l=0.59
X347 VPWR VGND VPWR VPWR sky130_fd_pr__pfet_01v8_hvt ad=0.2262 pd=2.26 as=0 ps=0 w=0.87 l=0.59
X348 u_loop.u_gh.B _36_.A VGND VGND sky130_fd_pr__nfet_01v8 ad=0.08775 pd=0.92 as=0.169 ps=1.82 w=0.65 l=0.15
X349 VGND VPWR VGND VGND sky130_fd_pr__nfet_01v8 ad=0.143 pd=1.62 as=0 ps=0 w=0.55 l=0.59
X350 VPWR VGND VPWR VPWR sky130_fd_pr__pfet_01v8_hvt ad=0.2262 pd=2.26 as=0 ps=0 w=0.87 l=0.59
X351 VPWR a_3491_5247# _28_.A VPWR sky130_fd_pr__pfet_01v8_hvt ad=0.26 pd=2.52 as=0.135 ps=1.27 w=1 l=0.15
X352 prenh u_loop.u_d0.A a_4769_4175# VGND sky130_fd_pr__nfet_01v8 ad=0.08775 pd=0.92 as=0.169 ps=1.82 w=0.65 l=0.15
X353 _56_.Q a_6619_4373# VGND VGND sky130_fd_pr__nfet_01v8 ad=0.08775 pd=0.92 as=0.2087 ps=2.02 w=0.65 l=0.15
X354 a_6244_8751# _31_.Y VGND VGND sky130_fd_pr__nfet_01v8 ad=0.066 pd=0.745 as=0.2205 ps=1.89 w=0.42 l=0.15
X355 a_5293_5487# _41_.C1 a_5190_5487# VGND sky130_fd_pr__nfet_01v8 ad=0.08775 pd=0.92 as=0.23725 ps=2.03 w=0.65 l=0.15
X356 a_8468_5321# a_7553_4949# a_8121_4917# VGND sky130_fd_pr__special_nfet_01v8 ad=0.0711 pd=0.755 as=0.0999 ps=0.985 w=0.36 l=0.15
X357 a_7907_4159# a_7732_4233# a_8086_4221# VGND sky130_fd_pr__nfet_01v8 ad=0.1092 pd=1.36 as=0.06405 ps=0.725 w=0.42 l=0.15
X358 VGND u_loop.u_gh.C a_7429_4221# VGND sky130_fd_pr__nfet_01v8 ad=0.1346 pd=1.15 as=0.0441 ps=0.63 w=0.42 l=0.15
X359 _56_.D _56_.Q VGND VGND sky130_fd_pr__nfet_01v8 ad=0.08775 pd=0.92 as=0.169 ps=1.82 w=0.65 l=0.15
X360 u_loop.u_gh.C a_1499_6575# VPWR VPWR sky130_fd_pr__pfet_01v8_hvt ad=0.14 pd=1.28 as=0.195 ps=1.39 w=1 l=0.15
X361 VGND VPWR VGND VGND sky130_fd_pr__nfet_01v8 ad=0.143 pd=1.62 as=0 ps=0 w=0.55 l=0.59
X362 _53_.A a_1835_4373# VGND VGND sky130_fd_pr__nfet_01v8 ad=0.08775 pd=0.92 as=0.169 ps=1.82 w=0.65 l=0.15
X363 VPWR VGND VPWR VPWR sky130_fd_pr__pfet_01v8_hvt ad=0.2262 pd=2.26 as=0 ps=0 w=0.87 l=0.59
X364 VGND VPWR VGND VGND sky130_fd_pr__nfet_01v8 ad=0.143 pd=1.62 as=0 ps=0 w=0.55 l=0.59
X365 a_1665_7663# a_1499_7663# VPWR VPWR sky130_fd_pr__pfet_01v8_hvt ad=0.1664 pd=1.8 as=0.0864 ps=0.91 w=0.64 l=0.15
X366 VPWR VGND VPWR VPWR sky130_fd_pr__pfet_01v8_hvt ad=0.2262 pd=2.26 as=0 ps=0 w=0.87 l=0.59
X367 VGND VPWR VGND VGND sky130_fd_pr__nfet_01v8 ad=0.143 pd=1.62 as=0 ps=0 w=0.55 l=0.59
X368 VGND VPWR VGND VGND sky130_fd_pr__nfet_01v8 ad=0.143 pd=1.62 as=0 ps=0 w=0.55 l=0.59
X369 VGND _51_.Y a_1499_7663# VGND sky130_fd_pr__nfet_01v8 ad=0.0567 pd=0.69 as=0.1092 ps=1.36 w=0.42 l=0.15
X370 _63_.Q a_2755_7637# VPWR VPWR sky130_fd_pr__pfet_01v8_hvt ad=0.135 pd=1.27 as=0.3012 ps=2.66 w=1 l=0.15
X371 VGND _64_.Q _64_.D VGND sky130_fd_pr__nfet_01v8 ad=0.169 pd=1.82 as=0.08775 ps=0.92 w=0.65 l=0.15
X372 a_7808_7485# _68_.D VPWR VPWR sky130_fd_pr__pfet_01v8_hvt ad=0.0651 pd=0.73 as=0.1092 ps=1.36 w=0.42 l=0.15
X373 VGND VPWR VGND VGND sky130_fd_pr__nfet_01v8 ad=0.143 pd=1.62 as=0 ps=0 w=0.55 l=0.59
X374 a_2015_7663# a_1665_7663# a_1920_7663# VPWR sky130_fd_pr__pfet_01v8_hvt ad=0.07245 pd=0.765 as=0.0651 ps=0.73 w=0.42 l=0.15
X375 a_3670_5309# u_loop.u_gh.C VGND VGND sky130_fd_pr__nfet_01v8 ad=0.06405 pd=0.725 as=0.12495 ps=1.015 w=0.42 l=0.15
X376 VGND a_7539_7637# a_7473_7663# VGND sky130_fd_pr__nfet_01v8 ad=0.12495 pd=1.015 as=0.0669 ps=0.75 w=0.42 l=0.15
X377 VPWR VGND VPWR VPWR sky130_fd_pr__pfet_01v8_hvt ad=0.2262 pd=2.26 as=0 ps=0 w=0.87 l=0.59
X378 VGND _69_.LO sky130_fd_pr__res_generic_po w=0.48 l=0.045
X379 a_6606_4765# a_5529_4399# a_6444_4399# VPWR sky130_fd_pr__pfet_01v8_hvt ad=0.0567 pd=0.69 as=0.0588 ps=0.7 w=0.42 l=0.15
X380 VGND a_3859_8511# a_3793_8585# VGND sky130_fd_pr__nfet_01v8 ad=0.12495 pd=1.015 as=0.0669 ps=0.75 w=0.42 l=0.15
X381 VGND VPWR VGND VGND sky130_fd_pr__nfet_01v8 ad=0.143 pd=1.62 as=0 ps=0 w=0.55 l=0.59
X382 VGND VPWR VGND VGND sky130_fd_pr__nfet_01v8 ad=0.143 pd=1.62 as=0 ps=0 w=0.55 l=0.59
X383 VGND VPWR VGND VGND sky130_fd_pr__nfet_01v8 ad=0.143 pd=1.62 as=0 ps=0 w=0.55 l=0.59
X384 VGND VPWR VGND VGND sky130_fd_pr__nfet_01v8 ad=0.143 pd=1.62 as=0 ps=0 w=0.55 l=0.59
X385 VPWR VGND VPWR VPWR sky130_fd_pr__pfet_01v8_hvt ad=0.2262 pd=2.26 as=0 ps=0 w=0.87 l=0.59
X386 a_3386_6031# a_2309_6037# a_3224_6409# VPWR sky130_fd_pr__pfet_01v8_hvt ad=0.0567 pd=0.69 as=0.0588 ps=0.7 w=0.42 l=0.15
X387 a_7093_5487# a_6927_5487# VPWR VPWR sky130_fd_pr__pfet_01v8_hvt ad=0.1664 pd=1.8 as=0.0864 ps=0.91 w=0.64 l=0.15
X388 a_2526_4765# a_2439_4541# a_2122_4651# VPWR sky130_fd_pr__pfet_01v8_hvt ad=0.12915 pd=1.185 as=0.0588 ps=0.7 w=0.42 l=0.15
X389 a_5069_2767# a_4833_2767# VGND VGND sky130_fd_pr__nfet_01v8 ad=0.1092 pd=1.36 as=0.0567 ps=0.69 w=0.42 l=0.5
X390 _22_.Y _45_.A VGND VGND sky130_fd_pr__nfet_01v8 ad=0.08775 pd=0.92 as=0.169 ps=1.82 w=0.65 l=0.15
X391 VPWR src[0] a_4167_6147# VPWR sky130_fd_pr__pfet_01v8_hvt ad=0.1468 pd=1.34 as=0.1092 ps=1.36 w=0.42 l=0.15
X392 a_2309_6037# a_2143_6037# VPWR VPWR sky130_fd_pr__pfet_01v8_hvt ad=0.1664 pd=1.8 as=0.0864 ps=0.91 w=0.64 l=0.15
X393 VPWR VGND VPWR VPWR sky130_fd_pr__pfet_01v8_hvt ad=0.2262 pd=2.26 as=0 ps=0 w=0.87 l=0.59
X394 a_7705_5487# a_7661_5729# a_7539_5487# VGND sky130_fd_pr__nfet_01v8 ad=0.0441 pd=0.63 as=0.1401 ps=1.1 w=0.42 l=0.15
X395 VGND VPWR VGND VGND sky130_fd_pr__nfet_01v8 ad=0.143 pd=1.62 as=0 ps=0 w=0.55 l=0.59
X396 VPWR src[0] a_1845_6825# VPWR sky130_fd_pr__pfet_01v8_hvt ad=0.195 pd=1.39 as=0.105 ps=1.21 w=1 l=0.15
X397 VPWR u_loop.u_gh.B u_loop.u_gl.A2 VPWR sky130_fd_pr__pfet_01v8_hvt ad=0.26 pd=2.52 as=0.26 ps=2.52 w=1 l=0.15
X398 VGND VPWR VGND VGND sky130_fd_pr__nfet_01v8 ad=0.143 pd=1.62 as=0 ps=0 w=0.55 l=0.59
X399 VGND VPWR VGND VGND sky130_fd_pr__nfet_01v8 ad=0.143 pd=1.62 as=0 ps=0 w=0.55 l=0.59
X400 VPWR VGND VPWR VPWR sky130_fd_pr__pfet_01v8_hvt ad=0.2262 pd=2.26 as=0 ps=0 w=0.87 l=0.59
X401 VGND VPWR VGND VGND sky130_fd_pr__nfet_01v8 ad=0.143 pd=1.62 as=0 ps=0 w=0.55 l=0.59
X402 a_3158_4765# a_2439_4541# a_2595_4636# VGND sky130_fd_pr__special_nfet_01v8 ad=0.066 pd=0.745 as=0.0594 ps=0.69 w=0.36 l=0.15
X403 _40_.B a_3859_8511# VGND VGND sky130_fd_pr__nfet_01v8 ad=0.08775 pd=0.92 as=0.2087 ps=2.02 w=0.65 l=0.15
X404 VGND VPWR VGND VGND sky130_fd_pr__nfet_01v8 ad=0.143 pd=1.62 as=0 ps=0 w=0.55 l=0.59
X405 u_loop.u_d7.X a_6739_2767# VGND VGND sky130_fd_pr__nfet_01v8 ad=0.169 pd=1.82 as=0.097 ps=0.975 w=0.65 l=0.15
X406 a_7894_3855# a_6817_3861# a_7732_4233# VPWR sky130_fd_pr__pfet_01v8_hvt ad=0.0567 pd=0.69 as=0.0588 ps=0.7 w=0.42 l=0.15
X407 VGND a_3399_6335# _64_.Q VGND sky130_fd_pr__nfet_01v8 ad=0.169 pd=1.82 as=0.08775 ps=0.92 w=0.65 l=0.15
X408 VPWR a_2877_6005# a_2767_6031# VPWR sky130_fd_pr__pfet_01v8_hvt ad=0.07035 pd=0.755 as=0.1155 ps=0.97 w=0.42 l=0.15
X409 VGND VPWR VGND VGND sky130_fd_pr__nfet_01v8 ad=0.143 pd=1.62 as=0 ps=0 w=0.55 l=0.59
X410 VPWR _55_.Q _42_.Y VPWR sky130_fd_pr__pfet_01v8_hvt ad=0.26 pd=2.52 as=0.135 ps=1.27 w=1 l=0.15
X411 VGND VPWR VGND VGND sky130_fd_pr__nfet_01v8 ad=0.143 pd=1.62 as=0 ps=0 w=0.55 l=0.59
X412 VPWR u_loop.u_d3.X a_4097_2767# VPWR sky130_fd_pr__pfet_01v8_hvt ad=0.0567 pd=0.69 as=0.1092 ps=1.36 w=0.42 l=0.15
X413 VGND _27_.Y a_3158_4765# VGND sky130_fd_pr__nfet_01v8 ad=0.2205 pd=1.89 as=0.066 ps=0.745 w=0.42 l=0.15
X414 VPWR _27_.Y a_3158_4765# VPWR sky130_fd_pr__pfet_01v8_hvt ad=0.1092 pd=1.36 as=0.0651 ps=0.73 w=0.42 l=0.15
X415 _48_.Y _30_.A VPWR VPWR sky130_fd_pr__pfet_01v8_hvt ad=0.135 pd=1.27 as=0.26 ps=2.52 w=1 l=0.15
X416 VPWR VGND VPWR VPWR sky130_fd_pr__pfet_01v8_hvt ad=0.2262 pd=2.26 as=0 ps=0 w=0.87 l=0.59
X417 VPWR VGND VPWR VPWR sky130_fd_pr__pfet_01v8_hvt ad=0.2262 pd=2.26 as=0 ps=0 w=0.87 l=0.59
X418 VGND VPWR VGND VGND sky130_fd_pr__nfet_01v8 ad=0.143 pd=1.62 as=0 ps=0 w=0.55 l=0.59
X419 VPWR VGND VPWR VPWR sky130_fd_pr__pfet_01v8_hvt ad=0.2262 pd=2.26 as=0 ps=0 w=0.87 l=0.59
X420 VPWR a_6619_4373# _56_.Q VPWR sky130_fd_pr__pfet_01v8_hvt ad=0.26 pd=2.52 as=0.135 ps=1.27 w=1 l=0.15
X421 VGND VPWR VGND VGND sky130_fd_pr__nfet_01v8 ad=0.143 pd=1.62 as=0 ps=0 w=0.55 l=0.59
X422 VPWR _28_.A _28_.Y VPWR sky130_fd_pr__pfet_01v8_hvt ad=0.26 pd=2.52 as=0.135 ps=1.27 w=1 l=0.15
X423 a_2766_9427# a_3044_9411# a_3000_9295# VPWR sky130_fd_pr__pfet_01v8_hvt ad=0.0588 pd=0.7 as=0.0567 ps=0.69 w=0.42 l=0.15
X424 _45_.A a_7539_7637# VGND VGND sky130_fd_pr__nfet_01v8 ad=0.08775 pd=0.92 as=0.2087 ps=2.02 w=0.65 l=0.15
X425 _32_.Y _32_.A VGND VGND sky130_fd_pr__nfet_01v8 ad=0.08775 pd=0.92 as=0.169 ps=1.82 w=0.65 l=0.15
X426 a_5389_7119# _41_.B1 VPWR VPWR sky130_fd_pr__pfet_01v8_hvt ad=0.1125 pd=1.225 as=0.165 ps=1.33 w=1 l=0.15
X427 a_1835_4373# a_2122_4651# VPWR VPWR sky130_fd_pr__pfet_01v8_hvt ad=0.0567 pd=0.69 as=0.1134 ps=1.38 w=0.42 l=0.15
X428 a_4510_3311# u_loop.u_d0.A prenl VGND sky130_fd_pr__nfet_01v8 ad=0.091 pd=0.93 as=0.091 ps=0.93 w=0.65 l=0.15
X429 VPWR VGND VPWR VPWR sky130_fd_pr__pfet_01v8_hvt ad=0.2262 pd=2.26 as=0 ps=0 w=0.87 l=0.59
X430 a_5293_7439# _39_.B2 a_5377_7439# VGND sky130_fd_pr__nfet_01v8 ad=0.169 pd=1.82 as=0.08775 ps=0.92 w=0.65 l=0.15
X431 _28_.A a_3491_5247# VPWR VPWR sky130_fd_pr__pfet_01v8_hvt ad=0.135 pd=1.27 as=0.3012 ps=2.66 w=1 l=0.15
X432 VPWR VGND VPWR VPWR sky130_fd_pr__pfet_01v8_hvt ad=0.2262 pd=2.26 as=0 ps=0 w=0.87 l=0.59
X433 a_6904_8751# a_5823_8751# a_6557_8993# VPWR sky130_fd_pr__pfet_01v8_hvt ad=0.0588 pd=0.7 as=0.12915 ps=1.185 w=0.42 l=0.15
X434 VPWR a_7364_7663# a_7539_7637# VPWR sky130_fd_pr__pfet_01v8_hvt ad=0.1134 pd=1.38 as=0.0567 ps=0.69 w=0.42 l=0.15
X435 VGND _52_.Y a_2143_6037# VGND sky130_fd_pr__nfet_01v8 ad=0.0567 pd=0.69 as=0.1092 ps=1.36 w=0.42 l=0.15
X436 VPWR VGND VPWR VPWR sky130_fd_pr__pfet_01v8_hvt ad=0.2262 pd=2.26 as=0 ps=0 w=0.87 l=0.59
X437 VGND VPWR VGND VGND sky130_fd_pr__nfet_01v8 ad=0.143 pd=1.62 as=0 ps=0 w=0.55 l=0.59
X438 VGND VPWR VGND VGND sky130_fd_pr__nfet_01v8 ad=0.143 pd=1.62 as=0 ps=0 w=0.55 l=0.59
X439 VGND _39_.B2 _21_.Y VGND sky130_fd_pr__nfet_01v8 ad=0.169 pd=1.82 as=0.08775 ps=0.92 w=0.65 l=0.15
X440 a_6704_7663# _22_.Y VPWR VPWR sky130_fd_pr__pfet_01v8_hvt ad=0.0651 pd=0.73 as=0.1092 ps=1.36 w=0.42 l=0.15
X441 VPWR VGND VPWR VPWR sky130_fd_pr__pfet_01v8_hvt ad=0.2262 pd=2.26 as=0 ps=0 w=0.87 l=0.59
X442 VPWR VGND VPWR VPWR sky130_fd_pr__pfet_01v8_hvt ad=0.2262 pd=2.26 as=0 ps=0 w=0.87 l=0.59
X443 _53_.Y _53_.A VPWR VPWR sky130_fd_pr__pfet_01v8_hvt ad=0.135 pd=1.27 as=0.26 ps=2.52 w=1 l=0.15
X444 VPWR _68_.D sky130_fd_pr__res_generic_po w=0.48 l=0.045
X445 VPWR _45_.A _57_.CLK VPWR sky130_fd_pr__pfet_01v8_hvt ad=0.26 pd=2.52 as=0.135 ps=1.27 w=1 l=0.15
X446 VGND VPWR VGND VGND sky130_fd_pr__nfet_01v8 ad=0.143 pd=1.62 as=0 ps=0 w=0.55 l=0.59
X447 a_4075_6825# src[0] VPWR VPWR sky130_fd_pr__pfet_01v8_hvt ad=0.135 pd=1.27 as=0.135 ps=1.27 w=1 l=0.15
X448 VPWR a_2769_2223# a_2875_2223# VPWR sky130_fd_pr__pfet_01v8_hvt ad=0.14075 pd=1.325 as=0.1092 ps=1.36 w=0.42 l=0.5
X449 prenl u_loop.u_d0.A a_4510_3311# VGND sky130_fd_pr__nfet_01v8 ad=0.091 pd=0.93 as=0.091 ps=0.93 w=0.65 l=0.15
X450 a_2801_9661# a_2766_9427# a_2479_9269# VGND sky130_fd_pr__nfet_01v8 ad=0.06405 pd=0.725 as=0.1092 ps=1.36 w=0.42 l=0.15
X451 a_3477_9661# u_loop.u_gh.C VGND VGND sky130_fd_pr__nfet_01v8 ad=0.0441 pd=0.63 as=0.1346 ps=1.15 w=0.42 l=0.15
X452 VGND VPWR VGND VGND sky130_fd_pr__nfet_01v8 ad=0.143 pd=1.62 as=0 ps=0 w=0.55 l=0.59
X453 VGND src[1] a_3348_7235# VGND sky130_fd_pr__nfet_01v8 ad=0.10187 pd=0.99 as=0.0567 ps=0.69 w=0.42 l=0.15
X454 a_2659_6409# a_2143_6037# a_2564_6397# VGND sky130_fd_pr__special_nfet_01v8 ad=0.0594 pd=0.69 as=0.066 ps=0.745 w=0.36 l=0.15
X455 a_6891_6409# a_6375_6037# a_6796_6397# VGND sky130_fd_pr__special_nfet_01v8 ad=0.0594 pd=0.69 as=0.066 ps=0.745 w=0.36 l=0.15
X456 VGND VPWR VGND VGND sky130_fd_pr__nfet_01v8 ad=0.143 pd=1.62 as=0 ps=0 w=0.55 l=0.59
X457 VGND VPWR VGND VGND sky130_fd_pr__nfet_01v8 ad=0.143 pd=1.62 as=0 ps=0 w=0.55 l=0.59
X458 VPWR VGND VPWR VPWR sky130_fd_pr__pfet_01v8_hvt ad=0.2262 pd=2.26 as=0 ps=0 w=0.87 l=0.59
X459 a_2877_6005# a_2659_6409# VGND VGND sky130_fd_pr__nfet_01v8 ad=0.0999 pd=0.985 as=0.1346 ps=1.15 w=0.64 l=0.15
X460 VGND _53_.Y a_2235_4949# VGND sky130_fd_pr__nfet_01v8 ad=0.0567 pd=0.69 as=0.1092 ps=1.36 w=0.42 l=0.15
X461 VGND _56_.Q _55_.CLK VGND sky130_fd_pr__nfet_01v8 ad=0.169 pd=1.82 as=0.08775 ps=0.92 w=0.65 l=0.15
X462 a_8643_5247# u_loop.u_gh.C VPWR VPWR sky130_fd_pr__pfet_01v8_hvt ad=0.0567 pd=0.69 as=0.0819 ps=0.81 w=0.42 l=0.15
X463 VGND VPWR VGND VGND sky130_fd_pr__nfet_01v8 ad=0.143 pd=1.62 as=0 ps=0 w=0.55 l=0.59
X464 VGND VPWR VGND VGND sky130_fd_pr__nfet_01v8 ad=0.143 pd=1.62 as=0 ps=0 w=0.55 l=0.59
X465 a_3802_9295# a_3083_9537# a_3239_9269# VGND sky130_fd_pr__special_nfet_01v8 ad=0.066 pd=0.745 as=0.0594 ps=0.69 w=0.36 l=0.15
X466 VPWR _41_.X a_6927_5487# VPWR sky130_fd_pr__pfet_01v8_hvt ad=0.0864 pd=0.91 as=0.1664 ps=1.8 w=0.64 l=0.15
X467 VGND VPWR VGND VGND sky130_fd_pr__nfet_01v8 ad=0.143 pd=1.62 as=0 ps=0 w=0.55 l=0.59
X468 VGND VPWR VGND VGND sky130_fd_pr__nfet_01v8 ad=0.143 pd=1.62 as=0 ps=0 w=0.55 l=0.59
X469 a_2125_2767# a_1889_2767# VPWR VPWR sky130_fd_pr__pfet_01v8_hvt ad=0.1092 pd=1.36 as=0.0567 ps=0.69 w=0.42 l=0.5
X470 u_loop.u_gl.B1 u_loop.u_gh.C VGND VGND sky130_fd_pr__nfet_01v8 ad=0.169 pd=1.82 as=0.169 ps=1.82 w=0.65 l=0.15
X471 VPWR _63_.Q _50_.Y VPWR sky130_fd_pr__pfet_01v8_hvt ad=0.26 pd=2.52 as=0.135 ps=1.27 w=1 l=0.15
X472 VGND _46_.A _31_.Y VGND sky130_fd_pr__nfet_01v8 ad=0.169 pd=1.82 as=0.08775 ps=0.92 w=0.65 l=0.15
X473 VPWR VGND VPWR VPWR sky130_fd_pr__pfet_01v8_hvt ad=0.2262 pd=2.26 as=0 ps=0 w=0.87 l=0.59
X474 VGND VPWR VGND VGND sky130_fd_pr__nfet_01v8 ad=0.143 pd=1.62 as=0 ps=0 w=0.55 l=0.59
X475 u_loop.u_d3.X a_3703_2767# VPWR VPWR sky130_fd_pr__pfet_01v8_hvt ad=0.26 pd=2.52 as=0.14075 ps=1.325 w=1 l=0.15
X476 prenh u_loop.u_gh.B VPWR VPWR sky130_fd_pr__pfet_01v8_hvt ad=0.135 pd=1.27 as=0.135 ps=1.27 w=1 l=0.15
X477 VGND VPWR VGND VGND sky130_fd_pr__nfet_01v8 ad=0.143 pd=1.62 as=0 ps=0 w=0.55 l=0.59
X478 a_3514_7235# _64_.Q a_3430_7235# VPWR sky130_fd_pr__pfet_01v8_hvt ad=0.0567 pd=0.69 as=0.0567 ps=0.69 w=0.42 l=0.15
X479 VPWR VGND VPWR VPWR sky130_fd_pr__pfet_01v8_hvt ad=0.2262 pd=2.26 as=0 ps=0 w=0.87 l=0.59
X480 a_7364_7663# a_6283_7663# a_7017_7905# VPWR sky130_fd_pr__pfet_01v8_hvt ad=0.0588 pd=0.7 as=0.12915 ps=1.185 w=0.42 l=0.15
X481 VPWR src[1] a_4158_7235# VPWR sky130_fd_pr__pfet_01v8_hvt ad=0.14825 pd=1.34 as=0.0567 ps=0.69 w=0.42 l=0.15
X482 a_2769_2223# a_2533_2223# VPWR VPWR sky130_fd_pr__pfet_01v8_hvt ad=0.1092 pd=1.36 as=0.0567 ps=0.69 w=0.42 l=0.5
X483 a_2439_4541# u_loop.u_d0.A VPWR VPWR sky130_fd_pr__pfet_01v8_hvt ad=0.1664 pd=1.8 as=0.0864 ps=0.91 w=0.64 l=0.15
X484 VPWR VGND VPWR VPWR sky130_fd_pr__pfet_01v8_hvt ad=0.2262 pd=2.26 as=0 ps=0 w=0.87 l=0.59
X485 VPWR VGND VPWR VPWR sky130_fd_pr__pfet_01v8_hvt ad=0.2262 pd=2.26 as=0 ps=0 w=0.87 l=0.59
X486 VGND u_loop.u_d0.A u_loop.u_q.B VGND sky130_fd_pr__nfet_01v8 ad=0.169 pd=1.82 as=0.08775 ps=0.92 w=0.65 l=0.15
X487 VPWR _25_.A a_5649_5737# VPWR sky130_fd_pr__pfet_01v8_hvt ad=0.165 pd=1.33 as=0.105 ps=1.21 w=1 l=0.15
X488 _55_.CLK _56_.Q VPWR VPWR sky130_fd_pr__pfet_01v8_hvt ad=0.135 pd=1.27 as=0.26 ps=2.52 w=1 l=0.15
X489 VPWR VGND VPWR VPWR sky130_fd_pr__pfet_01v8_hvt ad=0.2262 pd=2.26 as=0 ps=0 w=0.87 l=0.59
X490 _46_.A a_7079_8725# VGND VGND sky130_fd_pr__nfet_01v8 ad=0.08775 pd=0.92 as=0.2087 ps=2.02 w=0.65 l=0.15
X491 VGND src[0] a_4518_6575# VGND sky130_fd_pr__nfet_01v8 ad=0.08775 pd=0.92 as=0.169 ps=1.82 w=0.65 l=0.15
X492 a_8643_5247# a_8468_5321# a_8822_5309# VGND sky130_fd_pr__nfet_01v8 ad=0.1092 pd=1.36 as=0.06405 ps=0.725 w=0.42 l=0.15
X493 VPWR VGND VPWR VPWR sky130_fd_pr__pfet_01v8_hvt ad=0.2262 pd=2.26 as=0 ps=0 w=0.87 l=0.59
X494 VGND VPWR VGND VGND sky130_fd_pr__nfet_01v8 ad=0.143 pd=1.62 as=0 ps=0 w=0.55 l=0.59
X495 VPWR VGND VPWR VPWR sky130_fd_pr__pfet_01v8_hvt ad=0.2262 pd=2.26 as=0 ps=0 w=0.87 l=0.59
X496 VGND VPWR VGND VGND sky130_fd_pr__nfet_01v8 ad=0.143 pd=1.62 as=0 ps=0 w=0.55 l=0.59
X497 VPWR a_6904_8751# a_7079_8725# VPWR sky130_fd_pr__pfet_01v8_hvt ad=0.1134 pd=1.38 as=0.0567 ps=0.69 w=0.42 l=0.15
X498 VGND VPWR VGND VGND sky130_fd_pr__nfet_01v8 ad=0.143 pd=1.62 as=0 ps=0 w=0.55 l=0.59
X499 a_8822_7485# u_loop.u_gh.C VGND VGND sky130_fd_pr__nfet_01v8 ad=0.06405 pd=0.725 as=0.12495 ps=1.015 w=0.42 l=0.15
X500 VGND VPWR VGND VGND sky130_fd_pr__nfet_01v8 ad=0.143 pd=1.62 as=0 ps=0 w=0.55 l=0.59
X501 _27_.Y _53_.A VPWR VPWR sky130_fd_pr__pfet_01v8_hvt ad=0.135 pd=1.27 as=0.26 ps=2.52 w=1 l=0.15
X502 a_6553_4399# a_5363_4399# a_6444_4399# VGND sky130_fd_pr__special_nfet_01v8 ad=0.0669 pd=0.75 as=0.0711 ps=0.755 w=0.36 l=0.15
X503 a_2859_4943# u_loop.u_gh.C VPWR VPWR sky130_fd_pr__pfet_01v8_hvt ad=0.1092 pd=1.36 as=0.07035 ps=0.755 w=0.42 l=0.15
X504 _20_.Y pre VPWR VPWR sky130_fd_pr__pfet_01v8_hvt ad=0.135 pd=1.27 as=0.26 ps=2.52 w=1 l=0.15
X505 VPWR a_8643_5247# a_8630_4943# VPWR sky130_fd_pr__pfet_01v8_hvt ad=0.0819 pd=0.81 as=0.0567 ps=0.69 w=0.42 l=0.15
X506 VGND VPWR VGND VGND sky130_fd_pr__nfet_01v8 ad=0.143 pd=1.62 as=0 ps=0 w=0.55 l=0.59
X507 a_3170_9295# a_3044_9411# a_2766_9427# VGND sky130_fd_pr__special_nfet_01v8 ad=0.0999 pd=0.985 as=0.0711 ps=0.755 w=0.36 l=0.15
X508 VGND _30_.A _48_.Y VGND sky130_fd_pr__nfet_01v8 ad=0.169 pd=1.82 as=0.08775 ps=0.92 w=0.65 l=0.15
X509 VGND a_2755_7637# _63_.Q VGND sky130_fd_pr__nfet_01v8 ad=0.169 pd=1.82 as=0.08775 ps=0.92 w=0.65 l=0.15
X510 VGND a_7631_6335# _32_.A VGND sky130_fd_pr__nfet_01v8 ad=0.169 pd=1.82 as=0.08775 ps=0.92 w=0.65 l=0.15
X511 _28_.Y _28_.A VGND VGND sky130_fd_pr__nfet_01v8 ad=0.08775 pd=0.92 as=0.169 ps=1.82 w=0.65 l=0.15
X512 VPWR VGND VPWR VPWR sky130_fd_pr__pfet_01v8_hvt ad=0.2262 pd=2.26 as=0 ps=0 w=0.87 l=0.59
X513 VGND VPWR VGND VGND sky130_fd_pr__nfet_01v8 ad=0.143 pd=1.62 as=0 ps=0 w=0.55 l=0.59
X514 a_6244_8751# _31_.Y VPWR VPWR sky130_fd_pr__pfet_01v8_hvt ad=0.0651 pd=0.73 as=0.1092 ps=1.36 w=0.42 l=0.15
X515 a_5377_7439# _36_.A VGND VGND sky130_fd_pr__nfet_01v8 ad=0.08775 pd=0.92 as=0.169 ps=1.82 w=0.65 l=0.15
X516 VPWR a_3316_5321# a_3491_5247# VPWR sky130_fd_pr__pfet_01v8_hvt ad=0.1134 pd=1.38 as=0.0567 ps=0.69 w=0.42 l=0.15
X517 a_6798_4399# u_loop.u_gh.C VGND VGND sky130_fd_pr__nfet_01v8 ad=0.06405 pd=0.725 as=0.12495 ps=1.015 w=0.42 l=0.15
X518 a_5975_4399# a_5529_4399# a_5879_4399# VGND sky130_fd_pr__special_nfet_01v8 ad=0.1401 pd=1.1 as=0.0594 ps=0.69 w=0.36 l=0.15
X519 a_5786_9661# u_loop.u_gh.C VGND VGND sky130_fd_pr__nfet_01v8 ad=0.06405 pd=0.725 as=0.12495 ps=1.015 w=0.42 l=0.15
X520 a_7661_5729# a_7443_5487# VPWR VPWR sky130_fd_pr__pfet_01v8_hvt ad=0.12915 pd=1.185 as=0.2184 ps=2.2 w=0.84 l=0.15
X521 VGND VPWR VGND VGND sky130_fd_pr__nfet_01v8 ad=0.143 pd=1.62 as=0 ps=0 w=0.55 l=0.59
X522 VPWR VGND VPWR VPWR sky130_fd_pr__pfet_01v8_hvt ad=0.2262 pd=2.26 as=0 ps=0 w=0.87 l=0.59
X523 VGND VPWR VGND VGND sky130_fd_pr__nfet_01v8 ad=0.143 pd=1.62 as=0 ps=0 w=0.55 l=0.59
X524 VPWR VGND VPWR VPWR sky130_fd_pr__pfet_01v8_hvt ad=0.2262 pd=2.26 as=0 ps=0 w=0.87 l=0.59
X525 VGND _42_.Y a_7387_4949# VGND sky130_fd_pr__nfet_01v8 ad=0.0567 pd=0.69 as=0.1092 ps=1.36 w=0.42 l=0.15
X526 a_3170_9295# a_3083_9537# a_2766_9427# VPWR sky130_fd_pr__pfet_01v8_hvt ad=0.12915 pd=1.185 as=0.0588 ps=0.7 w=0.42 l=0.15
X527 VGND VPWR VGND VGND sky130_fd_pr__nfet_01v8 ad=0.143 pd=1.62 as=0 ps=0 w=0.55 l=0.59
X528 _25_.Y _25_.A VGND VGND sky130_fd_pr__nfet_01v8 ad=0.08775 pd=0.92 as=0.169 ps=1.82 w=0.65 l=0.15
X529 a_5293_7439# _38_.X a_5190_7439# VGND sky130_fd_pr__nfet_01v8 ad=0.08775 pd=0.92 as=0.23725 ps=2.03 w=0.65 l=0.15
X530 a_2656_5309# _28_.Y VPWR VPWR sky130_fd_pr__pfet_01v8_hvt ad=0.0651 pd=0.73 as=0.1092 ps=1.36 w=0.42 l=0.15
X531 VPWR u_loop.u_d6.X a_6397_2767# VPWR sky130_fd_pr__pfet_01v8_hvt ad=0.0567 pd=0.69 as=0.1092 ps=1.36 w=0.42 l=0.15
X532 VPWR VGND VPWR VPWR sky130_fd_pr__pfet_01v8_hvt ad=0.2262 pd=2.26 as=0 ps=0 w=0.87 l=0.59
X533 VGND u_loop.u_gl.A2 a_4510_3311# VGND sky130_fd_pr__nfet_01v8 ad=0.091 pd=0.93 as=0.091 ps=0.93 w=0.65 l=0.15
X534 VGND VPWR VGND VGND sky130_fd_pr__nfet_01v8 ad=0.143 pd=1.62 as=0 ps=0 w=0.55 l=0.59
X535 a_2015_7663# a_1499_7663# a_1920_7663# VGND sky130_fd_pr__special_nfet_01v8 ad=0.0594 pd=0.69 as=0.066 ps=0.745 w=0.36 l=0.15
X536 VPWR VGND VPWR VPWR sky130_fd_pr__pfet_01v8_hvt ad=0.2262 pd=2.26 as=0 ps=0 w=0.87 l=0.59
X537 VGND VPWR VGND VGND sky130_fd_pr__nfet_01v8 ad=0.143 pd=1.62 as=0 ps=0 w=0.55 l=0.59
X538 VGND VPWR VGND VGND sky130_fd_pr__nfet_01v8 ad=0.143 pd=1.62 as=0 ps=0 w=0.55 l=0.59
X539 VGND u_loop.u_d1.X a_2625_2767# VGND sky130_fd_pr__nfet_01v8 ad=0.0567 pd=0.69 as=0.1092 ps=1.36 w=0.42 l=0.15
X540 a_2564_6397# _64_.D VGND VGND sky130_fd_pr__nfet_01v8 ad=0.066 pd=0.745 as=0.2205 ps=1.89 w=0.42 l=0.15
X541 VGND VPWR VGND VGND sky130_fd_pr__nfet_01v8 ad=0.143 pd=1.62 as=0 ps=0 w=0.55 l=0.59
X542 VPWR VGND VPWR VPWR sky130_fd_pr__pfet_01v8_hvt ad=0.2262 pd=2.26 as=0 ps=0 w=0.87 l=0.59
X543 _70_.LO VGND sky130_fd_pr__res_generic_po w=0.48 l=0.045
X544 a_6541_6037# a_6375_6037# VGND VGND sky130_fd_pr__nfet_01v8 ad=0.1092 pd=1.36 as=0.0567 ps=0.69 w=0.42 l=0.15
X545 VGND VPWR VGND VGND sky130_fd_pr__nfet_01v8 ad=0.143 pd=1.62 as=0 ps=0 w=0.55 l=0.59
X546 VPWR a_8008_5487# a_8183_5461# VPWR sky130_fd_pr__pfet_01v8_hvt ad=0.1134 pd=1.38 as=0.0567 ps=0.69 w=0.42 l=0.15
X547 VPWR VGND VPWR VPWR sky130_fd_pr__pfet_01v8_hvt ad=0.2262 pd=2.26 as=0 ps=0 w=0.87 l=0.59
X548 VPWR VGND VPWR VPWR sky130_fd_pr__pfet_01v8_hvt ad=0.2262 pd=2.26 as=0 ps=0 w=0.87 l=0.59
X549 VGND VPWR VGND VGND sky130_fd_pr__nfet_01v8 ad=0.143 pd=1.62 as=0 ps=0 w=0.55 l=0.59
X550 VPWR VGND VPWR VPWR sky130_fd_pr__pfet_01v8_hvt ad=0.2262 pd=2.26 as=0 ps=0 w=0.87 l=0.59
X551 VPWR VGND VPWR VPWR sky130_fd_pr__pfet_01v8_hvt ad=0.2262 pd=2.26 as=0 ps=0 w=0.87 l=0.59
X552 a_4333_2767# a_4097_2767# VGND VGND sky130_fd_pr__nfet_01v8 ad=0.1092 pd=1.36 as=0.0567 ps=0.69 w=0.42 l=0.5
X553 VGND VPWR VGND VGND sky130_fd_pr__nfet_01v8 ad=0.143 pd=1.62 as=0 ps=0 w=0.55 l=0.59
X554 a_3227_8207# u_loop.u_gh.C VPWR VPWR sky130_fd_pr__pfet_01v8_hvt ad=0.1092 pd=1.36 as=0.07035 ps=0.755 w=0.42 l=0.15
X555 a_2233_7905# a_2015_7663# VGND VGND sky130_fd_pr__nfet_01v8 ad=0.0999 pd=0.985 as=0.1346 ps=1.15 w=0.64 l=0.15
X556 VGND VPWR VGND VGND sky130_fd_pr__nfet_01v8 ad=0.143 pd=1.62 as=0 ps=0 w=0.55 l=0.59
X557 a_7553_7125# a_7387_7125# VPWR VPWR sky130_fd_pr__pfet_01v8_hvt ad=0.1664 pd=1.8 as=0.0864 ps=0.91 w=0.64 l=0.15
X558 _41_.X a_5190_5487# VGND VGND sky130_fd_pr__nfet_01v8 ad=0.08775 pd=0.92 as=0.08775 ps=0.92 w=0.65 l=0.15
X559 xb a_8183_5461# VGND VGND sky130_fd_pr__nfet_01v8 ad=0.08775 pd=0.92 as=0.2087 ps=2.02 w=0.65 l=0.15
X560 VGND VPWR VGND VGND sky130_fd_pr__nfet_01v8 ad=0.143 pd=1.62 as=0 ps=0 w=0.55 l=0.59
X561 a_4510_3311# u_loop.u_d0.A prenl VGND sky130_fd_pr__nfet_01v8 ad=0.091 pd=0.93 as=0.091 ps=0.93 w=0.65 l=0.15
X562 VGND u_loop.u_gh.C a_4351_4175# VGND sky130_fd_pr__nfet_01v8 ad=0.08775 pd=0.92 as=0.08775 ps=0.92 w=0.65 l=0.15
X563 a_3992_7235# _40_.B VGND VGND sky130_fd_pr__nfet_01v8 ad=0.0567 pd=0.69 as=0.0567 ps=0.69 w=0.42 l=0.15
X564 a_8011_4943# u_loop.u_gh.C VPWR VPWR sky130_fd_pr__pfet_01v8_hvt ad=0.1092 pd=1.36 as=0.07035 ps=0.755 w=0.42 l=0.15
X565 VPWR VGND VPWR VPWR sky130_fd_pr__pfet_01v8_hvt ad=0.2262 pd=2.26 as=0 ps=0 w=0.87 l=0.59
X566 VGND VPWR VGND VGND sky130_fd_pr__nfet_01v8 ad=0.143 pd=1.62 as=0 ps=0 w=0.55 l=0.59
X567 VPWR VGND VPWR VPWR sky130_fd_pr__pfet_01v8_hvt ad=0.2262 pd=2.26 as=0 ps=0 w=0.87 l=0.59
X568 a_2656_5309# _28_.Y VGND VGND sky130_fd_pr__nfet_01v8 ad=0.066 pd=0.745 as=0.2205 ps=1.89 w=0.42 l=0.15
X569 VGND VPWR VGND VGND sky130_fd_pr__nfet_01v8 ad=0.143 pd=1.62 as=0 ps=0 w=0.55 l=0.59
X570 VGND a_3388_7351# a_3348_7235# VGND sky130_fd_pr__nfet_01v8 ad=0.0567 pd=0.69 as=0.1092 ps=1.36 w=0.42 l=0.15
X571 VPWR u_loop.u_gh.C a_3384_9295# VPWR sky130_fd_pr__pfet_01v8_hvt ad=0.07035 pd=0.755 as=0.1092 ps=1.36 w=0.42 l=0.15
X572 a_7526_8029# a_6449_7663# a_7364_7663# VPWR sky130_fd_pr__pfet_01v8_hvt ad=0.0567 pd=0.69 as=0.0588 ps=0.7 w=0.42 l=0.15
X573 VGND a_3348_7235# _38_.X VGND sky130_fd_pr__nfet_01v8 ad=0.10025 pd=0.985 as=0.08775 ps=0.92 w=0.65 l=0.15
X574 VPWR VGND VPWR VPWR sky130_fd_pr__pfet_01v8_hvt ad=0.2262 pd=2.26 as=0 ps=0 w=0.87 l=0.59
X575 VGND VPWR VGND VGND sky130_fd_pr__nfet_01v8 ad=0.143 pd=1.62 as=0 ps=0 w=0.55 l=0.59
X576 VGND VPWR VGND VGND sky130_fd_pr__nfet_01v8 ad=0.143 pd=1.62 as=0 ps=0 w=0.55 l=0.59
X577 VGND u_loop.u_gh.C a_7705_5487# VGND sky130_fd_pr__nfet_01v8 ad=0.1346 pd=1.15 as=0.0441 ps=0.63 w=0.42 l=0.15
X578 VPWR VGND VPWR VPWR sky130_fd_pr__pfet_01v8_hvt ad=0.2262 pd=2.26 as=0 ps=0 w=0.87 l=0.59
X579 prenh u_loop.u_gh.B VPWR VPWR sky130_fd_pr__pfet_01v8_hvt ad=0.135 pd=1.27 as=0.135 ps=1.27 w=1 l=0.15
X580 VPWR u_loop.u_d4.X a_4833_2767# VPWR sky130_fd_pr__pfet_01v8_hvt ad=0.0567 pd=0.69 as=0.1092 ps=1.36 w=0.42 l=0.15
X581 a_4074_7235# a_4032_7351# a_3992_7235# VPWR sky130_fd_pr__pfet_01v8_hvt ad=0.0567 pd=0.69 as=0.1092 ps=1.36 w=0.42 l=0.15
X582 VPWR VGND VPWR VPWR sky130_fd_pr__pfet_01v8_hvt ad=0.2262 pd=2.26 as=0 ps=0 w=0.87 l=0.59
X583 VGND _64_.Q _51_.Y VGND sky130_fd_pr__nfet_01v8 ad=0.169 pd=1.82 as=0.08775 ps=0.92 w=0.65 l=0.15
X584 VGND VPWR VGND VGND sky130_fd_pr__nfet_01v8 ad=0.143 pd=1.62 as=0 ps=0 w=0.55 l=0.59
X585 VGND VPWR VGND VGND sky130_fd_pr__nfet_01v8 ad=0.143 pd=1.62 as=0 ps=0 w=0.55 l=0.59
X586 _47_.Y _39_.B2 VGND VGND sky130_fd_pr__nfet_01v8 ad=0.08775 pd=0.92 as=0.169 ps=1.82 w=0.65 l=0.15
X587 VGND VPWR VGND VGND sky130_fd_pr__nfet_01v8 ad=0.143 pd=1.62 as=0 ps=0 w=0.55 l=0.59
X588 VPWR VGND VPWR VPWR sky130_fd_pr__pfet_01v8_hvt ad=0.2262 pd=2.26 as=0 ps=0 w=0.87 l=0.59
X589 VPWR _45_.A a_5649_7119# VPWR sky130_fd_pr__pfet_01v8_hvt ad=0.165 pd=1.33 as=0.105 ps=1.21 w=1 l=0.15
X590 VGND VPWR VGND VGND sky130_fd_pr__nfet_01v8 ad=0.143 pd=1.62 as=0 ps=0 w=0.55 l=0.59
X591 VGND VPWR VGND VGND sky130_fd_pr__nfet_01v8 ad=0.143 pd=1.62 as=0 ps=0 w=0.55 l=0.59
X592 VPWR VGND VPWR VPWR sky130_fd_pr__pfet_01v8_hvt ad=0.2262 pd=2.26 as=0 ps=0 w=0.87 l=0.59
X593 VPWR a_3083_9537# a_3044_9411# VPWR sky130_fd_pr__pfet_01v8_hvt ad=0.0864 pd=0.91 as=0.1664 ps=1.8 w=0.64 l=0.15
X594 a_3684_8585# a_2769_8213# a_3337_8181# VGND sky130_fd_pr__special_nfet_01v8 ad=0.0711 pd=0.755 as=0.0999 ps=0.985 w=0.36 l=0.15
X595 VPWR src[1] _36_.A VPWR sky130_fd_pr__pfet_01v8_hvt ad=0.275 pd=2.55 as=0.135 ps=1.27 w=1 l=0.15
X596 VPWR VGND VPWR VPWR sky130_fd_pr__pfet_01v8_hvt ad=0.2262 pd=2.26 as=0 ps=0 w=0.87 l=0.59
X597 VPWR _57_.CLK a_6375_6037# VPWR sky130_fd_pr__pfet_01v8_hvt ad=0.0864 pd=0.91 as=0.1664 ps=1.8 w=0.64 l=0.15
X598 VGND VPWR VGND VGND sky130_fd_pr__nfet_01v8 ad=0.143 pd=1.62 as=0 ps=0 w=0.55 l=0.59
X599 VGND a_7907_4159# _55_.Q VGND sky130_fd_pr__nfet_01v8 ad=0.169 pd=1.82 as=0.08775 ps=0.92 w=0.65 l=0.15
X600 VPWR _25_.A _25_.Y VPWR sky130_fd_pr__pfet_01v8_hvt ad=0.26 pd=2.52 as=0.135 ps=1.27 w=1 l=0.15
X601 a_2877_6005# a_2659_6409# VPWR VPWR sky130_fd_pr__pfet_01v8_hvt ad=0.12915 pd=1.185 as=0.2184 ps=2.2 w=0.84 l=0.15
X602 a_1654_6575# src[1] VGND VGND sky130_fd_pr__nfet_01v8 ad=0.091 pd=0.93 as=0.16535 ps=1.82 w=0.65 l=0.15
X603 a_4160_6575# src[1] VGND VGND sky130_fd_pr__nfet_01v8 ad=0.08775 pd=0.92 as=0.08775 ps=0.92 w=0.65 l=0.15
X604 VPWR VGND VPWR VPWR sky130_fd_pr__pfet_01v8_hvt ad=0.2262 pd=2.26 as=0 ps=0 w=0.87 l=0.59
X605 VPWR VGND VPWR VPWR sky130_fd_pr__pfet_01v8_hvt ad=0.2262 pd=2.26 as=0 ps=0 w=0.87 l=0.59
X606 VPWR VGND VPWR VPWR sky130_fd_pr__pfet_01v8_hvt ad=0.2262 pd=2.26 as=0 ps=0 w=0.87 l=0.59
X607 a_6444_4399# a_5363_4399# a_6097_4641# VPWR sky130_fd_pr__pfet_01v8_hvt ad=0.0588 pd=0.7 as=0.12915 ps=1.185 w=0.42 l=0.15
X608 VPWR VGND VPWR VPWR sky130_fd_pr__pfet_01v8_hvt ad=0.2262 pd=2.26 as=0 ps=0 w=0.87 l=0.59
X609 VGND VPWR VGND VGND sky130_fd_pr__nfet_01v8 ad=0.143 pd=1.62 as=0 ps=0 w=0.55 l=0.59
X610 a_7903_5321# a_7387_4949# a_7808_5309# VGND sky130_fd_pr__special_nfet_01v8 ad=0.0594 pd=0.69 as=0.066 ps=0.745 w=0.36 l=0.15
X611 a_8086_4221# u_loop.u_gh.C VGND VGND sky130_fd_pr__nfet_01v8 ad=0.06405 pd=0.725 as=0.12495 ps=1.015 w=0.42 l=0.15
X612 a_2123_8029# u_loop.u_gh.C VPWR VPWR sky130_fd_pr__pfet_01v8_hvt ad=0.1092 pd=1.36 as=0.07035 ps=0.755 w=0.42 l=0.15
X613 VPWR a_2580_7663# a_2755_7637# VPWR sky130_fd_pr__pfet_01v8_hvt ad=0.1134 pd=1.38 as=0.0567 ps=0.69 w=0.42 l=0.15
X614 a_2580_7663# a_1665_7663# a_2233_7905# VGND sky130_fd_pr__special_nfet_01v8 ad=0.0711 pd=0.755 as=0.0999 ps=0.985 w=0.36 l=0.15
X615 VPWR VGND VPWR VPWR sky130_fd_pr__pfet_01v8_hvt ad=0.2262 pd=2.26 as=0 ps=0 w=0.87 l=0.59
X616 u_loop.u_s2.A u_loop.u_cmp.Y VGND VGND sky130_fd_pr__nfet_01v8 ad=0.169 pd=1.82 as=0.169 ps=1.82 w=0.65 l=0.15
X617 a_3224_6409# a_2143_6037# a_2877_6005# VPWR sky130_fd_pr__pfet_01v8_hvt ad=0.0588 pd=0.7 as=0.12915 ps=1.185 w=0.42 l=0.15
X618 _67_.D VPWR sky130_fd_pr__res_generic_po w=0.48 l=0.045
X619 VGND u_loop.u_gh.C a_2157_4399# VGND sky130_fd_pr__nfet_01v8 ad=0.12495 pd=1.015 as=0.06405 ps=0.725 w=0.42 l=0.15
X620 VPWR _63_.Q _63_.D VPWR sky130_fd_pr__pfet_01v8_hvt ad=0.26 pd=2.52 as=0.135 ps=1.27 w=1 l=0.15
X621 VGND src[0] a_4167_6147# VGND sky130_fd_pr__nfet_01v8 ad=0.194 pd=1.95 as=0.1092 ps=1.36 w=0.42 l=0.15
X622 VGND VPWR VGND VGND sky130_fd_pr__nfet_01v8 ad=0.143 pd=1.62 as=0 ps=0 w=0.55 l=0.59
X623 VGND a_8643_7423# xa VGND sky130_fd_pr__nfet_01v8 ad=0.169 pd=1.82 as=0.08775 ps=0.92 w=0.65 l=0.15
X624 VGND VPWR VGND VGND sky130_fd_pr__nfet_01v8 ad=0.143 pd=1.62 as=0 ps=0 w=0.55 l=0.59
X625 VPWR VGND VPWR VPWR sky130_fd_pr__pfet_01v8_hvt ad=0.2262 pd=2.26 as=0 ps=0 w=0.87 l=0.59
X626 _55_.Q a_7907_4159# VPWR VPWR sky130_fd_pr__pfet_01v8_hvt ad=0.135 pd=1.27 as=0.3012 ps=2.66 w=1 l=0.15
X627 VGND VPWR VGND VGND sky130_fd_pr__nfet_01v8 ad=0.143 pd=1.62 as=0 ps=0 w=0.55 l=0.59
X628 a_4510_3311# u_loop.u_gl.A2 VGND VGND sky130_fd_pr__nfet_01v8 ad=0.091 pd=0.93 as=0.091 ps=0.93 w=0.65 l=0.15
X629 VPWR VGND VPWR VPWR sky130_fd_pr__pfet_01v8_hvt ad=0.2262 pd=2.26 as=0 ps=0 w=0.87 l=0.59
X630 VGND _56_.CLK a_5363_4399# VGND sky130_fd_pr__nfet_01v8 ad=0.0567 pd=0.69 as=0.1092 ps=1.36 w=0.42 l=0.15
X631 VGND _48_.Y a_4351_9301# VGND sky130_fd_pr__nfet_01v8 ad=0.0567 pd=0.69 as=0.1092 ps=1.36 w=0.42 l=0.15
X632 VPWR a_8121_7093# a_8011_7119# VPWR sky130_fd_pr__pfet_01v8_hvt ad=0.07035 pd=0.755 as=0.1155 ps=0.97 w=0.42 l=0.15
X633 VGND a_7631_6335# a_7565_6409# VGND sky130_fd_pr__nfet_01v8 ad=0.12495 pd=1.015 as=0.0669 ps=0.75 w=0.42 l=0.15
X634 VGND VPWR VGND VGND sky130_fd_pr__nfet_01v8 ad=0.143 pd=1.62 as=0 ps=0 w=0.55 l=0.59
X635 VPWR VGND VPWR VPWR sky130_fd_pr__pfet_01v8_hvt ad=0.2262 pd=2.26 as=0 ps=0 w=0.87 l=0.59
X636 a_1920_7663# _63_.D VPWR VPWR sky130_fd_pr__pfet_01v8_hvt ad=0.0651 pd=0.73 as=0.1092 ps=1.36 w=0.42 l=0.15
X637 a_8577_7497# a_7387_7125# a_8468_7497# VGND sky130_fd_pr__special_nfet_01v8 ad=0.0669 pd=0.75 as=0.0711 ps=0.755 w=0.36 l=0.15
X638 VGND a_5607_9599# _39_.B2 VGND sky130_fd_pr__nfet_01v8 ad=0.169 pd=1.82 as=0.08775 ps=0.92 w=0.65 l=0.15
X639 VGND _40_.B _49_.Y VGND sky130_fd_pr__nfet_01v8 ad=0.169 pd=1.82 as=0.08775 ps=0.92 w=0.65 l=0.15
X640 VPWR a_7079_8725# _46_.A VPWR sky130_fd_pr__pfet_01v8_hvt ad=0.26 pd=2.52 as=0.135 ps=1.27 w=1 l=0.15
X641 _63_.D _63_.Q VGND VGND sky130_fd_pr__nfet_01v8 ad=0.08775 pd=0.92 as=0.169 ps=1.82 w=0.65 l=0.15
X642 a_7153_6397# a_7109_6005# a_6987_6409# VGND sky130_fd_pr__nfet_01v8 ad=0.0441 pd=0.63 as=0.1401 ps=1.1 w=0.42 l=0.15
X643 VPWR a_5190_5487# _41_.X VPWR sky130_fd_pr__pfet_01v8_hvt ad=0.26 pd=2.52 as=0.135 ps=1.27 w=1 l=0.15
X644 a_7841_4233# a_6651_3861# a_7732_4233# VGND sky130_fd_pr__special_nfet_01v8 ad=0.0669 pd=0.75 as=0.0711 ps=0.755 w=0.36 l=0.15
X645 VGND VPWR VGND VGND sky130_fd_pr__nfet_01v8 ad=0.143 pd=1.62 as=0 ps=0 w=0.55 l=0.59
X646 a_7066_9117# a_5989_8751# a_6904_8751# VPWR sky130_fd_pr__pfet_01v8_hvt ad=0.0567 pd=0.69 as=0.0588 ps=0.7 w=0.42 l=0.15
X647 u_loop.u_d2.X a_2967_2767# VPWR VPWR sky130_fd_pr__pfet_01v8_hvt ad=0.26 pd=2.52 as=0.14075 ps=1.325 w=1 l=0.15
X648 a_2861_2767# a_2625_2767# VPWR VPWR sky130_fd_pr__pfet_01v8_hvt ad=0.1092 pd=1.36 as=0.0567 ps=0.69 w=0.42 l=0.5
X649 VPWR u_loop.u_gl.A2 a_4076_3561# VPWR sky130_fd_pr__pfet_01v8_hvt ad=0.145 pd=1.29 as=0.155 ps=1.31 w=1 l=0.15
X650 VGND VPWR VGND VGND sky130_fd_pr__nfet_01v8 ad=0.143 pd=1.62 as=0 ps=0 w=0.55 l=0.59
X651 a_3549_9661# a_3170_9295# a_3477_9661# VGND sky130_fd_pr__nfet_01v8 ad=0.1401 pd=1.1 as=0.0441 ps=0.63 w=0.42 l=0.15
X652 a_6999_6031# a_6375_6037# a_6891_6409# VPWR sky130_fd_pr__pfet_01v8_hvt ad=0.1155 pd=0.97 as=0.07245 ps=0.765 w=0.42 l=0.15
X653 VPWR VGND VPWR VPWR sky130_fd_pr__pfet_01v8_hvt ad=0.2262 pd=2.26 as=0 ps=0 w=0.87 l=0.59
X654 VGND a_2595_4636# a_2526_4765# VGND sky130_fd_pr__nfet_01v8 ad=0.1346 pd=1.15 as=0.0999 ps=0.985 w=0.64 l=0.15
X655 a_7999_7497# a_7553_7125# a_7903_7497# VGND sky130_fd_pr__special_nfet_01v8 ad=0.1401 pd=1.1 as=0.0594 ps=0.69 w=0.36 l=0.15
X656 VPWR VGND VPWR VPWR sky130_fd_pr__pfet_01v8_hvt ad=0.2262 pd=2.26 as=0 ps=0 w=0.87 l=0.59
X657 u_loop.u_d1.X a_2875_2223# VGND VGND sky130_fd_pr__nfet_01v8 ad=0.169 pd=1.82 as=0.097 ps=0.975 w=0.65 l=0.15
X658 VGND VPWR VGND VGND sky130_fd_pr__nfet_01v8 ad=0.143 pd=1.62 as=0 ps=0 w=0.55 l=0.59
X659 VGND VPWR VGND VGND sky130_fd_pr__nfet_01v8 ad=0.143 pd=1.62 as=0 ps=0 w=0.55 l=0.59
X660 a_2595_4636# a_2439_4541# a_2740_4765# VPWR sky130_fd_pr__pfet_01v8_hvt ad=0.07245 pd=0.765 as=0.1155 ps=0.97 w=0.42 l=0.15
X661 a_2580_7663# a_1499_7663# a_2233_7905# VPWR sky130_fd_pr__pfet_01v8_hvt ad=0.0588 pd=0.7 as=0.12915 ps=1.185 w=0.42 l=0.15
X662 VPWR a_3992_7235# _41_.C1 VPWR sky130_fd_pr__pfet_01v8_hvt ad=0.14575 pd=1.335 as=0.135 ps=1.27 w=1 l=0.15
X663 VGND VPWR VGND VGND sky130_fd_pr__nfet_01v8 ad=0.143 pd=1.62 as=0 ps=0 w=0.55 l=0.59
X664 VGND _32_.A _56_.CLK VGND sky130_fd_pr__nfet_01v8 ad=0.169 pd=1.82 as=0.08775 ps=0.92 w=0.65 l=0.15
X665 a_3478_4943# a_2401_4949# a_3316_5321# VPWR sky130_fd_pr__pfet_01v8_hvt ad=0.0567 pd=0.69 as=0.0588 ps=0.7 w=0.42 l=0.15
X666 a_7903_5321# a_7553_4949# a_7808_5309# VPWR sky130_fd_pr__pfet_01v8_hvt ad=0.07245 pd=0.765 as=0.0651 ps=0.73 w=0.42 l=0.15
X667 a_5805_2767# a_5569_2767# VGND VGND sky130_fd_pr__nfet_01v8 ad=0.1092 pd=1.36 as=0.0567 ps=0.69 w=0.42 l=0.5
X668 a_6601_8751# a_6557_8993# a_6435_8751# VGND sky130_fd_pr__nfet_01v8 ad=0.0441 pd=0.63 as=0.1401 ps=1.1 w=0.42 l=0.15
X669 VPWR VGND VPWR VPWR sky130_fd_pr__pfet_01v8_hvt ad=0.2262 pd=2.26 as=0 ps=0 w=0.87 l=0.59
X670 VPWR VGND VPWR VPWR sky130_fd_pr__pfet_01v8_hvt ad=0.2262 pd=2.26 as=0 ps=0 w=0.87 l=0.59
X671 a_2526_4765# a_2400_4667# a_2122_4651# VGND sky130_fd_pr__special_nfet_01v8 ad=0.0999 pd=0.985 as=0.0711 ps=0.755 w=0.36 l=0.15
X672 VGND VPWR VGND VGND sky130_fd_pr__nfet_01v8 ad=0.143 pd=1.62 as=0 ps=0 w=0.55 l=0.59
X673 VGND VPWR VGND VGND sky130_fd_pr__nfet_01v8 ad=0.143 pd=1.62 as=0 ps=0 w=0.55 l=0.59
X674 VPWR a_6557_8993# a_6447_9117# VPWR sky130_fd_pr__pfet_01v8_hvt ad=0.07035 pd=0.755 as=0.1155 ps=0.97 w=0.42 l=0.15
X675 a_3215_8585# a_2769_8213# a_3119_8585# VGND sky130_fd_pr__special_nfet_01v8 ad=0.1401 pd=1.1 as=0.0594 ps=0.69 w=0.36 l=0.15
X676 VPWR src[1] a_4518_6825# VPWR sky130_fd_pr__pfet_01v8_hvt ad=0.1625 pd=1.325 as=0.135 ps=1.27 w=1 l=0.15
X677 _42_.Y _55_.Q VGND VGND sky130_fd_pr__nfet_01v8 ad=0.08775 pd=0.92 as=0.169 ps=1.82 w=0.65 l=0.15
X678 a_3158_4765# a_2400_4667# a_2595_4636# VPWR sky130_fd_pr__pfet_01v8_hvt ad=0.0651 pd=0.73 as=0.07245 ps=0.765 w=0.42 l=0.15
X679 a_4975_9295# u_loop.u_gh.C VPWR VPWR sky130_fd_pr__pfet_01v8_hvt ad=0.1092 pd=1.36 as=0.07035 ps=0.755 w=0.42 l=0.15
X680 VPWR _50_.Y a_2603_8213# VPWR sky130_fd_pr__pfet_01v8_hvt ad=0.0864 pd=0.91 as=0.1664 ps=1.8 w=0.64 l=0.15
X681 a_6633_2767# a_6397_2767# VGND VGND sky130_fd_pr__nfet_01v8 ad=0.1092 pd=1.36 as=0.0567 ps=0.69 w=0.42 l=0.5
X682 VGND VPWR VGND VGND sky130_fd_pr__nfet_01v8 ad=0.143 pd=1.62 as=0 ps=0 w=0.55 l=0.59
X683 VPWR VGND VPWR VPWR sky130_fd_pr__pfet_01v8_hvt ad=0.2262 pd=2.26 as=0 ps=0 w=0.87 l=0.59
X684 VGND VPWR VGND VGND sky130_fd_pr__nfet_01v8 ad=0.143 pd=1.62 as=0 ps=0 w=0.55 l=0.59
X685 VGND VPWR VGND VGND sky130_fd_pr__nfet_01v8 ad=0.143 pd=1.62 as=0 ps=0 w=0.55 l=0.59
X686 VGND a_2479_9269# _30_.A VGND sky130_fd_pr__nfet_01v8 ad=0.2087 pd=2.02 as=0.08775 ps=0.92 w=0.65 l=0.15
X687 _41_.C1 a_3992_7235# VGND VGND sky130_fd_pr__nfet_01v8 ad=0.08775 pd=0.92 as=0.10187 ps=0.99 w=0.65 l=0.15
X688 a_8011_4943# a_7387_4949# a_7903_5321# VPWR sky130_fd_pr__pfet_01v8_hvt ad=0.1155 pd=0.97 as=0.07245 ps=0.765 w=0.42 l=0.15
X689 VPWR a_5432_9673# a_5607_9599# VPWR sky130_fd_pr__pfet_01v8_hvt ad=0.1134 pd=1.38 as=0.0567 ps=0.69 w=0.42 l=0.15
X690 VPWR VGND VPWR VPWR sky130_fd_pr__pfet_01v8_hvt ad=0.2262 pd=2.26 as=0 ps=0 w=0.87 l=0.59
X691 VGND VPWR VGND VGND sky130_fd_pr__nfet_01v8 ad=0.143 pd=1.62 as=0 ps=0 w=0.55 l=0.59
X692 a_4075_6825# src[1] a_4160_6575# VPWR sky130_fd_pr__pfet_01v8_hvt ad=0.26 pd=2.52 as=0.135 ps=1.27 w=1 l=0.15
X693 VPWR a_2969_4917# a_2859_4943# VPWR sky130_fd_pr__pfet_01v8_hvt ad=0.07035 pd=0.755 as=0.1155 ps=0.97 w=0.42 l=0.15
X694 a_3239_9269# a_3083_9537# a_3384_9295# VPWR sky130_fd_pr__pfet_01v8_hvt ad=0.07245 pd=0.765 as=0.1155 ps=0.97 w=0.42 l=0.15
X695 VPWR VGND VPWR VPWR sky130_fd_pr__pfet_01v8_hvt ad=0.2262 pd=2.26 as=0 ps=0 w=0.87 l=0.59
X696 a_4510_3311# u_loop.u_gl.A2 VGND VGND sky130_fd_pr__nfet_01v8 ad=0.091 pd=0.93 as=0.104 ps=0.97 w=0.65 l=0.15
X697 VPWR VGND VPWR VPWR sky130_fd_pr__pfet_01v8_hvt ad=0.2262 pd=2.26 as=0 ps=0 w=0.87 l=0.59
X698 _62_.D _40_.B VPWR VPWR sky130_fd_pr__pfet_01v8_hvt ad=0.135 pd=1.27 as=0.26 ps=2.52 w=1 l=0.15
X699 _21_.Y _39_.B2 VPWR VPWR sky130_fd_pr__pfet_01v8_hvt ad=0.135 pd=1.27 as=0.26 ps=2.52 w=1 l=0.15
X700 a_2111_7663# a_1665_7663# a_2015_7663# VGND sky130_fd_pr__special_nfet_01v8 ad=0.1401 pd=1.1 as=0.0594 ps=0.69 w=0.36 l=0.15
X701 VGND src[0] a_1654_6575# VGND sky130_fd_pr__nfet_01v8 ad=0.104 pd=0.97 as=0.091 ps=0.93 w=0.65 l=0.15
X702 VGND VPWR VGND VGND sky130_fd_pr__nfet_01v8 ad=0.143 pd=1.62 as=0 ps=0 w=0.55 l=0.59
X703 a_4772_9661# _21_.Y VPWR VPWR sky130_fd_pr__pfet_01v8_hvt ad=0.0651 pd=0.73 as=0.1092 ps=1.36 w=0.42 l=0.15
X704 VGND u_loop.u_gh.C a_6141_4399# VGND sky130_fd_pr__nfet_01v8 ad=0.1346 pd=1.15 as=0.0441 ps=0.63 w=0.42 l=0.15
X705 VGND u_loop.u_gh.C a_5129_9661# VGND sky130_fd_pr__nfet_01v8 ad=0.1346 pd=1.15 as=0.0441 ps=0.63 w=0.42 l=0.15
X706 prenh u_loop.u_d0.A VPWR VPWR sky130_fd_pr__pfet_01v8_hvt ad=0.135 pd=1.27 as=0.135 ps=1.27 w=1 l=0.15
X707 a_3802_9295# a_3044_9411# a_3239_9269# VPWR sky130_fd_pr__pfet_01v8_hvt ad=0.0651 pd=0.73 as=0.07245 ps=0.765 w=0.42 l=0.15
X708 a_5085_9269# a_4867_9673# VPWR VPWR sky130_fd_pr__pfet_01v8_hvt ad=0.12915 pd=1.185 as=0.2184 ps=2.2 w=0.84 l=0.15
X709 VPWR _46_.A _46_.Y VPWR sky130_fd_pr__pfet_01v8_hvt ad=0.26 pd=2.52 as=0.135 ps=1.27 w=1 l=0.15
X710 a_7808_7485# _68_.D VGND VGND sky130_fd_pr__nfet_01v8 ad=0.066 pd=0.745 as=0.2205 ps=1.89 w=0.42 l=0.15
X711 VGND _28_.A _52_.Y VGND sky130_fd_pr__nfet_01v8 ad=0.169 pd=1.82 as=0.08775 ps=0.92 w=0.65 l=0.15
X712 VPWR VGND VPWR VPWR sky130_fd_pr__pfet_01v8_hvt ad=0.2262 pd=2.26 as=0 ps=0 w=0.87 l=0.59
X713 VPWR VGND VPWR VPWR sky130_fd_pr__pfet_01v8_hvt ad=0.2262 pd=2.26 as=0 ps=0 w=0.87 l=0.59
X714 VPWR a_7732_4233# a_7907_4159# VPWR sky130_fd_pr__pfet_01v8_hvt ad=0.1134 pd=1.38 as=0.0567 ps=0.69 w=0.42 l=0.15
X715 a_3846_8207# a_2769_8213# a_3684_8585# VPWR sky130_fd_pr__pfet_01v8_hvt ad=0.0567 pd=0.69 as=0.0588 ps=0.7 w=0.42 l=0.15
X716 xa a_8643_7423# VPWR VPWR sky130_fd_pr__pfet_01v8_hvt ad=0.135 pd=1.27 as=0.3012 ps=2.66 w=1 l=0.15
X717 a_4518_6825# a_4160_6575# _41_.B1 VPWR sky130_fd_pr__pfet_01v8_hvt ad=0.28 pd=2.56 as=0.135 ps=1.27 w=1 l=0.15
X718 _57_.CLK _45_.A VGND VGND sky130_fd_pr__nfet_01v8 ad=0.08775 pd=0.92 as=0.169 ps=1.82 w=0.65 l=0.15
X719 VPWR VGND VPWR VPWR sky130_fd_pr__pfet_01v8_hvt ad=0.2262 pd=2.26 as=0 ps=0 w=0.87 l=0.59
X720 a_7061_7663# a_7017_7905# a_6895_7663# VGND sky130_fd_pr__nfet_01v8 ad=0.0441 pd=0.63 as=0.1401 ps=1.1 w=0.42 l=0.15
X721 a_3381_8573# a_3337_8181# a_3215_8585# VGND sky130_fd_pr__nfet_01v8 ad=0.0441 pd=0.63 as=0.1401 ps=1.1 w=0.42 l=0.15
X722 a_4160_6575# src[0] VGND VGND sky130_fd_pr__nfet_01v8 ad=0.08775 pd=0.92 as=0.17875 ps=1.85 w=0.65 l=0.15
X723 a_5432_9673# a_4351_9301# a_5085_9269# VPWR sky130_fd_pr__pfet_01v8_hvt ad=0.0588 pd=0.7 as=0.12915 ps=1.185 w=0.42 l=0.15
X724 VPWR _46_.Y a_6283_7663# VPWR sky130_fd_pr__pfet_01v8_hvt ad=0.0864 pd=0.91 as=0.1664 ps=1.8 w=0.64 l=0.15
X725 VPWR a_7017_7905# a_6907_8029# VPWR sky130_fd_pr__pfet_01v8_hvt ad=0.07035 pd=0.755 as=0.1155 ps=0.97 w=0.42 l=0.15
X726 a_4518_6825# src[1] VPWR VPWR sky130_fd_pr__pfet_01v8_hvt ad=0.26 pd=2.52 as=0.1625 ps=1.325 w=1 l=0.15
X727 VGND VPWR VGND VGND sky130_fd_pr__nfet_01v8 ad=0.143 pd=1.62 as=0 ps=0 w=0.55 l=0.59
X728 VPWR a_2861_2767# a_2967_2767# VPWR sky130_fd_pr__pfet_01v8_hvt ad=0.14075 pd=1.325 as=0.1092 ps=1.36 w=0.42 l=0.5
X729 a_7072_4221# _55_.D VPWR VPWR sky130_fd_pr__pfet_01v8_hvt ad=0.0651 pd=0.73 as=0.1092 ps=1.36 w=0.42 l=0.15
X730 VPWR _39_.B2 _47_.Y VPWR sky130_fd_pr__pfet_01v8_hvt ad=0.26 pd=2.52 as=0.135 ps=1.27 w=1 l=0.15
X731 VPWR a_3859_8511# _40_.B VPWR sky130_fd_pr__pfet_01v8_hvt ad=0.26 pd=2.52 as=0.135 ps=1.27 w=1 l=0.15
X732 VPWR VGND VPWR VPWR sky130_fd_pr__pfet_01v8_hvt ad=0.2262 pd=2.26 as=0 ps=0 w=0.87 l=0.59
X733 VPWR a_8643_5247# _25_.A VPWR sky130_fd_pr__pfet_01v8_hvt ad=0.26 pd=2.52 as=0.135 ps=1.27 w=1 l=0.15
X734 VGND VPWR VGND VGND sky130_fd_pr__nfet_01v8 ad=0.143 pd=1.62 as=0 ps=0 w=0.55 l=0.59
X735 VPWR a_5190_7439# _39_.X VPWR sky130_fd_pr__pfet_01v8_hvt ad=0.26 pd=2.52 as=0.135 ps=1.27 w=1 l=0.15
X736 VPWR VGND VPWR VPWR sky130_fd_pr__pfet_01v8_hvt ad=0.2262 pd=2.26 as=0 ps=0 w=0.87 l=0.59
X737 VPWR _47_.Y a_5823_8751# VPWR sky130_fd_pr__pfet_01v8_hvt ad=0.0864 pd=0.91 as=0.1664 ps=1.8 w=0.64 l=0.15
X738 VPWR VGND VPWR VPWR sky130_fd_pr__pfet_01v8_hvt ad=0.2262 pd=2.26 as=0 ps=0 w=0.87 l=0.59
X739 VGND VPWR VGND VGND sky130_fd_pr__nfet_01v8 ad=0.143 pd=1.62 as=0 ps=0 w=0.55 l=0.59
X740 _30_.A a_2479_9269# VPWR VPWR sky130_fd_pr__pfet_01v8_hvt ad=0.135 pd=1.27 as=0.26 ps=2.52 w=1 l=0.15
X741 _30_.Y _30_.A VGND VGND sky130_fd_pr__nfet_01v8 ad=0.08775 pd=0.92 as=0.169 ps=1.82 w=0.65 l=0.15
X742 _39_.X a_5190_7439# VGND VGND sky130_fd_pr__nfet_01v8 ad=0.08775 pd=0.92 as=0.08775 ps=0.92 w=0.65 l=0.15
X743 a_7093_5487# a_6927_5487# VGND VGND sky130_fd_pr__nfet_01v8 ad=0.1092 pd=1.36 as=0.0567 ps=0.69 w=0.42 l=0.15
X744 u_loop.u_d4.X a_4439_2767# VPWR VPWR sky130_fd_pr__pfet_01v8_hvt ad=0.26 pd=2.52 as=0.14075 ps=1.325 w=1 l=0.15
X745 VPWR VGND VPWR VPWR sky130_fd_pr__pfet_01v8_hvt ad=0.2262 pd=2.26 as=0 ps=0 w=0.87 l=0.59
X746 VGND VPWR VGND VGND sky130_fd_pr__nfet_01v8 ad=0.143 pd=1.62 as=0 ps=0 w=0.55 l=0.59
X747 VGND VPWR VGND VGND sky130_fd_pr__nfet_01v8 ad=0.143 pd=1.62 as=0 ps=0 w=0.55 l=0.59
X748 VGND VPWR VGND VGND sky130_fd_pr__nfet_01v8 ad=0.143 pd=1.62 as=0 ps=0 w=0.55 l=0.59
X749 VGND a_3239_9269# a_3170_9295# VGND sky130_fd_pr__nfet_01v8 ad=0.1346 pd=1.15 as=0.0999 ps=0.985 w=0.64 l=0.15
X750 VPWR VGND VPWR VPWR sky130_fd_pr__pfet_01v8_hvt ad=0.2262 pd=2.26 as=0 ps=0 w=0.87 l=0.59
X751 a_8822_5309# u_loop.u_gh.C VGND VGND sky130_fd_pr__nfet_01v8 ad=0.06405 pd=0.725 as=0.12495 ps=1.015 w=0.42 l=0.15
X752 VGND pre _20_.Y VGND sky130_fd_pr__nfet_01v8 ad=0.169 pd=1.82 as=0.08775 ps=0.92 w=0.65 l=0.15
X753 a_3239_9269# a_3044_9411# a_3549_9661# VGND sky130_fd_pr__special_nfet_01v8 ad=0.0594 pd=0.69 as=0.1401 ps=1.1 w=0.36 l=0.15
X754 VPWR VGND VPWR VPWR sky130_fd_pr__pfet_01v8_hvt ad=0.2262 pd=2.26 as=0 ps=0 w=0.87 l=0.59
X755 a_3119_8585# a_2769_8213# a_3024_8573# VPWR sky130_fd_pr__pfet_01v8_hvt ad=0.07245 pd=0.765 as=0.0651 ps=0.73 w=0.42 l=0.15
X756 a_2742_8029# a_1665_7663# a_2580_7663# VPWR sky130_fd_pr__pfet_01v8_hvt ad=0.0567 pd=0.69 as=0.0588 ps=0.7 w=0.42 l=0.15
X757 VPWR VGND VPWR VPWR sky130_fd_pr__pfet_01v8_hvt ad=0.2262 pd=2.26 as=0 ps=0 w=0.87 l=0.59
X758 VGND a_7079_8725# a_7013_8751# VGND sky130_fd_pr__nfet_01v8 ad=0.12495 pd=1.015 as=0.0669 ps=0.75 w=0.42 l=0.15
X759 VGND VPWR VGND VGND sky130_fd_pr__nfet_01v8 ad=0.143 pd=1.62 as=0 ps=0 w=0.55 l=0.59
X760 VGND _53_.A _53_.Y VGND sky130_fd_pr__nfet_01v8 ad=0.169 pd=1.82 as=0.08775 ps=0.92 w=0.65 l=0.15
X761 a_6619_4373# u_loop.u_gh.C VPWR VPWR sky130_fd_pr__pfet_01v8_hvt ad=0.0567 pd=0.69 as=0.0819 ps=0.81 w=0.42 l=0.15
X762 VGND VPWR VGND VGND sky130_fd_pr__nfet_01v8 ad=0.143 pd=1.62 as=0 ps=0 w=0.55 l=0.59
X763 VPWR u_loop.u_gh.C a_2740_4765# VPWR sky130_fd_pr__pfet_01v8_hvt ad=0.07035 pd=0.755 as=0.1092 ps=1.36 w=0.42 l=0.15
X764 VPWR VGND VPWR VPWR sky130_fd_pr__pfet_01v8_hvt ad=0.2262 pd=2.26 as=0 ps=0 w=0.87 l=0.59
X765 VPWR VGND VPWR VPWR sky130_fd_pr__pfet_01v8_hvt ad=0.2262 pd=2.26 as=0 ps=0 w=0.87 l=0.59
X766 VGND VPWR VGND VGND sky130_fd_pr__nfet_01v8 ad=0.143 pd=1.62 as=0 ps=0 w=0.55 l=0.59
X767 VGND VPWR VGND VGND sky130_fd_pr__nfet_01v8 ad=0.143 pd=1.62 as=0 ps=0 w=0.55 l=0.59
X768 VGND _36_.A u_loop.u_gh.B VGND sky130_fd_pr__nfet_01v8 ad=0.169 pd=1.82 as=0.08775 ps=0.92 w=0.65 l=0.15
X769 a_2833_4399# u_loop.u_gh.C VGND VGND sky130_fd_pr__nfet_01v8 ad=0.0441 pd=0.63 as=0.1346 ps=1.15 w=0.42 l=0.15
X770 VGND VPWR VGND VGND sky130_fd_pr__nfet_01v8 ad=0.143 pd=1.62 as=0 ps=0 w=0.55 l=0.59
X771 VPWR VGND VPWR VPWR sky130_fd_pr__pfet_01v8_hvt ad=0.2262 pd=2.26 as=0 ps=0 w=0.87 l=0.59
X772 VPWR VGND VPWR VPWR sky130_fd_pr__pfet_01v8_hvt ad=0.2262 pd=2.26 as=0 ps=0 w=0.87 l=0.59
X773 a_3227_8207# a_2603_8213# a_3119_8585# VPWR sky130_fd_pr__pfet_01v8_hvt ad=0.1155 pd=0.97 as=0.07245 ps=0.765 w=0.42 l=0.15
X774 a_3399_6335# u_loop.u_gh.C VPWR VPWR sky130_fd_pr__pfet_01v8_hvt ad=0.0567 pd=0.69 as=0.0819 ps=0.81 w=0.42 l=0.15
X775 a_7631_6335# u_loop.u_gh.C VPWR VPWR sky130_fd_pr__pfet_01v8_hvt ad=0.0567 pd=0.69 as=0.0819 ps=0.81 w=0.42 l=0.15
X776 VPWR a_2125_2767# a_2231_2767# VPWR sky130_fd_pr__pfet_01v8_hvt ad=0.14075 pd=1.325 as=0.1092 ps=1.36 w=0.42 l=0.5
X777 a_5377_5487# _41_.B1 a_5293_5487# VGND sky130_fd_pr__nfet_01v8 ad=0.08775 pd=0.92 as=0.08775 ps=0.92 w=0.65 l=0.15
X778 VGND VPWR VGND VGND sky130_fd_pr__nfet_01v8 ad=0.143 pd=1.62 as=0 ps=0 w=0.55 l=0.59
X779 a_7539_7637# a_7364_7663# a_7718_7663# VGND sky130_fd_pr__nfet_01v8 ad=0.1092 pd=1.36 as=0.06405 ps=0.725 w=0.42 l=0.15
X780 VGND VPWR VGND VGND sky130_fd_pr__nfet_01v8 ad=0.143 pd=1.62 as=0 ps=0 w=0.55 l=0.59
X781 VGND _56_.Q _56_.D VGND sky130_fd_pr__nfet_01v8 ad=0.169 pd=1.82 as=0.08775 ps=0.92 w=0.65 l=0.15
X782 VPWR VGND VPWR VPWR sky130_fd_pr__pfet_01v8_hvt ad=0.2262 pd=2.26 as=0 ps=0 w=0.87 l=0.59
X783 VGND VPWR VGND VGND sky130_fd_pr__nfet_01v8 ad=0.143 pd=1.62 as=0 ps=0 w=0.55 l=0.59
X784 VGND _40_.B _62_.D VGND sky130_fd_pr__nfet_01v8 ad=0.169 pd=1.82 as=0.08775 ps=0.92 w=0.65 l=0.15
X785 VGND a_1835_4373# _53_.A VGND sky130_fd_pr__nfet_01v8 ad=0.2087 pd=2.02 as=0.08775 ps=0.92 w=0.65 l=0.15
X786 prenh u_loop.u_gh.C VPWR VPWR sky130_fd_pr__pfet_01v8_hvt ad=0.135 pd=1.27 as=0.26 ps=2.52 w=1 l=0.15
X787 VGND VPWR VGND VGND sky130_fd_pr__nfet_01v8 ad=0.143 pd=1.62 as=0 ps=0 w=0.55 l=0.59
X788 VGND VPWR VGND VGND sky130_fd_pr__nfet_01v8 ad=0.143 pd=1.62 as=0 ps=0 w=0.55 l=0.59
X789 a_1920_7663# _63_.D VGND VGND sky130_fd_pr__nfet_01v8 ad=0.066 pd=0.745 as=0.2205 ps=1.89 w=0.42 l=0.15
X790 a_4076_3561# u_loop.u_gl.A2 VPWR VPWR sky130_fd_pr__pfet_01v8_hvt ad=0.265 pd=2.53 as=0.14 ps=1.28 w=1 l=0.15
X791 a_3337_8181# a_3119_8585# VGND VGND sky130_fd_pr__nfet_01v8 ad=0.0999 pd=0.985 as=0.1346 ps=1.15 w=0.64 l=0.15
X792 a_1665_7663# a_1499_7663# VGND VGND sky130_fd_pr__nfet_01v8 ad=0.1092 pd=1.36 as=0.0567 ps=0.69 w=0.42 l=0.15
X793 u_loop.u_gh.B _36_.A VPWR VPWR sky130_fd_pr__pfet_01v8_hvt ad=0.135 pd=1.27 as=0.26 ps=2.52 w=1 l=0.15
X794 VGND a_5069_2767# a_5175_2767# VGND sky130_fd_pr__nfet_01v8 ad=0.097 pd=0.975 as=0.1092 ps=1.36 w=0.42 l=0.5
X795 VGND a_7907_4159# a_7841_4233# VGND sky130_fd_pr__nfet_01v8 ad=0.12495 pd=1.015 as=0.0669 ps=0.75 w=0.42 l=0.15
X796 VGND VPWR VGND VGND sky130_fd_pr__nfet_01v8 ad=0.143 pd=1.62 as=0 ps=0 w=0.55 l=0.59
X797 VGND VPWR VGND VGND sky130_fd_pr__nfet_01v8 ad=0.143 pd=1.62 as=0 ps=0 w=0.55 l=0.59
X798 a_6817_3861# a_6651_3861# VPWR VPWR sky130_fd_pr__pfet_01v8_hvt ad=0.1664 pd=1.8 as=0.0864 ps=0.91 w=0.64 l=0.15
X799 prenh u_loop.u_d0.A VPWR VPWR sky130_fd_pr__pfet_01v8_hvt ad=0.135 pd=1.27 as=0.26 ps=2.52 w=1 l=0.15
X800 VPWR VGND VPWR VPWR sky130_fd_pr__pfet_01v8_hvt ad=0.2262 pd=2.26 as=0 ps=0 w=0.87 l=0.59
X801 VPWR VGND VPWR VPWR sky130_fd_pr__pfet_01v8_hvt ad=0.2262 pd=2.26 as=0 ps=0 w=0.87 l=0.59
X802 a_5879_4399# a_5363_4399# a_5784_4399# VGND sky130_fd_pr__special_nfet_01v8 ad=0.0594 pd=0.69 as=0.066 ps=0.745 w=0.36 l=0.15
X803 VPWR VGND VPWR VPWR sky130_fd_pr__pfet_01v8_hvt ad=0.2262 pd=2.26 as=0 ps=0 w=0.87 l=0.59
X804 _56_.D _56_.Q VPWR VPWR sky130_fd_pr__pfet_01v8_hvt ad=0.135 pd=1.27 as=0.26 ps=2.52 w=1 l=0.15
X805 a_2969_4917# a_2751_5321# VGND VGND sky130_fd_pr__nfet_01v8 ad=0.0999 pd=0.985 as=0.1346 ps=1.15 w=0.64 l=0.15
X806 VPWR VGND VPWR VPWR sky130_fd_pr__pfet_01v8_hvt ad=0.2262 pd=2.26 as=0 ps=0 w=0.87 l=0.59
X807 _55_.D _55_.Q VGND VGND sky130_fd_pr__nfet_01v8 ad=0.08775 pd=0.92 as=0.169 ps=1.82 w=0.65 l=0.15
X808 VPWR VGND VPWR VPWR sky130_fd_pr__pfet_01v8_hvt ad=0.2262 pd=2.26 as=0 ps=0 w=0.87 l=0.59
X809 VPWR a_7631_6335# a_7618_6031# VPWR sky130_fd_pr__pfet_01v8_hvt ad=0.0819 pd=0.81 as=0.0567 ps=0.69 w=0.42 l=0.15
X810 VPWR VGND VPWR VPWR sky130_fd_pr__pfet_01v8_hvt ad=0.2262 pd=2.26 as=0 ps=0 w=0.87 l=0.59
X811 VPWR VGND VPWR VPWR sky130_fd_pr__pfet_01v8_hvt ad=0.2262 pd=2.26 as=0 ps=0 w=0.87 l=0.59
X812 VGND _45_.A _22_.Y VGND sky130_fd_pr__nfet_01v8 ad=0.169 pd=1.82 as=0.08775 ps=0.92 w=0.65 l=0.15
X813 a_5594_9295# a_4517_9301# a_5432_9673# VPWR sky130_fd_pr__pfet_01v8_hvt ad=0.0567 pd=0.69 as=0.0588 ps=0.7 w=0.42 l=0.15
X814 a_2356_4765# a_1835_4373# VPWR VPWR sky130_fd_pr__pfet_01v8_hvt ad=0.0567 pd=0.69 as=0.0819 ps=0.81 w=0.42 l=0.15
X815 VGND u_loop.u_d2.X a_3361_2767# VGND sky130_fd_pr__nfet_01v8 ad=0.0567 pd=0.69 as=0.1092 ps=1.36 w=0.42 l=0.15
X816 a_6097_4641# a_5879_4399# VGND VGND sky130_fd_pr__nfet_01v8 ad=0.0999 pd=0.985 as=0.1346 ps=1.15 w=0.64 l=0.15
X817 _50_.Y _63_.Q VGND VGND sky130_fd_pr__nfet_01v8 ad=0.08775 pd=0.92 as=0.169 ps=1.82 w=0.65 l=0.15
X818 VPWR VGND VPWR VPWR sky130_fd_pr__pfet_01v8_hvt ad=0.2262 pd=2.26 as=0 ps=0 w=0.87 l=0.59
X819 VPWR VGND VPWR VPWR sky130_fd_pr__pfet_01v8_hvt ad=0.2262 pd=2.26 as=0 ps=0 w=0.87 l=0.59
X820 VGND VPWR VGND VGND sky130_fd_pr__nfet_01v8 ad=0.143 pd=1.62 as=0 ps=0 w=0.55 l=0.59
X821 VGND VPWR VGND VGND sky130_fd_pr__nfet_01v8 ad=0.143 pd=1.62 as=0 ps=0 w=0.55 l=0.59
X822 a_2123_8029# a_1499_7663# a_2015_7663# VPWR sky130_fd_pr__pfet_01v8_hvt ad=0.1155 pd=0.97 as=0.07245 ps=0.765 w=0.42 l=0.15
X823 VGND a_8183_5461# a_8117_5487# VGND sky130_fd_pr__nfet_01v8 ad=0.12495 pd=1.015 as=0.0669 ps=0.75 w=0.42 l=0.15
X824 VGND _41_.X a_6927_5487# VGND sky130_fd_pr__nfet_01v8 ad=0.0567 pd=0.69 as=0.1092 ps=1.36 w=0.42 l=0.15
X825 u_loop.u_d6.X a_5911_2767# VGND VGND sky130_fd_pr__nfet_01v8 ad=0.169 pd=1.82 as=0.097 ps=0.975 w=0.65 l=0.15
X826 _56_.CLK _32_.A VPWR VPWR sky130_fd_pr__pfet_01v8_hvt ad=0.135 pd=1.27 as=0.26 ps=2.52 w=1 l=0.15
X827 a_7539_5487# a_7093_5487# a_7443_5487# VGND sky130_fd_pr__special_nfet_01v8 ad=0.1401 pd=1.1 as=0.0594 ps=0.69 w=0.36 l=0.15
X828 VPWR a_2595_4636# a_2526_4765# VPWR sky130_fd_pr__pfet_01v8_hvt ad=0.2184 pd=2.2 as=0.12915 ps=1.185 w=0.84 l=0.15
X829 VPWR a_7907_4159# a_7894_3855# VPWR sky130_fd_pr__pfet_01v8_hvt ad=0.0819 pd=0.81 as=0.0567 ps=0.69 w=0.42 l=0.15
X830 a_7017_7905# a_6799_7663# VPWR VPWR sky130_fd_pr__pfet_01v8_hvt ad=0.12915 pd=1.185 as=0.2184 ps=2.2 w=0.84 l=0.15
X831 VPWR VGND VPWR VPWR sky130_fd_pr__pfet_01v8_hvt ad=0.2262 pd=2.26 as=0 ps=0 w=0.87 l=0.59
X832 VGND VPWR VGND VGND sky130_fd_pr__nfet_01v8 ad=0.143 pd=1.62 as=0 ps=0 w=0.55 l=0.59
X833 VPWR a_6097_4641# a_5987_4765# VPWR sky130_fd_pr__pfet_01v8_hvt ad=0.07035 pd=0.755 as=0.1155 ps=0.97 w=0.42 l=0.15
X834 VPWR VGND VPWR VPWR sky130_fd_pr__pfet_01v8_hvt ad=0.2262 pd=2.26 as=0 ps=0 w=0.87 l=0.59
X835 a_2439_4541# u_loop.u_d0.A VGND VGND sky130_fd_pr__nfet_01v8 ad=0.1092 pd=1.36 as=0.0567 ps=0.69 w=0.42 l=0.15
X836 VPWR VGND VPWR VPWR sky130_fd_pr__pfet_01v8_hvt ad=0.2262 pd=2.26 as=0 ps=0 w=0.87 l=0.59
X837 VGND VPWR VGND VGND sky130_fd_pr__nfet_01v8 ad=0.143 pd=1.62 as=0 ps=0 w=0.55 l=0.59
X838 VGND src[1] a_4369_6351# VGND sky130_fd_pr__nfet_01v8 ad=0.08775 pd=0.92 as=0.08775 ps=0.92 w=0.65 l=0.15
X839 VGND VPWR VGND VGND sky130_fd_pr__nfet_01v8 ad=0.143 pd=1.62 as=0 ps=0 w=0.55 l=0.59
X840 VGND VPWR VGND VGND sky130_fd_pr__nfet_01v8 ad=0.143 pd=1.62 as=0 ps=0 w=0.55 l=0.59
X841 VGND u_loop.u_gh.C a_6601_8751# VGND sky130_fd_pr__nfet_01v8 ad=0.1346 pd=1.15 as=0.0441 ps=0.63 w=0.42 l=0.15
X842 a_7079_8725# a_6904_8751# a_7258_8751# VGND sky130_fd_pr__nfet_01v8 ad=0.1092 pd=1.36 as=0.06405 ps=0.725 w=0.42 l=0.15
X843 VPWR VGND VPWR VPWR sky130_fd_pr__pfet_01v8_hvt ad=0.2262 pd=2.26 as=0 ps=0 w=0.87 l=0.59
X844 VGND VPWR VGND VGND sky130_fd_pr__nfet_01v8 ad=0.143 pd=1.62 as=0 ps=0 w=0.55 l=0.59
X845 a_3000_9295# a_2479_9269# VPWR VPWR sky130_fd_pr__pfet_01v8_hvt ad=0.0567 pd=0.69 as=0.0819 ps=0.81 w=0.42 l=0.15
X846 a_6557_8993# a_6339_8751# VPWR VPWR sky130_fd_pr__pfet_01v8_hvt ad=0.12915 pd=1.185 as=0.2184 ps=2.2 w=0.84 l=0.15
X847 VPWR VGND VPWR VPWR sky130_fd_pr__pfet_01v8_hvt ad=0.2262 pd=2.26 as=0 ps=0 w=0.87 l=0.59
X848 VGND VPWR VGND VGND sky130_fd_pr__nfet_01v8 ad=0.143 pd=1.62 as=0 ps=0 w=0.55 l=0.59
X849 VPWR VGND VPWR VPWR sky130_fd_pr__pfet_01v8_hvt ad=0.2262 pd=2.26 as=0 ps=0 w=0.87 l=0.59
X850 VPWR u_loop.u_d5.X a_5569_2767# VPWR sky130_fd_pr__pfet_01v8_hvt ad=0.0567 pd=0.69 as=0.1092 ps=1.36 w=0.42 l=0.15
X851 VGND a_4333_2767# a_4439_2767# VGND sky130_fd_pr__nfet_01v8 ad=0.097 pd=0.975 as=0.1092 ps=1.36 w=0.42 l=0.5
X852 VGND VPWR VGND VGND sky130_fd_pr__nfet_01v8 ad=0.143 pd=1.62 as=0 ps=0 w=0.55 l=0.59
X853 a_2921_6397# a_2877_6005# a_2755_6409# VGND sky130_fd_pr__nfet_01v8 ad=0.0441 pd=0.63 as=0.1401 ps=1.1 w=0.42 l=0.15
X854 VGND _32_.A _32_.Y VGND sky130_fd_pr__nfet_01v8 ad=0.169 pd=1.82 as=0.08775 ps=0.92 w=0.65 l=0.15
X855 VGND u_loop.u_d7.X u_loop.u_d0.A VGND sky130_fd_pr__nfet_01v8 ad=0.169 pd=1.82 as=0.08775 ps=0.92 w=0.65 l=0.15
X856 a_3224_6409# a_2309_6037# a_2877_6005# VGND sky130_fd_pr__special_nfet_01v8 ad=0.0711 pd=0.755 as=0.0999 ps=0.985 w=0.36 l=0.15
X857 VPWR u_loop.u_gh.C a_1835_4373# VPWR sky130_fd_pr__pfet_01v8_hvt ad=0.0819 pd=0.81 as=0.0567 ps=0.69 w=0.42 l=0.15
X858 u_loop.u_d7.X a_6739_2767# VPWR VPWR sky130_fd_pr__pfet_01v8_hvt ad=0.26 pd=2.52 as=0.14075 ps=1.325 w=1 l=0.15
X859 a_8121_4917# a_7903_5321# VGND VGND sky130_fd_pr__nfet_01v8 ad=0.0999 pd=0.985 as=0.1346 ps=1.15 w=0.64 l=0.15
X860 VPWR VGND VPWR VPWR sky130_fd_pr__pfet_01v8_hvt ad=0.2262 pd=2.26 as=0 ps=0 w=0.87 l=0.59
X861 VGND VPWR VGND VGND sky130_fd_pr__nfet_01v8 ad=0.143 pd=1.62 as=0 ps=0 w=0.55 l=0.59
X862 u_loop.u_cmp.Y x VPWR VPWR sky130_fd_pr__pfet_01v8_hvt ad=0.26 pd=2.52 as=0.26 ps=2.52 w=1 l=0.15
X863 VPWR VGND VPWR VPWR sky130_fd_pr__pfet_01v8_hvt ad=0.2262 pd=2.26 as=0 ps=0 w=0.87 l=0.59
X864 a_6999_6031# u_loop.u_gh.C VPWR VPWR sky130_fd_pr__pfet_01v8_hvt ad=0.1092 pd=1.36 as=0.07035 ps=0.755 w=0.42 l=0.15
X865 a_2309_6037# a_2143_6037# VGND VGND sky130_fd_pr__nfet_01v8 ad=0.1092 pd=1.36 as=0.0567 ps=0.69 w=0.42 l=0.15
X866 VPWR a_7385_3829# a_7275_3855# VPWR sky130_fd_pr__pfet_01v8_hvt ad=0.07035 pd=0.755 as=0.1155 ps=0.97 w=0.42 l=0.15
X867 a_2969_4917# a_2751_5321# VPWR VPWR sky130_fd_pr__pfet_01v8_hvt ad=0.12915 pd=1.185 as=0.2184 ps=2.2 w=0.84 l=0.15
X868 a_2157_4399# a_2122_4651# a_1835_4373# VGND sky130_fd_pr__nfet_01v8 ad=0.06405 pd=0.725 as=0.1092 ps=1.36 w=0.42 l=0.15
X869 VPWR VGND VPWR VPWR sky130_fd_pr__pfet_01v8_hvt ad=0.2262 pd=2.26 as=0 ps=0 w=0.87 l=0.59
X870 VPWR VGND VPWR VPWR sky130_fd_pr__pfet_01v8_hvt ad=0.2262 pd=2.26 as=0 ps=0 w=0.87 l=0.59
X871 VGND VPWR VGND VGND sky130_fd_pr__nfet_01v8 ad=0.143 pd=1.62 as=0 ps=0 w=0.55 l=0.59
X872 a_6444_4399# a_5529_4399# a_6097_4641# VGND sky130_fd_pr__special_nfet_01v8 ad=0.0711 pd=0.755 as=0.0999 ps=0.985 w=0.36 l=0.15
X873 VPWR a_3597_2767# a_3703_2767# VPWR sky130_fd_pr__pfet_01v8_hvt ad=0.14075 pd=1.325 as=0.1092 ps=1.36 w=0.42 l=0.5
X874 _49_.Y _40_.B VPWR VPWR sky130_fd_pr__pfet_01v8_hvt ad=0.135 pd=1.27 as=0.26 ps=2.52 w=1 l=0.15
X875 VGND a_2755_7637# a_2689_7663# VGND sky130_fd_pr__nfet_01v8 ad=0.12495 pd=1.015 as=0.0669 ps=0.75 w=0.42 l=0.15
X876 u_loop.u_d0.X a_2231_2767# VGND VGND sky130_fd_pr__nfet_01v8 ad=0.169 pd=1.82 as=0.097 ps=0.975 w=0.65 l=0.15
X877 VPWR VGND VPWR VPWR sky130_fd_pr__pfet_01v8_hvt ad=0.2262 pd=2.26 as=0 ps=0 w=0.87 l=0.59
X878 a_2766_9427# a_3083_9537# a_3041_9661# VGND sky130_fd_pr__special_nfet_01v8 ad=0.0711 pd=0.755 as=0.0669 ps=0.75 w=0.36 l=0.15
X879 VPWR _30_.A _30_.Y VPWR sky130_fd_pr__pfet_01v8_hvt ad=0.26 pd=2.52 as=0.135 ps=1.27 w=1 l=0.15
X880 a_8643_7423# u_loop.u_gh.C VPWR VPWR sky130_fd_pr__pfet_01v8_hvt ad=0.0567 pd=0.69 as=0.0819 ps=0.81 w=0.42 l=0.15
X881 _52_.Y _28_.A VPWR VPWR sky130_fd_pr__pfet_01v8_hvt ad=0.135 pd=1.27 as=0.26 ps=2.52 w=1 l=0.15
X882 a_2277_7663# a_2233_7905# a_2111_7663# VGND sky130_fd_pr__nfet_01v8 ad=0.0441 pd=0.63 as=0.1401 ps=1.1 w=0.42 l=0.15
X883 a_3013_5309# a_2969_4917# a_2847_5321# VGND sky130_fd_pr__nfet_01v8 ad=0.0441 pd=0.63 as=0.1401 ps=1.1 w=0.42 l=0.15
X884 VPWR _55_.Q _55_.D VPWR sky130_fd_pr__pfet_01v8_hvt ad=0.26 pd=2.52 as=0.135 ps=1.27 w=1 l=0.15
X885 VPWR VGND VPWR VPWR sky130_fd_pr__pfet_01v8_hvt ad=0.2262 pd=2.26 as=0 ps=0 w=0.87 l=0.59
X886 VGND VPWR VGND VGND sky130_fd_pr__nfet_01v8 ad=0.143 pd=1.62 as=0 ps=0 w=0.55 l=0.59
X887 VGND VPWR VGND VGND sky130_fd_pr__nfet_01v8 ad=0.143 pd=1.62 as=0 ps=0 w=0.55 l=0.59
X888 VGND VPWR VGND VGND sky130_fd_pr__nfet_01v8 ad=0.143 pd=1.62 as=0 ps=0 w=0.55 l=0.59
X889 a_3316_5321# a_2235_4949# a_2969_4917# VPWR sky130_fd_pr__pfet_01v8_hvt ad=0.0588 pd=0.7 as=0.12915 ps=1.185 w=0.42 l=0.15
X890 a_4351_4175# u_loop.u_gh.B a_4769_4175# VGND sky130_fd_pr__nfet_01v8 ad=0.08775 pd=0.92 as=0.08775 ps=0.92 w=0.65 l=0.15
X891 VPWR VGND VPWR VPWR sky130_fd_pr__pfet_01v8_hvt ad=0.2262 pd=2.26 as=0 ps=0 w=0.87 l=0.59
X892 u_loop.u_d5.X a_5175_2767# VGND VGND sky130_fd_pr__nfet_01v8 ad=0.169 pd=1.82 as=0.097 ps=0.975 w=0.65 l=0.15
X893 VPWR VGND VPWR VPWR sky130_fd_pr__pfet_01v8_hvt ad=0.2262 pd=2.26 as=0 ps=0 w=0.87 l=0.59
X894 VPWR u_loop.u_gh.C a_2479_9269# VPWR sky130_fd_pr__pfet_01v8_hvt ad=0.0819 pd=0.81 as=0.0567 ps=0.69 w=0.42 l=0.15
X895 VGND u_loop.u_gh.C a_7061_7663# VGND sky130_fd_pr__nfet_01v8 ad=0.1346 pd=1.15 as=0.0441 ps=0.63 w=0.42 l=0.15
X896 _64_.D _64_.Q VGND VGND sky130_fd_pr__nfet_01v8 ad=0.08775 pd=0.92 as=0.169 ps=1.82 w=0.65 l=0.15
X897 VGND VPWR VGND VGND sky130_fd_pr__nfet_01v8 ad=0.143 pd=1.62 as=0 ps=0 w=0.55 l=0.59
X898 VGND u_loop.u_gh.C a_3381_8573# VGND sky130_fd_pr__nfet_01v8 ad=0.1346 pd=1.15 as=0.0441 ps=0.63 w=0.42 l=0.15
X899 VGND VPWR VGND VGND sky130_fd_pr__nfet_01v8 ad=0.143 pd=1.62 as=0 ps=0 w=0.55 l=0.59
X900 VPWR a_1499_6575# u_loop.u_gh.C VPWR sky130_fd_pr__pfet_01v8_hvt ad=0.265 pd=2.53 as=0.14 ps=1.28 w=1 l=0.15
X901 VPWR a_8468_5321# a_8643_5247# VPWR sky130_fd_pr__pfet_01v8_hvt ad=0.1134 pd=1.38 as=0.0567 ps=0.69 w=0.42 l=0.15
X902 VPWR VGND VPWR VPWR sky130_fd_pr__pfet_01v8_hvt ad=0.2262 pd=2.26 as=0 ps=0 w=0.87 l=0.59
X903 a_4517_9301# a_4351_9301# VPWR VPWR sky130_fd_pr__pfet_01v8_hvt ad=0.1664 pd=1.8 as=0.0864 ps=0.91 w=0.64 l=0.15
X904 VPWR VGND VPWR VPWR sky130_fd_pr__pfet_01v8_hvt ad=0.2262 pd=2.26 as=0 ps=0 w=0.87 l=0.59
X905 a_2847_5321# a_2401_4949# a_2751_5321# VGND sky130_fd_pr__special_nfet_01v8 ad=0.1401 pd=1.1 as=0.0594 ps=0.69 w=0.36 l=0.15
X906 a_7348_5487# _67_.D VPWR VPWR sky130_fd_pr__pfet_01v8_hvt ad=0.0651 pd=0.73 as=0.1092 ps=1.36 w=0.42 l=0.15
X907 VPWR u_loop.u_d0.A a_1889_2767# VPWR sky130_fd_pr__pfet_01v8_hvt ad=0.0567 pd=0.69 as=0.1092 ps=1.36 w=0.42 l=0.15
X908 VPWR VGND VPWR VPWR sky130_fd_pr__pfet_01v8_hvt ad=0.2262 pd=2.26 as=0 ps=0 w=0.87 l=0.59
X909 VPWR VGND VPWR VPWR sky130_fd_pr__pfet_01v8_hvt ad=0.2262 pd=2.26 as=0 ps=0 w=0.87 l=0.59
X910 VPWR VGND VPWR VPWR sky130_fd_pr__pfet_01v8_hvt ad=0.2262 pd=2.26 as=0 ps=0 w=0.87 l=0.59
X911 _22_.Y _45_.A VPWR VPWR sky130_fd_pr__pfet_01v8_hvt ad=0.135 pd=1.27 as=0.26 ps=2.52 w=1 l=0.15
X912 a_3597_2767# a_3361_2767# VPWR VPWR sky130_fd_pr__pfet_01v8_hvt ad=0.1092 pd=1.36 as=0.0567 ps=0.69 w=0.42 l=0.5
X913 VGND VPWR VGND VGND sky130_fd_pr__nfet_01v8 ad=0.143 pd=1.62 as=0 ps=0 w=0.55 l=0.59
X914 VGND VPWR VGND VGND sky130_fd_pr__nfet_01v8 ad=0.143 pd=1.62 as=0 ps=0 w=0.55 l=0.59
X915 VPWR VGND VPWR VPWR sky130_fd_pr__pfet_01v8_hvt ad=0.2262 pd=2.26 as=0 ps=0 w=0.87 l=0.59
X916 VPWR src[1] a_3514_7235# VPWR sky130_fd_pr__pfet_01v8_hvt ad=0.14825 pd=1.34 as=0.0567 ps=0.69 w=0.42 l=0.15
X917 VGND VPWR VGND VGND sky130_fd_pr__nfet_01v8 ad=0.143 pd=1.62 as=0 ps=0 w=0.55 l=0.59
X918 a_8183_5461# a_8008_5487# a_8362_5487# VGND sky130_fd_pr__nfet_01v8 ad=0.1092 pd=1.36 as=0.06405 ps=0.725 w=0.42 l=0.15
X919 VGND VPWR VGND VGND sky130_fd_pr__nfet_01v8 ad=0.143 pd=1.62 as=0 ps=0 w=0.55 l=0.59
X920 VGND VPWR VGND VGND sky130_fd_pr__nfet_01v8 ad=0.143 pd=1.62 as=0 ps=0 w=0.55 l=0.59
X921 VPWR VGND VPWR VPWR sky130_fd_pr__pfet_01v8_hvt ad=0.2262 pd=2.26 as=0 ps=0 w=0.87 l=0.59
X922 VPWR a_8643_7423# a_8630_7119# VPWR sky130_fd_pr__pfet_01v8_hvt ad=0.0819 pd=0.81 as=0.0567 ps=0.69 w=0.42 l=0.15
X923 VGND VPWR VGND VGND sky130_fd_pr__nfet_01v8 ad=0.143 pd=1.62 as=0 ps=0 w=0.55 l=0.59
X924 VPWR _56_.Q _55_.CLK VPWR sky130_fd_pr__pfet_01v8_hvt ad=0.26 pd=2.52 as=0.135 ps=1.27 w=1 l=0.15
X925 VGND VPWR VGND VGND sky130_fd_pr__nfet_01v8 ad=0.143 pd=1.62 as=0 ps=0 w=0.55 l=0.59
X926 VPWR VGND VPWR VPWR sky130_fd_pr__pfet_01v8_hvt ad=0.2262 pd=2.26 as=0 ps=0 w=0.87 l=0.59
X927 VPWR VGND VPWR VPWR sky130_fd_pr__pfet_01v8_hvt ad=0.2262 pd=2.26 as=0 ps=0 w=0.87 l=0.59
X928 a_3337_8181# a_3119_8585# VPWR VPWR sky130_fd_pr__pfet_01v8_hvt ad=0.12915 pd=1.185 as=0.2184 ps=2.2 w=0.84 l=0.15
X929 VGND VPWR VGND VGND sky130_fd_pr__nfet_01v8 ad=0.143 pd=1.62 as=0 ps=0 w=0.55 l=0.59
X930 a_4518_6575# src[0] VGND VGND sky130_fd_pr__nfet_01v8 ad=0.08775 pd=0.92 as=0.08775 ps=0.92 w=0.65 l=0.15
X931 a_8008_5487# a_6927_5487# a_7661_5729# VPWR sky130_fd_pr__pfet_01v8_hvt ad=0.0588 pd=0.7 as=0.12915 ps=1.185 w=0.42 l=0.15
X932 _40_.B a_3859_8511# VPWR VPWR sky130_fd_pr__pfet_01v8_hvt ad=0.135 pd=1.27 as=0.3012 ps=2.66 w=1 l=0.15
X933 VPWR a_3399_6335# _64_.Q VPWR sky130_fd_pr__pfet_01v8_hvt ad=0.26 pd=2.52 as=0.135 ps=1.27 w=1 l=0.15
X934 a_8121_4917# a_7903_5321# VPWR VPWR sky130_fd_pr__pfet_01v8_hvt ad=0.12915 pd=1.185 as=0.2184 ps=2.2 w=0.84 l=0.15
X935 u_loop.u_gl.B1 u_loop.u_gh.C VPWR VPWR sky130_fd_pr__pfet_01v8_hvt ad=0.26 pd=2.52 as=0.26 ps=2.52 w=1 l=0.15
X936 VPWR VGND VPWR VPWR sky130_fd_pr__pfet_01v8_hvt ad=0.2262 pd=2.26 as=0 ps=0 w=0.87 l=0.59
X937 VGND VPWR VGND VGND sky130_fd_pr__nfet_01v8 ad=0.143 pd=1.62 as=0 ps=0 w=0.55 l=0.59
X938 prenl u_loop.u_gl.B1 a_4076_3561# VPWR sky130_fd_pr__pfet_01v8_hvt ad=0.14 pd=1.28 as=0.26 ps=2.52 w=1 l=0.15
X939 VGND VPWR VGND VGND sky130_fd_pr__nfet_01v8 ad=0.143 pd=1.62 as=0 ps=0 w=0.55 l=0.59
X940 VPWR _53_.A _27_.Y VPWR sky130_fd_pr__pfet_01v8_hvt ad=0.26 pd=2.52 as=0.135 ps=1.27 w=1 l=0.15
X941 VPWR VGND VPWR VPWR sky130_fd_pr__pfet_01v8_hvt ad=0.2262 pd=2.26 as=0 ps=0 w=0.87 l=0.59
X942 VGND VPWR VGND VGND sky130_fd_pr__nfet_01v8 ad=0.143 pd=1.62 as=0 ps=0 w=0.55 l=0.59
X943 _64_.Q a_3399_6335# VGND VGND sky130_fd_pr__nfet_01v8 ad=0.08775 pd=0.92 as=0.2087 ps=2.02 w=0.65 l=0.15
X944 VGND VPWR VGND VGND sky130_fd_pr__nfet_01v8 ad=0.143 pd=1.62 as=0 ps=0 w=0.55 l=0.59
X945 VGND VPWR VGND VGND sky130_fd_pr__nfet_01v8 ad=0.143 pd=1.62 as=0 ps=0 w=0.55 l=0.59
X946 VGND VPWR VGND VGND sky130_fd_pr__nfet_01v8 ad=0.143 pd=1.62 as=0 ps=0 w=0.55 l=0.59
X947 a_3684_8585# a_2603_8213# a_3337_8181# VPWR sky130_fd_pr__pfet_01v8_hvt ad=0.0588 pd=0.7 as=0.12915 ps=1.185 w=0.42 l=0.15
X948 VPWR VGND VPWR VPWR sky130_fd_pr__pfet_01v8_hvt ad=0.2262 pd=2.26 as=0 ps=0 w=0.87 l=0.59
X949 a_5649_5737# _36_.A a_5190_5487# VPWR sky130_fd_pr__pfet_01v8_hvt ad=0.105 pd=1.21 as=0.3875 ps=1.775 w=1 l=0.15
X950 VGND VPWR VGND VGND sky130_fd_pr__nfet_01v8 ad=0.143 pd=1.62 as=0 ps=0 w=0.55 l=0.59
X951 a_8468_5321# a_7387_4949# a_8121_4917# VPWR sky130_fd_pr__pfet_01v8_hvt ad=0.0588 pd=0.7 as=0.12915 ps=1.185 w=0.42 l=0.15
X952 VGND VPWR VGND VGND sky130_fd_pr__nfet_01v8 ad=0.143 pd=1.62 as=0 ps=0 w=0.55 l=0.59
X953 VPWR a_7539_7637# _45_.A VPWR sky130_fd_pr__pfet_01v8_hvt ad=0.26 pd=2.52 as=0.135 ps=1.27 w=1 l=0.15
X954 _32_.Y _32_.A VPWR VPWR sky130_fd_pr__pfet_01v8_hvt ad=0.135 pd=1.27 as=0.26 ps=2.52 w=1 l=0.15
X955 VPWR VGND VPWR VPWR sky130_fd_pr__pfet_01v8_hvt ad=0.2262 pd=2.26 as=0 ps=0 w=0.87 l=0.59
X956 VPWR VGND VPWR VPWR sky130_fd_pr__pfet_01v8_hvt ad=0.2262 pd=2.26 as=0 ps=0 w=0.87 l=0.59
X957 VGND VPWR VGND VGND sky130_fd_pr__nfet_01v8 ad=0.143 pd=1.62 as=0 ps=0 w=0.55 l=0.59
X958 a_3119_8585# a_2603_8213# a_3024_8573# VGND sky130_fd_pr__special_nfet_01v8 ad=0.0594 pd=0.69 as=0.066 ps=0.745 w=0.36 l=0.15
X959 a_7808_5309# _25_.Y VGND VGND sky130_fd_pr__nfet_01v8 ad=0.066 pd=0.745 as=0.2205 ps=1.89 w=0.42 l=0.15
X960 _56_.Q a_6619_4373# VPWR VPWR sky130_fd_pr__pfet_01v8_hvt ad=0.135 pd=1.27 as=0.3012 ps=2.66 w=1 l=0.15
X961 VGND VPWR VGND VGND sky130_fd_pr__nfet_01v8 ad=0.143 pd=1.62 as=0 ps=0 w=0.55 l=0.59
X962 VPWR VGND VPWR VPWR sky130_fd_pr__pfet_01v8_hvt ad=0.2262 pd=2.26 as=0 ps=0 w=0.87 l=0.59
X963 VPWR VGND VPWR VPWR sky130_fd_pr__pfet_01v8_hvt ad=0.2262 pd=2.26 as=0 ps=0 w=0.87 l=0.59
X964 VPWR VGND VPWR VPWR sky130_fd_pr__pfet_01v8_hvt ad=0.2262 pd=2.26 as=0 ps=0 w=0.87 l=0.59
X965 a_4032_7351# src[0] VGND VGND sky130_fd_pr__nfet_01v8 ad=0.1092 pd=1.36 as=0.10025 ps=0.985 w=0.42 l=0.15
X966 _36_.A a_4167_6147# a_4369_6351# VGND sky130_fd_pr__nfet_01v8 ad=0.08775 pd=0.92 as=0.169 ps=1.82 w=0.65 l=0.15
X967 a_5879_4399# a_5529_4399# a_5784_4399# VPWR sky130_fd_pr__pfet_01v8_hvt ad=0.07245 pd=0.765 as=0.0651 ps=0.73 w=0.42 l=0.15
X968 VPWR _41_.C1 a_5190_5487# VPWR sky130_fd_pr__pfet_01v8_hvt ad=0.165 pd=1.33 as=0.325 ps=2.65 w=1 l=0.15
X969 a_1582_6575# _20_.Y a_1499_6575# VGND sky130_fd_pr__nfet_01v8 ad=0.06825 pd=0.86 as=0.17225 ps=1.83 w=0.65 l=0.15
X970 VGND a_3399_6335# a_3333_6409# VGND sky130_fd_pr__nfet_01v8 ad=0.12495 pd=1.015 as=0.0669 ps=0.75 w=0.42 l=0.15
X971 VPWR VGND VPWR VPWR sky130_fd_pr__pfet_01v8_hvt ad=0.2262 pd=2.26 as=0 ps=0 w=0.87 l=0.59
X972 VGND a_5805_2767# a_5911_2767# VGND sky130_fd_pr__nfet_01v8 ad=0.097 pd=0.975 as=0.1092 ps=1.36 w=0.42 l=0.5
X973 VGND _30_.Y a_3802_9295# VGND sky130_fd_pr__nfet_01v8 ad=0.2205 pd=1.89 as=0.066 ps=0.745 w=0.42 l=0.15
X974 _46_.Y _46_.A VGND VGND sky130_fd_pr__nfet_01v8 ad=0.08775 pd=0.92 as=0.169 ps=1.82 w=0.65 l=0.15
X975 a_5377_7439# _41_.B1 a_5293_7439# VGND sky130_fd_pr__nfet_01v8 ad=0.08775 pd=0.92 as=0.08775 ps=0.92 w=0.65 l=0.15
X976 VPWR VGND VPWR VPWR sky130_fd_pr__pfet_01v8_hvt ad=0.2262 pd=2.26 as=0 ps=0 w=0.87 l=0.59
X977 a_7539_7637# u_loop.u_gh.C VPWR VPWR sky130_fd_pr__pfet_01v8_hvt ad=0.0567 pd=0.69 as=0.0819 ps=0.81 w=0.42 l=0.15
X978 a_2659_6409# a_2309_6037# a_2564_6397# VPWR sky130_fd_pr__pfet_01v8_hvt ad=0.07245 pd=0.765 as=0.0651 ps=0.73 w=0.42 l=0.15
X979 a_6891_6409# a_6541_6037# a_6796_6397# VPWR sky130_fd_pr__pfet_01v8_hvt ad=0.07245 pd=0.765 as=0.0651 ps=0.73 w=0.42 l=0.15
X980 VPWR VGND VPWR VPWR sky130_fd_pr__pfet_01v8_hvt ad=0.2262 pd=2.26 as=0 ps=0 w=0.87 l=0.59
X981 VGND VPWR VGND VGND sky130_fd_pr__nfet_01v8 ad=0.143 pd=1.62 as=0 ps=0 w=0.55 l=0.59
X982 _41_.B1 a_4160_6575# VGND VGND sky130_fd_pr__nfet_01v8 ad=0.08775 pd=0.92 as=0.169 ps=1.82 w=0.65 l=0.15
X983 _28_.Y _28_.A VPWR VPWR sky130_fd_pr__pfet_01v8_hvt ad=0.135 pd=1.27 as=0.26 ps=2.52 w=1 l=0.15
X984 _53_.A a_1835_4373# VPWR VPWR sky130_fd_pr__pfet_01v8_hvt ad=0.135 pd=1.27 as=0.26 ps=2.52 w=1 l=0.15
X985 VPWR VGND VPWR VPWR sky130_fd_pr__pfet_01v8_hvt ad=0.2262 pd=2.26 as=0 ps=0 w=0.87 l=0.59
X986 VGND a_6633_2767# a_6739_2767# VGND sky130_fd_pr__nfet_01v8 ad=0.097 pd=0.975 as=0.1092 ps=1.36 w=0.42 l=0.5
X987 a_5987_4765# a_5363_4399# a_5879_4399# VPWR sky130_fd_pr__pfet_01v8_hvt ad=0.1155 pd=0.97 as=0.07245 ps=0.765 w=0.42 l=0.15
X988 VPWR VGND VPWR VPWR sky130_fd_pr__pfet_01v8_hvt ad=0.2262 pd=2.26 as=0 ps=0 w=0.87 l=0.59
X989 VPWR VGND VPWR VPWR sky130_fd_pr__pfet_01v8_hvt ad=0.2262 pd=2.26 as=0 ps=0 w=0.87 l=0.59
X990 VPWR VGND VPWR VPWR sky130_fd_pr__pfet_01v8_hvt ad=0.2262 pd=2.26 as=0 ps=0 w=0.87 l=0.59
X991 VGND VPWR VGND VGND sky130_fd_pr__nfet_01v8 ad=0.143 pd=1.62 as=0 ps=0 w=0.55 l=0.59
X992 VPWR _64_.Q _64_.D VPWR sky130_fd_pr__pfet_01v8_hvt ad=0.26 pd=2.52 as=0.135 ps=1.27 w=1 l=0.15
X993 VPWR VGND VPWR VPWR sky130_fd_pr__pfet_01v8_hvt ad=0.2262 pd=2.26 as=0 ps=0 w=0.87 l=0.59
X994 a_8011_7119# u_loop.u_gh.C VPWR VPWR sky130_fd_pr__pfet_01v8_hvt ad=0.1092 pd=1.36 as=0.07035 ps=0.755 w=0.42 l=0.15
X995 VGND VPWR VGND VGND sky130_fd_pr__nfet_01v8 ad=0.143 pd=1.62 as=0 ps=0 w=0.55 l=0.59
X996 a_7013_8751# a_5823_8751# a_6904_8751# VGND sky130_fd_pr__special_nfet_01v8 ad=0.0669 pd=0.75 as=0.0711 ps=0.755 w=0.36 l=0.15
X997 a_2767_6031# a_2143_6037# a_2659_6409# VPWR sky130_fd_pr__pfet_01v8_hvt ad=0.1155 pd=0.97 as=0.07245 ps=0.765 w=0.42 l=0.15
X998 a_3041_9661# a_2479_9269# VGND VGND sky130_fd_pr__nfet_01v8 ad=0.0669 pd=0.75 as=0.12495 ps=1.015 w=0.42 l=0.15
X999 VPWR VGND VPWR VPWR sky130_fd_pr__pfet_01v8_hvt ad=0.2262 pd=2.26 as=0 ps=0 w=0.87 l=0.59
X1000 VGND VPWR VGND VGND sky130_fd_pr__nfet_01v8 ad=0.143 pd=1.62 as=0 ps=0 w=0.55 l=0.59
X1001 VGND VPWR VGND VGND sky130_fd_pr__nfet_01v8 ad=0.143 pd=1.62 as=0 ps=0 w=0.55 l=0.59
X1002 VPWR VGND VPWR VPWR sky130_fd_pr__pfet_01v8_hvt ad=0.2262 pd=2.26 as=0 ps=0 w=0.87 l=0.59
X1003 a_5541_9673# a_4351_9301# a_5432_9673# VGND sky130_fd_pr__special_nfet_01v8 ad=0.0669 pd=0.75 as=0.0711 ps=0.755 w=0.36 l=0.15
X1004 VGND a_8183_5461# xb VGND sky130_fd_pr__nfet_01v8 ad=0.169 pd=1.82 as=0.08775 ps=0.92 w=0.65 l=0.15
X1005 a_4351_4175# u_loop.u_gh.C VGND VGND sky130_fd_pr__nfet_01v8 ad=0.08775 pd=0.92 as=0.08775 ps=0.92 w=0.65 l=0.15
X1006 VGND VPWR VGND VGND sky130_fd_pr__nfet_01v8 ad=0.143 pd=1.62 as=0 ps=0 w=0.55 l=0.59
X1007 VPWR VGND VPWR VPWR sky130_fd_pr__pfet_01v8_hvt ad=0.2262 pd=2.26 as=0 ps=0 w=0.87 l=0.59
X1008 VGND VPWR VGND VGND sky130_fd_pr__nfet_01v8 ad=0.143 pd=1.62 as=0 ps=0 w=0.55 l=0.59
X1009 VPWR _46_.A _31_.Y VPWR sky130_fd_pr__pfet_01v8_hvt ad=0.26 pd=2.52 as=0.135 ps=1.27 w=1 l=0.15
X1010 a_4963_9673# a_4517_9301# a_4867_9673# VGND sky130_fd_pr__special_nfet_01v8 ad=0.1401 pd=1.1 as=0.0594 ps=0.69 w=0.36 l=0.15
X1011 VPWR VGND VPWR VPWR sky130_fd_pr__pfet_01v8_hvt ad=0.2262 pd=2.26 as=0 ps=0 w=0.87 l=0.59
X1012 a_2401_4949# a_2235_4949# VPWR VPWR sky130_fd_pr__pfet_01v8_hvt ad=0.1664 pd=1.8 as=0.0864 ps=0.91 w=0.64 l=0.15
X1013 VGND VPWR VGND VGND sky130_fd_pr__nfet_01v8 ad=0.143 pd=1.62 as=0 ps=0 w=0.55 l=0.59
X1014 VPWR VGND VPWR VPWR sky130_fd_pr__pfet_01v8_hvt ad=0.2262 pd=2.26 as=0 ps=0 w=0.87 l=0.59
X1015 VPWR VGND VPWR VPWR sky130_fd_pr__pfet_01v8_hvt ad=0.2262 pd=2.26 as=0 ps=0 w=0.87 l=0.59
X1016 _31_.Y _46_.A VGND VGND sky130_fd_pr__nfet_01v8 ad=0.08775 pd=0.92 as=0.169 ps=1.82 w=0.65 l=0.15
X1017 a_8468_7497# a_7553_7125# a_8121_7093# VGND sky130_fd_pr__special_nfet_01v8 ad=0.0711 pd=0.755 as=0.0999 ps=0.985 w=0.36 l=0.15
X1018 a_7732_4233# a_6817_3861# a_7385_3829# VGND sky130_fd_pr__special_nfet_01v8 ad=0.0711 pd=0.755 as=0.0999 ps=0.985 w=0.36 l=0.15
X1019 VGND VPWR VGND VGND sky130_fd_pr__nfet_01v8 ad=0.143 pd=1.62 as=0 ps=0 w=0.55 l=0.59
X1020 a_5069_2767# a_4833_2767# VPWR VPWR sky130_fd_pr__pfet_01v8_hvt ad=0.1092 pd=1.36 as=0.0567 ps=0.69 w=0.42 l=0.5
X1021 VGND VPWR VGND VGND sky130_fd_pr__nfet_01v8 ad=0.143 pd=1.62 as=0 ps=0 w=0.55 l=0.59
X1022 a_4769_4175# u_loop.u_d0.A prenh VGND sky130_fd_pr__nfet_01v8 ad=0.1755 pd=1.84 as=0.08775 ps=0.92 w=0.65 l=0.15
X1023 a_2233_7905# a_2015_7663# VPWR VPWR sky130_fd_pr__pfet_01v8_hvt ad=0.12915 pd=1.185 as=0.2184 ps=2.2 w=0.84 l=0.15
X1024 _51_.Y _64_.Q VGND VGND sky130_fd_pr__nfet_01v8 ad=0.08775 pd=0.92 as=0.169 ps=1.82 w=0.65 l=0.15
X1025 a_4158_7235# _40_.B a_4074_7235# VPWR sky130_fd_pr__pfet_01v8_hvt ad=0.0567 pd=0.69 as=0.0567 ps=0.69 w=0.42 l=0.15
X1026 a_6457_2473# u_loop.u_q.B u_loop.u_d0.A VPWR sky130_fd_pr__pfet_01v8_hvt ad=0.105 pd=1.21 as=0.26 ps=2.52 w=1 l=0.15
X1027 prenh u_loop.u_gh.C VPWR VPWR sky130_fd_pr__pfet_01v8_hvt ad=0.135 pd=1.27 as=0.135 ps=1.27 w=1 l=0.15
X1028 VPWR VGND VPWR VPWR sky130_fd_pr__pfet_01v8_hvt ad=0.2262 pd=2.26 as=0 ps=0 w=0.87 l=0.59
X1029 VPWR a_2439_4541# a_2400_4667# VPWR sky130_fd_pr__pfet_01v8_hvt ad=0.0864 pd=0.91 as=0.1664 ps=1.8 w=0.64 l=0.15
X1030 VPWR VGND VPWR VPWR sky130_fd_pr__pfet_01v8_hvt ad=0.2262 pd=2.26 as=0 ps=0 w=0.87 l=0.59
X1031 VPWR VGND VPWR VPWR sky130_fd_pr__pfet_01v8_hvt ad=0.2262 pd=2.26 as=0 ps=0 w=0.87 l=0.59
X1032 a_3083_9537# _49_.Y VPWR VPWR sky130_fd_pr__pfet_01v8_hvt ad=0.1664 pd=1.8 as=0.0864 ps=0.91 w=0.64 l=0.15
X1033 u_loop.u_q.B u_loop.u_s2.Y VGND VGND sky130_fd_pr__nfet_01v8 ad=0.08775 pd=0.92 as=0.169 ps=1.82 w=0.65 l=0.15
X1034 VGND VPWR VGND VGND sky130_fd_pr__nfet_01v8 ad=0.143 pd=1.62 as=0 ps=0 w=0.55 l=0.59
X1035 a_3024_8573# _62_.D VPWR VPWR sky130_fd_pr__pfet_01v8_hvt ad=0.0651 pd=0.73 as=0.1092 ps=1.36 w=0.42 l=0.15
X1036 a_3430_7235# a_3388_7351# a_3348_7235# VPWR sky130_fd_pr__pfet_01v8_hvt ad=0.0567 pd=0.69 as=0.1092 ps=1.36 w=0.42 l=0.15
X1037 a_2595_4636# a_2400_4667# a_2905_4399# VGND sky130_fd_pr__special_nfet_01v8 ad=0.0594 pd=0.69 as=0.1401 ps=1.1 w=0.36 l=0.15
X1038 a_5529_4399# a_5363_4399# VPWR VPWR sky130_fd_pr__pfet_01v8_hvt ad=0.1664 pd=1.8 as=0.0864 ps=0.91 w=0.64 l=0.15
X1039 a_6097_4641# a_5879_4399# VPWR VPWR sky130_fd_pr__pfet_01v8_hvt ad=0.12915 pd=1.185 as=0.2184 ps=2.2 w=0.84 l=0.15
X1040 a_7473_7663# a_6283_7663# a_7364_7663# VGND sky130_fd_pr__special_nfet_01v8 ad=0.0669 pd=0.75 as=0.0711 ps=0.755 w=0.36 l=0.15
X1041 a_8170_5853# a_7093_5487# a_8008_5487# VPWR sky130_fd_pr__pfet_01v8_hvt ad=0.0567 pd=0.69 as=0.0588 ps=0.7 w=0.42 l=0.15
X1042 a_7661_5729# a_7443_5487# VGND VGND sky130_fd_pr__nfet_01v8 ad=0.0999 pd=0.985 as=0.1346 ps=1.15 w=0.64 l=0.15
X1043 a_7079_8725# u_loop.u_gh.C VPWR VPWR sky130_fd_pr__pfet_01v8_hvt ad=0.0567 pd=0.69 as=0.0819 ps=0.81 w=0.42 l=0.15
X1044 VGND VPWR VGND VGND sky130_fd_pr__nfet_01v8 ad=0.143 pd=1.62 as=0 ps=0 w=0.55 l=0.59
X1045 VPWR VGND VPWR VPWR sky130_fd_pr__pfet_01v8_hvt ad=0.2262 pd=2.26 as=0 ps=0 w=0.87 l=0.59
X1046 VPWR a_7631_6335# _32_.A VPWR sky130_fd_pr__pfet_01v8_hvt ad=0.26 pd=2.52 as=0.135 ps=1.27 w=1 l=0.15
X1047 a_6817_3861# a_6651_3861# VGND VGND sky130_fd_pr__nfet_01v8 ad=0.1092 pd=1.36 as=0.0567 ps=0.69 w=0.42 l=0.15
X1048 VGND VPWR VGND VGND sky130_fd_pr__nfet_01v8 ad=0.143 pd=1.62 as=0 ps=0 w=0.55 l=0.59
X1049 a_5649_7119# _36_.A a_5190_7439# VPWR sky130_fd_pr__pfet_01v8_hvt ad=0.105 pd=1.21 as=0.3875 ps=1.775 w=1 l=0.15
X1050 a_4076_3561# u_loop.u_gl.B1 prenl VPWR sky130_fd_pr__pfet_01v8_hvt ad=0.14 pd=1.28 as=0.14 ps=1.28 w=1 l=0.15
X1051 a_2122_4651# a_2439_4541# a_2397_4399# VGND sky130_fd_pr__special_nfet_01v8 ad=0.0711 pd=0.755 as=0.0669 ps=0.75 w=0.36 l=0.15
X1052 _39_.B2 a_5607_9599# VPWR VPWR sky130_fd_pr__pfet_01v8_hvt ad=0.135 pd=1.27 as=0.3012 ps=2.66 w=1 l=0.15
X1053 _45_.A a_7539_7637# VPWR VPWR sky130_fd_pr__pfet_01v8_hvt ad=0.135 pd=1.27 as=0.3012 ps=2.66 w=1 l=0.15
X1054 _48_.Y _30_.A VGND VGND sky130_fd_pr__nfet_01v8 ad=0.08775 pd=0.92 as=0.169 ps=1.82 w=0.65 l=0.15
X1055 a_6895_7663# a_6449_7663# a_6799_7663# VGND sky130_fd_pr__special_nfet_01v8 ad=0.1401 pd=1.1 as=0.0594 ps=0.69 w=0.36 l=0.15
X1056 a_7718_7663# u_loop.u_gh.C VGND VGND sky130_fd_pr__nfet_01v8 ad=0.06405 pd=0.725 as=0.12495 ps=1.015 w=0.42 l=0.15
X1057 a_7553_7125# a_7387_7125# VGND VGND sky130_fd_pr__nfet_01v8 ad=0.1092 pd=1.36 as=0.0567 ps=0.69 w=0.42 l=0.15
X1058 _32_.A a_7631_6335# VGND VGND sky130_fd_pr__nfet_01v8 ad=0.08775 pd=0.92 as=0.2087 ps=2.02 w=0.65 l=0.15
X1059 VGND VPWR VGND VGND sky130_fd_pr__nfet_01v8 ad=0.143 pd=1.62 as=0 ps=0 w=0.55 l=0.59
X1060 VGND VPWR VGND VGND sky130_fd_pr__nfet_01v8 ad=0.143 pd=1.62 as=0 ps=0 w=0.55 l=0.59
X1061 VGND VPWR VGND VGND sky130_fd_pr__nfet_01v8 ad=0.143 pd=1.62 as=0 ps=0 w=0.55 l=0.59
X1062 VGND VPWR VGND VGND sky130_fd_pr__nfet_01v8 ad=0.143 pd=1.62 as=0 ps=0 w=0.55 l=0.59
X1063 VPWR VGND VPWR VPWR sky130_fd_pr__pfet_01v8_hvt ad=0.2262 pd=2.26 as=0 ps=0 w=0.87 l=0.59
X1064 VGND u_loop.u_gh.C a_2921_6397# VGND sky130_fd_pr__nfet_01v8 ad=0.1346 pd=1.15 as=0.0441 ps=0.63 w=0.42 l=0.15
X1065 a_3399_6335# a_3224_6409# a_3578_6397# VGND sky130_fd_pr__nfet_01v8 ad=0.1092 pd=1.36 as=0.06405 ps=0.725 w=0.42 l=0.15
X1066 a_7631_6335# a_7456_6409# a_7810_6397# VGND sky130_fd_pr__nfet_01v8 ad=0.1092 pd=1.36 as=0.06405 ps=0.725 w=0.42 l=0.15
X1067 a_8630_4943# a_7553_4949# a_8468_5321# VPWR sky130_fd_pr__pfet_01v8_hvt ad=0.0567 pd=0.69 as=0.0588 ps=0.7 w=0.42 l=0.15
X1068 VPWR VGND VPWR VPWR sky130_fd_pr__pfet_01v8_hvt ad=0.2262 pd=2.26 as=0 ps=0 w=0.87 l=0.59
X1069 VPWR VGND VPWR VPWR sky130_fd_pr__pfet_01v8_hvt ad=0.2262 pd=2.26 as=0 ps=0 w=0.87 l=0.59
X1070 VPWR _38_.X a_5190_7439# VPWR sky130_fd_pr__pfet_01v8_hvt ad=0.165 pd=1.33 as=0.325 ps=2.65 w=1 l=0.15
X1071 VGND VPWR VGND VGND sky130_fd_pr__nfet_01v8 ad=0.143 pd=1.62 as=0 ps=0 w=0.55 l=0.59
X1072 VPWR a_7907_4159# _55_.Q VPWR sky130_fd_pr__pfet_01v8_hvt ad=0.26 pd=2.52 as=0.135 ps=1.27 w=1 l=0.15
X1073 _63_.Q a_2755_7637# VGND VGND sky130_fd_pr__nfet_01v8 ad=0.08775 pd=0.92 as=0.2087 ps=2.02 w=0.65 l=0.15
X1074 a_4032_7351# src[0] VPWR VPWR sky130_fd_pr__pfet_01v8_hvt ad=0.1092 pd=1.36 as=0.14575 ps=1.335 w=0.42 l=0.15
X1075 VPWR VGND VPWR VPWR sky130_fd_pr__pfet_01v8_hvt ad=0.2262 pd=2.26 as=0 ps=0 w=0.87 l=0.59
X1076 a_5784_4399# _56_.D VGND VGND sky130_fd_pr__nfet_01v8 ad=0.066 pd=0.745 as=0.2205 ps=1.89 w=0.42 l=0.15
X1077 a_4772_9661# _21_.Y VGND VGND sky130_fd_pr__nfet_01v8 ad=0.066 pd=0.745 as=0.2205 ps=1.89 w=0.42 l=0.15
X1078 VPWR a_7661_5729# a_7551_5853# VPWR sky130_fd_pr__pfet_01v8_hvt ad=0.07035 pd=0.755 as=0.1155 ps=0.97 w=0.42 l=0.15
X1079 a_7553_4949# a_7387_4949# VPWR VPWR sky130_fd_pr__pfet_01v8_hvt ad=0.1664 pd=1.8 as=0.0864 ps=0.91 w=0.64 l=0.15
X1080 a_3388_7351# src[0] VGND VGND sky130_fd_pr__nfet_01v8 ad=0.1092 pd=1.36 as=0.10025 ps=0.985 w=0.42 l=0.15
X1081 VPWR VGND VPWR VPWR sky130_fd_pr__pfet_01v8_hvt ad=0.2262 pd=2.26 as=0 ps=0 w=0.87 l=0.59
X1082 VGND VPWR VGND VGND sky130_fd_pr__nfet_01v8 ad=0.143 pd=1.62 as=0 ps=0 w=0.55 l=0.59
X1083 VGND VPWR VGND VGND sky130_fd_pr__nfet_01v8 ad=0.143 pd=1.62 as=0 ps=0 w=0.55 l=0.59
X1084 VGND VPWR VGND VGND sky130_fd_pr__nfet_01v8 ad=0.143 pd=1.62 as=0 ps=0 w=0.55 l=0.59
X1085 VGND u_loop.u_gh.C a_2277_7663# VGND sky130_fd_pr__nfet_01v8 ad=0.1346 pd=1.15 as=0.0441 ps=0.63 w=0.42 l=0.15
X1086 VPWR VGND VPWR VPWR sky130_fd_pr__pfet_01v8_hvt ad=0.2262 pd=2.26 as=0 ps=0 w=0.87 l=0.59
X1087 VGND a_3083_9537# a_3044_9411# VGND sky130_fd_pr__nfet_01v8 ad=0.0567 pd=0.69 as=0.1092 ps=1.36 w=0.42 l=0.15
X1088 VPWR VGND VPWR VPWR sky130_fd_pr__pfet_01v8_hvt ad=0.2262 pd=2.26 as=0 ps=0 w=0.87 l=0.59
X1089 a_7903_7497# a_7553_7125# a_7808_7485# VPWR sky130_fd_pr__pfet_01v8_hvt ad=0.07245 pd=0.765 as=0.0651 ps=0.73 w=0.42 l=0.15
X1090 u_loop.u_gh.C a_1499_6575# VGND VGND sky130_fd_pr__nfet_01v8 ad=0.091 pd=0.93 as=0.104 ps=0.97 w=0.65 l=0.15
X1091 VGND _57_.CLK a_6375_6037# VGND sky130_fd_pr__nfet_01v8 ad=0.0567 pd=0.69 as=0.1092 ps=1.36 w=0.42 l=0.15
X1092 VPWR VGND VPWR VPWR sky130_fd_pr__pfet_01v8_hvt ad=0.2262 pd=2.26 as=0 ps=0 w=0.87 l=0.59
X1093 VPWR VGND VPWR VPWR sky130_fd_pr__pfet_01v8_hvt ad=0.2262 pd=2.26 as=0 ps=0 w=0.87 l=0.59
X1094 a_8008_5487# a_7093_5487# a_7661_5729# VGND sky130_fd_pr__special_nfet_01v8 ad=0.0711 pd=0.755 as=0.0999 ps=0.985 w=0.36 l=0.15
X1095 VGND u_loop.u_gh.B u_loop.u_gl.A2 VGND sky130_fd_pr__nfet_01v8 ad=0.169 pd=1.82 as=0.169 ps=1.82 w=0.65 l=0.15
X1096 VGND VPWR VGND VGND sky130_fd_pr__nfet_01v8 ad=0.143 pd=1.62 as=0 ps=0 w=0.55 l=0.59
X1097 VPWR VGND VPWR VPWR sky130_fd_pr__pfet_01v8_hvt ad=0.2262 pd=2.26 as=0 ps=0 w=0.87 l=0.59
X1098 VGND u_loop.u_d3.X a_4097_2767# VGND sky130_fd_pr__nfet_01v8 ad=0.0567 pd=0.69 as=0.1092 ps=1.36 w=0.42 l=0.15
X1099 VPWR _39_.X a_7387_7125# VPWR sky130_fd_pr__pfet_01v8_hvt ad=0.0864 pd=0.91 as=0.1664 ps=1.8 w=0.64 l=0.15
X1100 a_7263_4233# a_6817_3861# a_7167_4233# VGND sky130_fd_pr__special_nfet_01v8 ad=0.1401 pd=1.1 as=0.0594 ps=0.69 w=0.36 l=0.15
X1101 VGND VPWR VGND VGND sky130_fd_pr__nfet_01v8 ad=0.143 pd=1.62 as=0 ps=0 w=0.55 l=0.59
X1102 a_4351_4175# u_loop.u_gh.C VGND VGND sky130_fd_pr__nfet_01v8 ad=0.08775 pd=0.92 as=0.08775 ps=0.92 w=0.65 l=0.15
X1103 a_8011_7119# a_7387_7125# a_7903_7497# VPWR sky130_fd_pr__pfet_01v8_hvt ad=0.1155 pd=0.97 as=0.07245 ps=0.765 w=0.42 l=0.15
X1104 a_2767_6031# u_loop.u_gh.C VPWR VPWR sky130_fd_pr__pfet_01v8_hvt ad=0.1092 pd=1.36 as=0.07035 ps=0.755 w=0.42 l=0.15
X1105 VGND VPWR VGND VGND sky130_fd_pr__nfet_01v8 ad=0.143 pd=1.62 as=0 ps=0 w=0.55 l=0.59
X1106 VPWR a_3348_7235# _38_.X VPWR sky130_fd_pr__pfet_01v8_hvt ad=0.14575 pd=1.335 as=0.135 ps=1.27 w=1 l=0.15
X1107 VGND VPWR VGND VGND sky130_fd_pr__nfet_01v8 ad=0.143 pd=1.62 as=0 ps=0 w=0.55 l=0.59
X1108 VPWR VGND VPWR VPWR sky130_fd_pr__pfet_01v8_hvt ad=0.2262 pd=2.26 as=0 ps=0 w=0.87 l=0.59
X1109 VPWR VGND VPWR VPWR sky130_fd_pr__pfet_01v8_hvt ad=0.2262 pd=2.26 as=0 ps=0 w=0.87 l=0.59
X1110 VGND _25_.A a_5377_5487# VGND sky130_fd_pr__nfet_01v8 ad=0.08775 pd=0.92 as=0.08775 ps=0.92 w=0.65 l=0.15
X1111 VGND VPWR VGND VGND sky130_fd_pr__nfet_01v8 ad=0.143 pd=1.62 as=0 ps=0 w=0.55 l=0.59
X1112 VGND VPWR VGND VGND sky130_fd_pr__nfet_01v8 ad=0.143 pd=1.62 as=0 ps=0 w=0.55 l=0.59
X1113 VGND _55_.Q _42_.Y VGND sky130_fd_pr__nfet_01v8 ad=0.169 pd=1.82 as=0.08775 ps=0.92 w=0.65 l=0.15
X1114 VGND _47_.Y a_5823_8751# VGND sky130_fd_pr__nfet_01v8 ad=0.0567 pd=0.69 as=0.1092 ps=1.36 w=0.42 l=0.15
X1115 a_2769_8213# a_2603_8213# VPWR VPWR sky130_fd_pr__pfet_01v8_hvt ad=0.1664 pd=1.8 as=0.0864 ps=0.91 w=0.64 l=0.15
X1116 VPWR VGND VPWR VPWR sky130_fd_pr__pfet_01v8_hvt ad=0.2262 pd=2.26 as=0 ps=0 w=0.87 l=0.59
X1117 VPWR VGND VPWR VPWR sky130_fd_pr__pfet_01v8_hvt ad=0.2262 pd=2.26 as=0 ps=0 w=0.87 l=0.59
X1118 VGND VPWR VGND VGND sky130_fd_pr__nfet_01v8 ad=0.143 pd=1.62 as=0 ps=0 w=0.55 l=0.59
X1119 _38_.X a_3348_7235# VGND VGND sky130_fd_pr__nfet_01v8 ad=0.08775 pd=0.92 as=0.10187 ps=0.99 w=0.65 l=0.15
X1120 VPWR src[0] a_4518_6825# VPWR sky130_fd_pr__pfet_01v8_hvt ad=0.135 pd=1.27 as=0.26 ps=2.52 w=1 l=0.15
X1121 a_7109_6005# a_6891_6409# VGND VGND sky130_fd_pr__nfet_01v8 ad=0.0999 pd=0.985 as=0.1346 ps=1.15 w=0.64 l=0.15
X1122 a_6435_8751# a_5989_8751# a_6339_8751# VGND sky130_fd_pr__special_nfet_01v8 ad=0.1401 pd=1.1 as=0.0594 ps=0.69 w=0.36 l=0.15
X1123 a_7258_8751# u_loop.u_gh.C VGND VGND sky130_fd_pr__nfet_01v8 ad=0.06405 pd=0.725 as=0.12495 ps=1.015 w=0.42 l=0.15
X1124 VPWR _64_.Q _51_.Y VPWR sky130_fd_pr__pfet_01v8_hvt ad=0.26 pd=2.52 as=0.135 ps=1.27 w=1 l=0.15
X1125 VPWR VGND VPWR VPWR sky130_fd_pr__pfet_01v8_hvt ad=0.2262 pd=2.26 as=0 ps=0 w=0.87 l=0.59
X1126 VGND a_6619_4373# _56_.Q VGND sky130_fd_pr__nfet_01v8 ad=0.169 pd=1.82 as=0.08775 ps=0.92 w=0.65 l=0.15
X1127 a_2740_4765# a_2526_4765# VPWR VPWR sky130_fd_pr__pfet_01v8_hvt ad=0.1155 pd=0.97 as=0.07035 ps=0.755 w=0.42 l=0.15
X1128 a_4769_4175# u_loop.u_d0.A prenh VGND sky130_fd_pr__nfet_01v8 ad=0.08775 pd=0.92 as=0.08775 ps=0.92 w=0.65 l=0.15
X1129 VPWR VGND VPWR VPWR sky130_fd_pr__pfet_01v8_hvt ad=0.2262 pd=2.26 as=0 ps=0 w=0.87 l=0.59
X1130 VPWR VGND VPWR VPWR sky130_fd_pr__pfet_01v8_hvt ad=0.2262 pd=2.26 as=0 ps=0 w=0.87 l=0.59
X1131 VGND VPWR VGND VGND sky130_fd_pr__nfet_01v8 ad=0.143 pd=1.62 as=0 ps=0 w=0.55 l=0.59
X1132 a_4351_4175# u_loop.u_gh.B a_4769_4175# VGND sky130_fd_pr__nfet_01v8 ad=0.169 pd=1.82 as=0.08775 ps=0.92 w=0.65 l=0.15
X1133 _36_.A src[1] VPWR VPWR sky130_fd_pr__pfet_01v8_hvt ad=0.135 pd=1.27 as=0.335 ps=1.67 w=1 l=0.15
X1134 VPWR VGND VPWR VPWR sky130_fd_pr__pfet_01v8_hvt ad=0.2262 pd=2.26 as=0 ps=0 w=0.87 l=0.59
X1135 VPWR a_2755_7637# _63_.Q VPWR sky130_fd_pr__pfet_01v8_hvt ad=0.26 pd=2.52 as=0.135 ps=1.27 w=1 l=0.15
X1136 VPWR _39_.B2 _21_.Y VPWR sky130_fd_pr__pfet_01v8_hvt ad=0.26 pd=2.52 as=0.135 ps=1.27 w=1 l=0.15
X1137 a_7429_4221# a_7385_3829# a_7263_4233# VGND sky130_fd_pr__nfet_01v8 ad=0.0441 pd=0.63 as=0.1401 ps=1.1 w=0.42 l=0.15
X1138 a_7565_6409# a_6375_6037# a_7456_6409# VGND sky130_fd_pr__special_nfet_01v8 ad=0.0669 pd=0.75 as=0.0711 ps=0.755 w=0.36 l=0.15
X1139 VGND VPWR VGND VGND sky130_fd_pr__nfet_01v8 ad=0.143 pd=1.62 as=0 ps=0 w=0.55 l=0.59
X1140 VGND a_8643_7423# a_8577_7497# VGND sky130_fd_pr__nfet_01v8 ad=0.12495 pd=1.015 as=0.0669 ps=0.75 w=0.42 l=0.15
X1141 a_8165_7485# a_8121_7093# a_7999_7497# VGND sky130_fd_pr__nfet_01v8 ad=0.0441 pd=0.63 as=0.1401 ps=1.1 w=0.42 l=0.15
X1142 VGND VPWR VGND VGND sky130_fd_pr__nfet_01v8 ad=0.143 pd=1.62 as=0 ps=0 w=0.55 l=0.59
X1143 VGND VPWR VGND VGND sky130_fd_pr__nfet_01v8 ad=0.143 pd=1.62 as=0 ps=0 w=0.55 l=0.59
X1144 VGND VPWR VGND VGND sky130_fd_pr__nfet_01v8 ad=0.143 pd=1.62 as=0 ps=0 w=0.55 l=0.59
X1145 a_6987_6409# a_6541_6037# a_6891_6409# VGND sky130_fd_pr__special_nfet_01v8 ad=0.1401 pd=1.1 as=0.0594 ps=0.69 w=0.36 l=0.15
X1146 _25_.A a_8643_5247# VGND VGND sky130_fd_pr__nfet_01v8 ad=0.08775 pd=0.92 as=0.2087 ps=2.02 w=0.65 l=0.15
X1147 VPWR a_8643_7423# xa VPWR sky130_fd_pr__pfet_01v8_hvt ad=0.26 pd=2.52 as=0.135 ps=1.27 w=1 l=0.15
X1148 VGND _45_.A _57_.CLK VGND sky130_fd_pr__nfet_01v8 ad=0.169 pd=1.82 as=0.08775 ps=0.92 w=0.65 l=0.15
X1149 prenl u_loop.u_gl.B1 a_4076_3561# VPWR sky130_fd_pr__pfet_01v8_hvt ad=0.14 pd=1.28 as=0.14 ps=1.28 w=1 l=0.15
X1150 _25_.Y _25_.A VPWR VPWR sky130_fd_pr__pfet_01v8_hvt ad=0.135 pd=1.27 as=0.26 ps=2.52 w=1 l=0.15
X1151 VPWR a_6619_4373# a_6606_4765# VPWR sky130_fd_pr__pfet_01v8_hvt ad=0.0819 pd=0.81 as=0.0567 ps=0.69 w=0.42 l=0.15
X1152 VPWR VGND VPWR VPWR sky130_fd_pr__pfet_01v8_hvt ad=0.2262 pd=2.26 as=0 ps=0 w=0.87 l=0.59
X1153 VGND src[0] a_4160_6575# VGND sky130_fd_pr__nfet_01v8 ad=0.08775 pd=0.92 as=0.08775 ps=0.92 w=0.65 l=0.15
X1154 VGND VPWR VGND VGND sky130_fd_pr__nfet_01v8 ad=0.143 pd=1.62 as=0 ps=0 w=0.55 l=0.59
X1155 a_7072_4221# _55_.D VGND VGND sky130_fd_pr__nfet_01v8 ad=0.066 pd=0.745 as=0.2205 ps=1.89 w=0.42 l=0.15
X1156 VGND a_6619_4373# a_6553_4399# VGND sky130_fd_pr__nfet_01v8 ad=0.12495 pd=1.015 as=0.0669 ps=0.75 w=0.42 l=0.15
X1157 VGND a_5607_9599# a_5541_9673# VGND sky130_fd_pr__nfet_01v8 ad=0.12495 pd=1.015 as=0.0669 ps=0.75 w=0.42 l=0.15
X1158 VGND VPWR VGND VGND sky130_fd_pr__nfet_01v8 ad=0.143 pd=1.62 as=0 ps=0 w=0.55 l=0.59
X1159 a_6449_7663# a_6283_7663# VPWR VPWR sky130_fd_pr__pfet_01v8_hvt ad=0.1664 pd=1.8 as=0.0864 ps=0.91 w=0.64 l=0.15
X1160 a_1654_6575# en a_1582_6575# VGND sky130_fd_pr__nfet_01v8 ad=0.16535 pd=1.82 as=0.06825 ps=0.86 w=0.65 l=0.15
X1161 VGND u_loop.u_gh.C a_7153_6397# VGND sky130_fd_pr__nfet_01v8 ad=0.1346 pd=1.15 as=0.0441 ps=0.63 w=0.42 l=0.15
X1162 a_2125_2767# a_1889_2767# VGND VGND sky130_fd_pr__nfet_01v8 ad=0.1092 pd=1.36 as=0.0567 ps=0.69 w=0.42 l=0.5
X1163 VGND VPWR VGND VGND sky130_fd_pr__nfet_01v8 ad=0.143 pd=1.62 as=0 ps=0 w=0.55 l=0.59
X1164 VGND VPWR VGND VGND sky130_fd_pr__nfet_01v8 ad=0.143 pd=1.62 as=0 ps=0 w=0.55 l=0.59
X1165 VGND _46_.Y a_6283_7663# VGND sky130_fd_pr__nfet_01v8 ad=0.0567 pd=0.69 as=0.1092 ps=1.36 w=0.42 l=0.15
X1166 VPWR a_3399_6335# a_3386_6031# VPWR sky130_fd_pr__pfet_01v8_hvt ad=0.0819 pd=0.81 as=0.0567 ps=0.69 w=0.42 l=0.15
X1167 a_8117_5487# a_6927_5487# a_8008_5487# VGND sky130_fd_pr__special_nfet_01v8 ad=0.0669 pd=0.75 as=0.0711 ps=0.755 w=0.36 l=0.15
X1168 VGND _50_.Y a_2603_8213# VGND sky130_fd_pr__nfet_01v8 ad=0.0567 pd=0.69 as=0.1092 ps=1.36 w=0.42 l=0.15
X1169 a_2755_7637# u_loop.u_gh.C VPWR VPWR sky130_fd_pr__pfet_01v8_hvt ad=0.0567 pd=0.69 as=0.0819 ps=0.81 w=0.42 l=0.15
X1170 _63_.D _63_.Q VPWR VPWR sky130_fd_pr__pfet_01v8_hvt ad=0.135 pd=1.27 as=0.26 ps=2.52 w=1 l=0.15
X1171 a_6799_7663# a_6449_7663# a_6704_7663# VPWR sky130_fd_pr__pfet_01v8_hvt ad=0.07245 pd=0.765 as=0.0651 ps=0.73 w=0.42 l=0.15
X1172 a_3388_7351# src[0] VPWR VPWR sky130_fd_pr__pfet_01v8_hvt ad=0.1092 pd=1.36 as=0.14575 ps=1.335 w=0.42 l=0.15
X1173 VPWR VGND VPWR VPWR sky130_fd_pr__pfet_01v8_hvt ad=0.2262 pd=2.26 as=0 ps=0 w=0.87 l=0.59
X1174 a_5190_5487# _56_.Q a_5389_5737# VPWR sky130_fd_pr__pfet_01v8_hvt ad=0.3875 pd=1.775 as=0.1125 ps=1.225 w=1 l=0.15
X1175 VPWR VGND VPWR VPWR sky130_fd_pr__pfet_01v8_hvt ad=0.2262 pd=2.26 as=0 ps=0 w=0.87 l=0.59
X1176 a_4038_8573# u_loop.u_gh.C VGND VGND sky130_fd_pr__nfet_01v8 ad=0.06405 pd=0.725 as=0.12495 ps=1.015 w=0.42 l=0.15
X1177 VGND VPWR VGND VGND sky130_fd_pr__nfet_01v8 ad=0.143 pd=1.62 as=0 ps=0 w=0.55 l=0.59
X1178 a_5989_8751# a_5823_8751# VPWR VPWR sky130_fd_pr__pfet_01v8_hvt ad=0.1664 pd=1.8 as=0.0864 ps=0.91 w=0.64 l=0.15
X1179 u_loop.u_s2.Y u_loop.u_s2.A VPWR VPWR sky130_fd_pr__pfet_01v8_hvt ad=0.26 pd=2.52 as=0.26 ps=2.52 w=1 l=0.15
X1180 _46_.A a_7079_8725# VPWR VPWR sky130_fd_pr__pfet_01v8_hvt ad=0.135 pd=1.27 as=0.3012 ps=2.66 w=1 l=0.15
X1181 _41_.X a_5190_5487# VPWR VPWR sky130_fd_pr__pfet_01v8_hvt ad=0.135 pd=1.27 as=0.165 ps=1.33 w=1 l=0.15
X1182 VPWR VGND VPWR VPWR sky130_fd_pr__pfet_01v8_hvt ad=0.2262 pd=2.26 as=0 ps=0 w=0.87 l=0.59
X1183 VGND VPWR VGND VGND sky130_fd_pr__nfet_01v8 ad=0.143 pd=1.62 as=0 ps=0 w=0.55 l=0.59
X1184 VGND VPWR VGND VGND sky130_fd_pr__nfet_01v8 ad=0.143 pd=1.62 as=0 ps=0 w=0.55 l=0.59
X1185 VPWR VGND VPWR VPWR sky130_fd_pr__pfet_01v8_hvt ad=0.2262 pd=2.26 as=0 ps=0 w=0.87 l=0.59
X1186 xb a_8183_5461# VPWR VPWR sky130_fd_pr__pfet_01v8_hvt ad=0.135 pd=1.27 as=0.3012 ps=2.66 w=1 l=0.15
X1187 VPWR u_loop.u_d1.X a_2625_2767# VPWR sky130_fd_pr__pfet_01v8_hvt ad=0.0567 pd=0.69 as=0.1092 ps=1.36 w=0.42 l=0.15
X1188 VGND u_loop.u_gl.A2 a_4510_3311# VGND sky130_fd_pr__nfet_01v8 ad=0.17225 pd=1.83 as=0.091 ps=0.93 w=0.65 l=0.15
X1189 a_6907_8029# a_6283_7663# a_6799_7663# VPWR sky130_fd_pr__pfet_01v8_hvt ad=0.1155 pd=0.97 as=0.07245 ps=0.765 w=0.42 l=0.15
X1190 a_8362_5487# u_loop.u_gh.C VGND VGND sky130_fd_pr__nfet_01v8 ad=0.06405 pd=0.725 as=0.12495 ps=1.015 w=0.42 l=0.15
X1191 VPWR VGND VPWR VPWR sky130_fd_pr__pfet_01v8_hvt ad=0.2262 pd=2.26 as=0 ps=0 w=0.87 l=0.59
X1192 VPWR a_3337_8181# a_3227_8207# VPWR sky130_fd_pr__pfet_01v8_hvt ad=0.07035 pd=0.755 as=0.1155 ps=0.97 w=0.42 l=0.15
X1193 VGND u_loop.u_d0.X a_2533_2223# VGND sky130_fd_pr__nfet_01v8 ad=0.0567 pd=0.69 as=0.1092 ps=1.36 w=0.42 l=0.15
X1194 VGND VPWR VGND VGND sky130_fd_pr__nfet_01v8 ad=0.143 pd=1.62 as=0 ps=0 w=0.55 l=0.59
X1195 a_1845_6825# src[1] a_1499_6575# VPWR sky130_fd_pr__pfet_01v8_hvt ad=0.105 pd=1.21 as=0.3675 ps=1.735 w=1 l=0.15
X1196 a_4333_2767# a_4097_2767# VPWR VPWR sky130_fd_pr__pfet_01v8_hvt ad=0.1092 pd=1.36 as=0.0567 ps=0.69 w=0.42 l=0.5
X1197 VPWR _30_.A _48_.Y VPWR sky130_fd_pr__pfet_01v8_hvt ad=0.26 pd=2.52 as=0.135 ps=1.27 w=1 l=0.15
X1198 VPWR VGND VPWR VPWR sky130_fd_pr__pfet_01v8_hvt ad=0.2262 pd=2.26 as=0 ps=0 w=0.87 l=0.59
X1199 VGND a_3491_5247# _28_.A VGND sky130_fd_pr__nfet_01v8 ad=0.169 pd=1.82 as=0.08775 ps=0.92 w=0.65 l=0.15
X1200 VPWR VGND VPWR VPWR sky130_fd_pr__pfet_01v8_hvt ad=0.2262 pd=2.26 as=0 ps=0 w=0.87 l=0.59
X1201 _27_.Y _53_.A VGND VGND sky130_fd_pr__nfet_01v8 ad=0.08775 pd=0.92 as=0.169 ps=1.82 w=0.65 l=0.15
X1202 VPWR VGND VPWR VPWR sky130_fd_pr__pfet_01v8_hvt ad=0.2262 pd=2.26 as=0 ps=0 w=0.87 l=0.59
X1203 _41_.C1 a_3992_7235# VPWR VPWR sky130_fd_pr__pfet_01v8_hvt ad=0.135 pd=1.27 as=0.14825 ps=1.34 w=1 l=0.15
X1204 VPWR a_4167_6147# _36_.A VPWR sky130_fd_pr__pfet_01v8_hvt ad=0.335 pd=1.67 as=0.165 ps=1.33 w=1 l=0.15
X1205 a_2689_7663# a_1499_7663# a_2580_7663# VGND sky130_fd_pr__special_nfet_01v8 ad=0.0669 pd=0.75 as=0.0711 ps=0.755 w=0.36 l=0.15
X1206 VGND u_loop.u_d6.X a_6397_2767# VGND sky130_fd_pr__nfet_01v8 ad=0.0567 pd=0.69 as=0.1092 ps=1.36 w=0.42 l=0.15
X1207 _30_.A a_2479_9269# VGND VGND sky130_fd_pr__nfet_01v8 ad=0.08775 pd=0.92 as=0.169 ps=1.82 w=0.65 l=0.15
X1208 VPWR a_7456_6409# a_7631_6335# VPWR sky130_fd_pr__pfet_01v8_hvt ad=0.1134 pd=1.38 as=0.0567 ps=0.69 w=0.42 l=0.15
X1209 VGND VPWR VGND VGND sky130_fd_pr__nfet_01v8 ad=0.143 pd=1.62 as=0 ps=0 w=0.55 l=0.59
X1210 VPWR VGND VPWR VPWR sky130_fd_pr__pfet_01v8_hvt ad=0.2262 pd=2.26 as=0 ps=0 w=0.87 l=0.59
X1211 a_5607_9599# u_loop.u_gh.C VPWR VPWR sky130_fd_pr__pfet_01v8_hvt ad=0.0567 pd=0.69 as=0.0819 ps=0.81 w=0.42 l=0.15
X1212 a_4160_6575# src[1] a_4075_6825# VPWR sky130_fd_pr__pfet_01v8_hvt ad=0.135 pd=1.27 as=0.135 ps=1.27 w=1 l=0.15
X1213 VGND VPWR VGND VGND sky130_fd_pr__nfet_01v8 ad=0.143 pd=1.62 as=0 ps=0 w=0.55 l=0.59
X1214 a_3425_5321# a_2235_4949# a_3316_5321# VGND sky130_fd_pr__special_nfet_01v8 ad=0.0669 pd=0.75 as=0.0711 ps=0.755 w=0.36 l=0.15
X1215 VPWR _53_.A _53_.Y VPWR sky130_fd_pr__pfet_01v8_hvt ad=0.26 pd=2.52 as=0.135 ps=1.27 w=1 l=0.15
X1216 a_6796_6397# _32_.Y VPWR VPWR sky130_fd_pr__pfet_01v8_hvt ad=0.0651 pd=0.73 as=0.1092 ps=1.36 w=0.42 l=0.15
X1217 VPWR VGND VPWR VPWR sky130_fd_pr__pfet_01v8_hvt ad=0.2262 pd=2.26 as=0 ps=0 w=0.87 l=0.59
X1218 a_6339_8751# a_5989_8751# a_6244_8751# VPWR sky130_fd_pr__pfet_01v8_hvt ad=0.07245 pd=0.765 as=0.0651 ps=0.73 w=0.42 l=0.15
X1219 a_3859_8511# a_3684_8585# a_4038_8573# VGND sky130_fd_pr__nfet_01v8 ad=0.1092 pd=1.36 as=0.06405 ps=0.725 w=0.42 l=0.15
X1220 a_2934_7663# u_loop.u_gh.C VGND VGND sky130_fd_pr__nfet_01v8 ad=0.06405 pd=0.725 as=0.12495 ps=1.015 w=0.42 l=0.15
X1221 VPWR _36_.A u_loop.u_gh.B VPWR sky130_fd_pr__pfet_01v8_hvt ad=0.26 pd=2.52 as=0.135 ps=1.27 w=1 l=0.15
X1222 a_6381_3561# u_loop.u_s2.Y VPWR VPWR sky130_fd_pr__pfet_01v8_hvt ad=0.105 pd=1.21 as=0.26 ps=2.52 w=1 l=0.15
X1223 VPWR _51_.Y a_1499_7663# VPWR sky130_fd_pr__pfet_01v8_hvt ad=0.0864 pd=0.91 as=0.1664 ps=1.8 w=0.64 l=0.15
X1224 VPWR a_2233_7905# a_2123_8029# VPWR sky130_fd_pr__pfet_01v8_hvt ad=0.07035 pd=0.755 as=0.1155 ps=0.97 w=0.42 l=0.15
X1225 VGND VPWR VGND VGND sky130_fd_pr__nfet_01v8 ad=0.143 pd=1.62 as=0 ps=0 w=0.55 l=0.59
X1226 a_4076_3561# u_loop.u_gl.B1 prenl VPWR sky130_fd_pr__pfet_01v8_hvt ad=0.155 pd=1.31 as=0.14 ps=1.28 w=1 l=0.15
X1227 a_7109_6005# a_6891_6409# VPWR VPWR sky130_fd_pr__pfet_01v8_hvt ad=0.12915 pd=1.185 as=0.2184 ps=2.2 w=0.84 l=0.15
X1228 VGND VPWR VGND VGND sky130_fd_pr__nfet_01v8 ad=0.143 pd=1.62 as=0 ps=0 w=0.55 l=0.59
X1229 a_2401_4949# a_2235_4949# VGND VGND sky130_fd_pr__nfet_01v8 ad=0.1092 pd=1.36 as=0.0567 ps=0.69 w=0.42 l=0.15
X1230 VPWR _56_.Q _56_.D VPWR sky130_fd_pr__pfet_01v8_hvt ad=0.26 pd=2.52 as=0.135 ps=1.27 w=1 l=0.15
X1231 VPWR VGND VPWR VPWR sky130_fd_pr__pfet_01v8_hvt ad=0.2262 pd=2.26 as=0 ps=0 w=0.87 l=0.59
X1232 a_7907_4159# u_loop.u_gh.C VPWR VPWR sky130_fd_pr__pfet_01v8_hvt ad=0.0567 pd=0.69 as=0.0819 ps=0.81 w=0.42 l=0.15
X1233 a_6447_9117# a_5823_8751# a_6339_8751# VPWR sky130_fd_pr__pfet_01v8_hvt ad=0.1155 pd=0.97 as=0.07245 ps=0.765 w=0.42 l=0.15
X1234 VGND VPWR VGND VGND sky130_fd_pr__nfet_01v8 ad=0.143 pd=1.62 as=0 ps=0 w=0.55 l=0.59
X1235 u_loop.u_cmp.Y x VGND VGND sky130_fd_pr__nfet_01v8 ad=0.169 pd=1.82 as=0.169 ps=1.82 w=0.65 l=0.15
X1236 VGND VPWR VGND VGND sky130_fd_pr__nfet_01v8 ad=0.143 pd=1.62 as=0 ps=0 w=0.55 l=0.59
X1237 VGND VPWR VGND VGND sky130_fd_pr__nfet_01v8 ad=0.143 pd=1.62 as=0 ps=0 w=0.55 l=0.59
X1238 VPWR VGND VPWR VPWR sky130_fd_pr__pfet_01v8_hvt ad=0.2262 pd=2.26 as=0 ps=0 w=0.87 l=0.59
X1239 VGND VPWR VGND VGND sky130_fd_pr__nfet_01v8 ad=0.143 pd=1.62 as=0 ps=0 w=0.55 l=0.59
X1240 VGND u_loop.u_d4.X a_4833_2767# VGND sky130_fd_pr__nfet_01v8 ad=0.0567 pd=0.69 as=0.1092 ps=1.36 w=0.42 l=0.15
X1241 a_4076_3561# u_loop.u_d0.A VPWR VPWR sky130_fd_pr__pfet_01v8_hvt ad=0.14 pd=1.28 as=0.14 ps=1.28 w=1 l=0.15
X1242 VPWR a_5607_9599# a_5594_9295# VPWR sky130_fd_pr__pfet_01v8_hvt ad=0.0819 pd=0.81 as=0.0567 ps=0.69 w=0.42 l=0.15
X1243 a_7456_6409# a_6375_6037# a_7109_6005# VPWR sky130_fd_pr__pfet_01v8_hvt ad=0.0588 pd=0.7 as=0.12915 ps=1.185 w=0.42 l=0.15
X1244 VPWR VGND VPWR VPWR sky130_fd_pr__pfet_01v8_hvt ad=0.2262 pd=2.26 as=0 ps=0 w=0.87 l=0.59
X1245 a_7808_5309# _25_.Y VPWR VPWR sky130_fd_pr__pfet_01v8_hvt ad=0.0651 pd=0.73 as=0.1092 ps=1.36 w=0.42 l=0.15
X1246 a_5190_7439# _39_.B2 a_5389_7119# VPWR sky130_fd_pr__pfet_01v8_hvt ad=0.3875 pd=1.775 as=0.1125 ps=1.225 w=1 l=0.15
X1247 VPWR VGND VPWR VPWR sky130_fd_pr__pfet_01v8_hvt ad=0.2262 pd=2.26 as=0 ps=0 w=0.87 l=0.59
X1248 a_2859_4943# a_2235_4949# a_2751_5321# VPWR sky130_fd_pr__pfet_01v8_hvt ad=0.1155 pd=0.97 as=0.07245 ps=0.765 w=0.42 l=0.15
X1249 a_3384_9295# a_3170_9295# VPWR VPWR sky130_fd_pr__pfet_01v8_hvt ad=0.1155 pd=0.97 as=0.07035 ps=0.755 w=0.42 l=0.15
X1250 VGND VPWR VGND VGND sky130_fd_pr__nfet_01v8 ad=0.143 pd=1.62 as=0 ps=0 w=0.55 l=0.59
X1251 VGND VPWR VGND VGND sky130_fd_pr__nfet_01v8 ad=0.143 pd=1.62 as=0 ps=0 w=0.55 l=0.59
X1252 VGND _63_.Q _50_.Y VGND sky130_fd_pr__nfet_01v8 ad=0.169 pd=1.82 as=0.08775 ps=0.92 w=0.65 l=0.15
X1253 VPWR VGND VPWR VPWR sky130_fd_pr__pfet_01v8_hvt ad=0.2262 pd=2.26 as=0 ps=0 w=0.87 l=0.59
X1254 VPWR _52_.Y a_2143_6037# VPWR sky130_fd_pr__pfet_01v8_hvt ad=0.0864 pd=0.91 as=0.1664 ps=1.8 w=0.64 l=0.15
X1255 _47_.Y _39_.B2 VPWR VPWR sky130_fd_pr__pfet_01v8_hvt ad=0.135 pd=1.27 as=0.26 ps=2.52 w=1 l=0.15
X1256 VGND a_7079_8725# _46_.A VGND sky130_fd_pr__nfet_01v8 ad=0.169 pd=1.82 as=0.08775 ps=0.92 w=0.65 l=0.15
X1257 VGND VPWR VGND VGND sky130_fd_pr__nfet_01v8 ad=0.143 pd=1.62 as=0 ps=0 w=0.55 l=0.59
X1258 VGND VPWR VGND VGND sky130_fd_pr__nfet_01v8 ad=0.143 pd=1.62 as=0 ps=0 w=0.55 l=0.59
X1259 _39_.X a_5190_7439# VPWR VPWR sky130_fd_pr__pfet_01v8_hvt ad=0.135 pd=1.27 as=0.165 ps=1.33 w=1 l=0.15
X1260 VPWR VGND VPWR VPWR sky130_fd_pr__pfet_01v8_hvt ad=0.2262 pd=2.26 as=0 ps=0 w=0.87 l=0.59
X1261 VPWR _32_.A _56_.CLK VPWR sky130_fd_pr__pfet_01v8_hvt ad=0.26 pd=2.52 as=0.135 ps=1.27 w=1 l=0.15
C0 a_3430_7235# _64_.Q 0
C1 a_2861_2767# a_2595_4636# 0
C2 VPWR u_loop.u_d2.X 0.25639f
C3 a_7553_7125# a_8121_7093# 0.18639f
C4 _56_.Q a_5389_5737# 0
C5 a_6927_5487# a_7109_6005# 0
C6 a_6339_8751# a_6447_9117# 0.05722f
C7 src[0] a_4518_6575# 0.10623f
C8 _56_.Q a_6619_4373# 0.13755f
C9 a_5377_7439# _40_.B 0
C10 a_7093_5487# a_7631_6335# 0.00585f
C11 _38_.X _40_.B 0.03092f
C12 _36_.A _67_.D 0
C13 _56_.Q _36_.A 0.19404f
C14 a_6283_7663# a_6891_6409# 0
C15 a_3478_4943# a_3316_5321# 0.00645f
C16 _46_.Y a_6244_8751# 0
C17 _42_.Y a_7553_4949# 0.00638f
C18 a_7387_4949# a_7443_5487# 0.01253f
C19 u_loop.u_gh.C a_2397_4399# 0
C20 a_5377_7439# src[1] 0
C21 _38_.X src[1] 0.46713f
C22 _46_.A _31_.Y 0.21046f
C23 a_7553_7125# a_8183_5461# 0
C24 _55_.Q a_8121_4917# 0
C25 u_loop.u_gl.A2 a_6444_4399# 0
C26 VPWR a_8011_4943# 0.14211f
C27 _64_.Q a_3399_6335# 0.10394f
C28 u_loop.u_d0.A _27_.Y 0.00297f
C29 a_2603_8213# _38_.X 0
C30 _25_.A a_7732_4233# 0
C31 a_3348_7235# a_3992_7235# 0
C32 a_6283_7663# _46_.A 0.05402f
C33 _55_.D a_6141_4399# 0
C34 a_6907_8029# a_7079_8725# 0
C35 _46_.A a_5823_8751# 0.03456f
C36 _21_.Y _31_.Y 0
C37 _55_.CLK a_5784_4399# 0.00161f
C38 a_1499_7663# a_2233_7905# 0.07009f
C39 a_2439_4541# _53_.A 0
C40 u_loop.u_gh.C a_2111_7663# 0.00117f
C41 a_2564_6397# _52_.Y 0.0056f
C42 _55_.Q a_6444_4399# 0
C43 _41_.C1 src[0] 0.19804f
C44 a_2877_6005# a_2526_4765# 0
C45 _21_.Y a_5823_8751# 0
C46 a_7539_7637# xa 0.00132f
C47 a_1499_7663# _63_.D 0.17501f
C48 a_2143_6037# a_3399_6335# 0.04348f
C49 u_loop.u_d0.X a_1889_2767# 0.00134f
C50 u_loop.u_d0.X a_2861_2767# 0.00219f
C51 a_6927_5487# a_7551_5853# 0
C52 _55_.CLK a_7808_5309# 0
C53 a_7732_4233# a_6817_3861# 0.12532f
C54 _32_.A a_6541_6037# 0.03099f
C55 a_7539_7637# a_7631_6335# 0
C56 a_1920_7663# a_1665_7663# 0.06418f
C57 a_8643_5247# u_loop.u_gh.C 0.27722f
C58 _41_.C1 a_4074_7235# 0
C59 a_2400_4667# a_2625_2767# 0
C60 xb _67_.D 0
C61 a_6927_5487# _25_.A 0.36581f
C62 a_2564_6397# _28_.Y 0
C63 _20_.Y _64_.Q 0.0031f
C64 _41_.C1 a_5190_7439# 0.00152f
C65 u_loop.u_gl.A2 u_loop.u_q.B 0
C66 u_loop.u_gh.B a_3316_5321# 0
C67 _40_.B src[1] 0.13524f
C68 a_2689_7663# a_1665_7663# 0
C69 VPWR a_4867_9673# 0.22469f
C70 _30_.Y src[0] 0
C71 _32_.A a_7661_5729# 0
C72 _70_.LO a_7903_7497# 0
C73 a_6799_7663# _67_.D 0
C74 a_5805_2767# u_loop.u_d5.X 0.00315f
C75 a_7387_4949# a_7385_3829# 0
C76 a_2934_7663# u_loop.u_gh.C 0.00319f
C77 _63_.D a_1654_6575# 0
C78 _32_.A u_loop.u_gh.C 0.43843f
C79 a_2603_8213# _40_.B 0.01288f
C80 a_2235_4949# u_loop.u_gh.B 0
C81 a_3044_9411# a_3859_8511# 0
C82 u_loop.u_cmp.Y u_loop.u_d0.A 0.3702f
C83 _25_.A a_6097_4641# 0
C84 _55_.Q a_7907_4159# 0.10428f
C85 a_6283_7663# a_6895_7663# 0
C86 a_2143_6037# _20_.Y 0.00268f
C87 a_2125_2767# a_1889_2767# 0.22264f
C88 a_2603_8213# src[1] 0
C89 _49_.Y a_3859_8511# 0.001f
C90 _57_.CLK a_6097_4641# 0
C91 _63_.Q a_2755_7637# 0.13594f
C92 a_8183_5461# _25_.A 0.00284f
C93 a_6927_5487# a_6817_3861# 0
C94 VPWR _27_.Y 0.7552f
C95 a_7841_4233# u_loop.u_gh.C 0
C96 _55_.Q a_7456_6409# 0
C97 a_6283_7663# _31_.Y 0
C98 _31_.Y a_5823_8751# 0.17459f
C99 a_7631_6335# _25_.Y 0
C100 _64_.D _52_.Y 0.05039f
C101 u_loop.u_d0.A u_loop.u_d3.X 0.14402f
C102 VPWR a_6796_6397# 0.08336f
C103 a_4867_9673# _30_.A 0
C104 a_4167_6147# a_4518_6575# 0
C105 a_2769_8213# a_2755_7637# 0.00213f
C106 _27_.Y a_2401_4949# 0.00201f
C107 a_6283_7663# a_5823_8751# 0
C108 a_7539_7637# a_6449_7663# 0.04251f
C109 u_loop.u_d3.X a_3361_2767# 0
C110 a_5529_4399# u_loop.u_cmp.Y 0
C111 a_7553_7125# _32_.A 0
C112 a_6739_2767# u_loop.u_d0.A 0
C113 _28_.A src[0] 0
C114 _64_.D a_2235_4949# 0
C115 u_loop.u_d7.X a_6397_2767# 0.00526f
C116 u_loop.u_gh.B a_5879_4399# 0
C117 a_7109_6005# _32_.A 0.02243f
C118 _64_.D _28_.Y 0
C119 u_loop.u_gh.C a_6447_9117# 0.02009f
C120 _55_.CLK a_7732_4233# 0
C121 a_3388_7351# _51_.Y 0
C122 a_7903_5321# a_8165_5309# 0.00171f
C123 a_1920_7663# a_2111_7663# 0
C124 u_loop.u_gl.B1 u_loop.u_gh.B 0.00151f
C125 a_3802_9295# a_3044_9411# 0.05936f
C126 a_4510_3311# u_loop.u_gh.C 0
C127 a_2309_6037# _41_.C1 0
C128 u_loop.u_d2.X a_2967_2767# 0.14649f
C129 VPWR a_2580_7663# 0.28398f
C130 a_2625_2767# a_2526_4765# 0
C131 a_3491_5247# u_loop.u_gh.C 0.28275f
C132 a_7903_7497# a_8165_7485# 0.00171f
C133 u_loop.u_gl.A2 a_5879_4399# 0
C134 u_loop.u_d4.X a_5069_2767# 0.00315f
C135 a_4963_9673# a_4867_9673# 0.01379f
C136 _41_.C1 a_4167_6147# 0.01926f
C137 VPWR u_loop.u_cmp.Y 0.6189f
C138 a_2439_4541# u_loop.u_d0.A 0.26817f
C139 a_1835_4373# _52_.Y 0
C140 _45_.A a_5989_8751# 0
C141 u_loop.u_gl.B1 u_loop.u_gl.A2 0.05549f
C142 u_loop.u_gh.C _47_.Y 0.00185f
C143 a_7631_6335# a_7443_5487# 0.00129f
C144 a_2439_4541# a_3361_2767# 0
C145 _64_.D a_1499_6575# 0.00116f
C146 _21_.Y a_4867_9673# 0.03732f
C147 a_3224_6409# _64_.Q 0.00192f
C148 a_4772_9661# a_3083_9537# 0
C149 _32_.Y _46_.Y 0
C150 a_6891_6409# a_6796_6397# 0.04983f
C151 a_7093_5487# _25_.Y 0
C152 _22_.Y a_5989_8751# 0
C153 _45_.A a_7061_7663# 0.00216f
C154 a_8121_4917# u_loop.u_gh.C 0.1668f
C155 VPWR a_6907_8029# 0.14233f
C156 _41_.B1 a_4160_6575# 0.20288f
C157 VPWR u_loop.u_d3.X 0.23705f
C158 a_2235_4949# a_1835_4373# 0.00366f
C159 a_6999_6031# _67_.D 0.00842f
C160 _39_.B2 a_5190_5487# 0
C161 a_3802_9295# a_3239_9269# 0.04983f
C162 a_7903_7497# xa 0
C163 a_3684_8585# _63_.D 0
C164 a_3384_9295# a_3119_8585# 0
C165 a_1835_4373# _28_.Y 0
C166 a_8643_5247# _25_.A 0.16364f
C167 a_2143_6037# a_3224_6409# 0.10232f
C168 a_6444_4399# u_loop.u_gh.C 0.24353f
C169 _22_.Y a_7061_7663# 0
C170 _55_.CLK a_6097_4641# 0.01579f
C171 _36_.A _64_.Q 0
C172 _63_.Q a_1499_6575# 0
C173 VPWR a_6739_2767# 0.20596f
C174 _56_.CLK a_5987_4765# 0.00201f
C175 _39_.B2 a_5293_7439# 0.01482f
C176 a_7631_6335# a_7903_7497# 0
C177 a_3384_9295# a_3170_9295# 0.09774f
C178 a_7066_9117# u_loop.u_gh.C 0
C179 _32_.A _25_.A 0.10333f
C180 a_4369_6351# _64_.Q 0
C181 a_4032_7351# a_4158_7235# 0.00462f
C182 _48_.Y _47_.Y 0
C183 a_2755_7637# u_loop.u_gh.C 0.34993f
C184 a_8008_5487# _67_.D 0
C185 a_2143_6037# _36_.A 0
C186 _57_.CLK _32_.A 0.15002f
C187 u_loop.u_gl.B1 a_4097_2767# 0.02267f
C188 a_4833_2767# a_4510_3311# 0.00186f
C189 a_7553_4949# a_6651_3861# 0
C190 a_5175_2767# prenh 0.01146f
C191 a_3348_7235# a_3388_7351# 0.16753f
C192 a_2143_6037# a_4369_6351# 0
C193 VPWR a_2439_4541# 0.51061f
C194 a_5569_2767# u_loop.u_cmp.Y 0.02062f
C195 _56_.CLK _67_.D 0
C196 _56_.Q _56_.CLK 0.22217f
C197 a_2309_6037# _28_.A 0
C198 a_6739_2767# a_6633_2767# 0.41909f
C199 a_7093_5487# a_7443_5487# 0.2298f
C200 a_7456_6409# a_6541_6037# 0.12532f
C201 a_2233_7905# _64_.Q 0
C202 a_1499_7663# _51_.Y 0.27257f
C203 a_2439_4541# a_2401_4949# 0
C204 u_loop.u_gh.C a_7907_4159# 0.27925f
C205 a_4518_6825# src[0] 0.03354f
C206 _45_.A xa 0
C207 a_3684_8585# a_3044_9411# 0
C208 u_loop.u_gh.C _52_.Y 0.01968f
C209 _63_.D _64_.Q 0
C210 a_7456_6409# a_7661_5729# 0
C211 a_5432_9673# u_loop.u_gh.C 0.2437f
C212 a_7456_6409# u_loop.u_gh.C 0.23162f
C213 u_loop.u_d6.X u_loop.u_gh.C 0
C214 a_6619_4373# a_6927_5487# 0
C215 a_2751_5321# _27_.Y 0.00444f
C216 a_7841_4233# a_6817_3861# 0
C217 _27_.Y a_2740_4765# 0
C218 _45_.A a_7631_6335# 0
C219 a_3316_5321# u_loop.u_gh.C 0.23468f
C220 u_loop.u_gh.C a_3425_5321# 0
C221 a_6907_8029# _46_.A 0.00118f
C222 a_2877_6005# a_2755_6409# 0
C223 _36_.A a_6927_5487# 0
C224 u_loop.u_d0.A u_loop.u_d1.X 0.30223f
C225 a_5607_9599# a_5989_8751# 0
C226 _45_.A a_5377_7439# 0.02146f
C227 a_2235_4949# u_loop.u_gh.C 0.33552f
C228 _41_.B1 a_4075_6825# 0
C229 a_3337_8181# _40_.B 0.00836f
C230 en a_1499_6575# 0.13332f
C231 VPWR a_2659_6409# 0.21489f
C232 u_loop.u_d1.X a_3361_2767# 0.00671f
C233 a_6283_7663# a_6796_6397# 0
C234 u_loop.u_gh.C _28_.Y 0.00831f
C235 _22_.Y a_5377_7439# 0
C236 _22_.Y _38_.X 0
C237 a_3083_9537# a_3041_9661# 0
C238 a_3337_8181# src[1] 0
C239 a_2767_6031# _52_.Y 0.00211f
C240 a_2659_6409# a_2401_4949# 0
C241 u_loop.u_cmp.Y a_5363_4399# 0
C242 _39_.B2 a_3992_7235# 0
C243 VPWR a_6381_3561# 0.00729f
C244 a_2603_8213# a_3337_8181# 0.07009f
C245 _41_.C1 a_5190_5487# 0.11417f
C246 a_7553_7125# a_7456_6409# 0
C247 a_2400_4667# _28_.A 0.00166f
C248 a_8121_4917# _25_.A 0.05319f
C249 a_3491_5247# a_3399_6335# 0
C250 _53_.A a_1835_4373# 0.15786f
C251 a_6449_7663# _39_.X 0.00103f
C252 u_loop.u_gh.C a_1499_6575# 0.16366f
C253 VPWR _62_.D 0.4776f
C254 a_7109_6005# a_7456_6409# 0.05116f
C255 a_4351_9301# a_3859_8511# 0
C256 a_3119_8585# _40_.B 0.00374f
C257 _40_.B a_3227_8207# 0
C258 a_6449_7663# _45_.A 0.02384f
C259 _55_.CLK _32_.A 0
C260 _27_.Y u_loop.u_d2.X 0
C261 _42_.Y _67_.D 0
C262 _39_.B2 a_4032_7351# 0
C263 u_loop.u_gh.C a_2905_4399# 0.00486f
C264 a_6444_4399# _25_.A 0
C265 a_8468_5321# u_loop.u_gh.C 0.2274f
C266 _56_.Q _42_.Y 0.03105f
C267 _41_.C1 a_5293_7439# 0
C268 u_loop.u_gh.B u_loop.u_d0.A 0.19206f
C269 u_loop.u_gh.C a_5879_4399# 0.17383f
C270 a_2233_7905# a_1665_7663# 0.18639f
C271 _40_.B a_3170_9295# 0.00154f
C272 _39_.X src[1] 0
C273 a_3119_8585# src[1] 0
C274 a_6927_5487# xb 0
C275 VPWR a_3478_4943# 0
C276 a_7539_5487# a_7348_5487# 0
C277 a_2656_5309# u_loop.u_gh.C 0.00251f
C278 _22_.Y a_6449_7663# 0.23152f
C279 u_loop.u_gl.B1 u_loop.u_gh.C 0.09716f
C280 a_7539_7637# a_7903_7497# 0.00145f
C281 VPWR a_4160_6575# 0.27787f
C282 a_5190_5487# a_5377_5487# 0.03258f
C283 _63_.D a_1665_7663# 0.2824f
C284 a_2603_8213# a_3119_8585# 0.11261f
C285 _25_.Y a_7443_5487# 0
C286 a_2603_8213# a_3227_8207# 0
C287 x prenh 0.21f
C288 _45_.A src[1] 0.00151f
C289 VPWR u_loop.u_d1.X 0.55309f
C290 u_loop.u_gl.A2 u_loop.u_d0.A 0.45202f
C291 _56_.CLK a_5784_4399# 0.01369f
C292 a_3478_4943# a_2401_4949# 0
C293 _62_.D _30_.A 0
C294 a_7275_3855# _67_.D 0
C295 a_6907_8029# a_6283_7663# 0
C296 a_6444_4399# a_6817_3861# 0
C297 a_2603_8213# a_3170_9295# 0
C298 u_loop.u_d4.X a_4439_2767# 0.1513f
C299 VPWR a_7348_5487# 0.08228f
C300 a_5529_4399# u_loop.u_gh.B 0.00103f
C301 a_8183_5461# xb 0.1048f
C302 a_4518_6825# a_4167_6147# 0
C303 a_4772_9661# u_loop.u_gh.C 0.01783f
C304 a_2603_8213# a_2479_9269# 0
C305 a_2122_4651# a_2397_4399# 0.00742f
C306 a_6557_8993# a_6447_9117# 0.09774f
C307 a_5190_5487# a_5649_5737# 0.01157f
C308 a_4510_3311# prenl 0.18656f
C309 _39_.B2 _46_.Y 0.00272f
C310 a_7907_4159# _25_.A 0.01506f
C311 a_3802_9295# a_4351_9301# 0
C312 VPWR a_2564_6397# 0.08495f
C313 u_loop.u_d4.X a_4333_2767# 0.01908f
C314 a_4439_2767# a_4333_2767# 0.41909f
C315 _53_.A a_2833_4399# 0
C316 u_loop.u_gl.A2 a_5529_4399# 0
C317 _55_.Q a_7167_4233# 0.00633f
C318 _28_.A a_2526_4765# 0
C319 a_7618_6031# _25_.Y 0
C320 a_2439_4541# a_2751_5321# 0
C321 a_2439_4541# a_2740_4765# 0
C322 a_7539_7637# _45_.A 0.14808f
C323 _55_.Q a_5529_4399# 0
C324 _53_.A u_loop.u_gh.C 0.02674f
C325 VPWR u_loop.u_gh.B 0.75183f
C326 VPWR a_3083_9537# 0.43031f
C327 _57_.CLK a_7456_6409# 0
C328 a_4097_2767# u_loop.u_d0.A 0.05024f
C329 u_loop.u_d2.X u_loop.u_d3.X 0.00342f
C330 a_7907_4159# a_6817_3861# 0.04251f
C331 _25_.Y a_7385_3829# 0
C332 _36_.A _32_.A 0.03983f
C333 VPWR a_6704_7663# 0.08229f
C334 a_3399_6335# _52_.Y 0
C335 a_2233_7905# a_2111_7663# 0
C336 _32_.Y _67_.D 0.00559f
C337 a_8577_7497# _68_.D 0
C338 u_loop.u_gh.B a_2401_4949# 0
C339 a_4772_9661# _48_.Y 0.00136f
C340 _56_.Q _32_.Y 0
C341 _41_.B1 a_6541_6037# 0
C342 a_6927_5487# a_7072_4221# 0
C343 a_4369_6351# _32_.A 0
C344 pre src[1] 0.01165f
C345 _41_.C1 a_3992_7235# 0.11299f
C346 VPWR u_loop.u_gl.A2 0.555f
C347 _55_.CLK a_8121_4917# 0
C348 a_3316_5321# a_3399_6335# 0
C349 a_6891_6409# a_7348_5487# 0
C350 u_loop.u_d0.A a_1835_4373# 0
C351 a_2766_9427# a_2755_7637# 0
C352 a_2235_4949# a_3399_6335# 0
C353 VPWR a_4075_6825# 0.38741f
C354 VPWR _55_.Q 0.59366f
C355 a_3083_9537# _30_.A 0.04548f
C356 _41_.B1 u_loop.u_gh.C 0
C357 _55_.CLK a_6444_4399# 0.02152f
C358 _42_.Y a_5784_4399# 0
C359 a_2751_5321# a_2659_6409# 0
C360 a_7079_8725# u_loop.u_gh.C 0.28213f
C361 a_6557_8993# a_7066_9117# 0
C362 _68_.D a_6704_7663# 0
C363 a_4032_7351# _41_.C1 0.14234f
C364 _39_.B2 a_4038_8573# 0
C365 VPWR _64_.D 0.46859f
C366 a_7153_6397# _32_.A 0.00211f
C367 VPWR a_6339_8751# 0.22402f
C368 a_6999_6031# a_6927_5487# 0
C369 a_8468_5321# _25_.A 0.06365f
C370 _20_.Y _52_.Y 0.01403f
C371 a_3491_5247# a_3224_6409# 0
C372 _64_.Q _51_.Y 0.11161f
C373 _46_.A a_7013_8751# 0
C374 a_6541_6037# _41_.X 0
C375 a_8643_5247# xb 0.00814f
C376 _55_.D prenh 0
C377 _57_.CLK a_5879_4399# 0
C378 a_3013_5309# u_loop.u_gh.C 0.0022f
C379 a_3684_8585# a_3348_7235# 0
C380 _32_.A xb 0
C381 a_5190_5487# _56_.D 0
C382 VPWR a_4097_2767# 0.2802f
C383 u_loop.u_gh.C _41_.X 0
C384 VPWR _63_.Q 1.05773f
C385 a_4032_7351# _30_.Y 0
C386 _36_.A a_3491_5247# 0.00105f
C387 a_8086_4221# a_7907_4159# 0.0074f
C388 a_6799_7663# _32_.A 0
C389 a_3041_9661# u_loop.u_gh.C 0
C390 _55_.CLK u_loop.u_q.B 0.00165f
C391 a_6927_5487# a_8008_5487# 0.10236f
C392 _55_.CLK a_7907_4159# 0
C393 a_8121_7093# a_8008_5487# 0
C394 VPWR a_2769_8213# 0.58495f
C395 a_7526_8029# u_loop.u_gh.C 0
C396 a_7526_8029# a_7364_7663# 0.00645f
C397 a_7387_7125# _67_.D 0
C398 a_7553_4949# a_6375_6037# 0
C399 _46_.A a_6704_7663# 0.00282f
C400 a_5377_7439# src[0] 0
C401 _38_.X src[0] 0.28035f
C402 a_3083_9537# _21_.Y 0
C403 a_2847_5321# u_loop.u_gh.C 0
C404 _56_.CLK a_6927_5487# 0
C405 _55_.Q a_6891_6409# 0
C406 _55_.CLK u_loop.u_d6.X 0
C407 VPWR a_1835_4373# 0.46729f
C408 a_2967_2767# u_loop.u_d1.X 0.06229f
C409 a_2769_2223# a_2861_2767# 0.0073f
C410 a_5805_2767# u_loop.u_q.B 0
C411 a_8822_7485# a_8643_7423# 0.0074f
C412 a_5911_2767# u_loop.u_s2.A 0.02144f
C413 _20_.Y a_1499_6575# 0.14109f
C414 a_6619_4373# a_6444_4399# 0.23366f
C415 _56_.CLK a_6097_4641# 0.00109f
C416 a_8183_5461# a_8008_5487# 0.23366f
C417 a_2755_7637# a_3224_6409# 0
C418 u_loop.u_d0.A u_loop.u_gh.C 0.628f
C419 _32_.A a_7017_7905# 0
C420 _38_.X a_4074_7235# 0
C421 a_7387_4949# a_7903_5321# 0.10317f
C422 u_loop.u_d6.X a_5805_2767# 0.01693f
C423 a_5377_7439# a_5190_7439# 0.03258f
C424 _38_.X a_5190_7439# 0.11417f
C425 u_loop.u_gh.C a_3361_2767# 0
C426 _39_.X a_7903_7497# 0
C427 a_2769_8213# _30_.A 0
C428 _25_.A a_5293_5487# 0
C429 a_6651_3861# _67_.D 0
C430 a_2231_2767# _53_.A 0
C431 _56_.Q a_6651_3861# 0
C432 a_3348_7235# _64_.Q 0.05985f
C433 _46_.A a_6339_8751# 0.02876f
C434 a_3337_8181# a_3227_8207# 0.09774f
C435 a_3337_8181# a_3119_8585# 0.20964f
C436 u_loop.u_gh.B a_5363_4399# 0.00661f
C437 a_7553_4949# a_8577_5321# 0
C438 a_1665_7663# _51_.Y 0.00443f
C439 u_loop.u_gl.A2 a_5975_4399# 0
C440 a_2235_4949# a_2595_4636# 0
C441 _45_.A a_7903_7497# 0
C442 a_7013_8751# a_5823_8751# 0
C443 a_7167_4233# u_loop.u_gh.C 0.19003f
C444 _21_.Y a_6339_8751# 0
C445 a_3337_8181# a_3170_9295# 0
C446 a_2595_4636# _28_.Y 0.00439f
C447 VPWR en 0.11348f
C448 src[0] _40_.B 0.15355f
C449 a_3224_6409# _52_.Y 0
C450 a_5529_4399# u_loop.u_gh.C 0.05441f
C451 a_6895_7663# a_6704_7663# 0
C452 a_2143_6037# a_3348_7235# 0
C453 u_loop.u_gl.A2 a_5363_4399# 0
C454 a_8643_7423# u_loop.u_gh.C 0.27931f
C455 a_2439_4541# _27_.Y 0.60962f
C456 u_loop.u_gh.B a_2751_5321# 0
C457 _41_.B1 _25_.A 0
C458 a_7539_5487# a_7661_5729# 0
C459 u_loop.u_gl.B1 prenl 0.32108f
C460 u_loop.u_d2.X u_loop.u_d1.X 0.03682f
C461 a_3000_9295# u_loop.u_gh.C 0
C462 a_7539_5487# u_loop.u_gh.C 0.00142f
C463 _55_.CLK a_5879_4399# 0.00828f
C464 a_3316_5321# a_3224_6409# 0
C465 src[0] src[1] 1.7807f
C466 a_2479_9269# a_2015_7663# 0
C467 a_5541_9673# u_loop.u_gh.C 0
C468 VPWR a_6541_6037# 0.6011f
C469 _39_.B2 a_3859_8511# 0.00191f
C470 _55_.Q a_5363_4399# 0
C471 a_7167_4233# a_7263_4233# 0.01379f
C472 a_2235_4949# a_3224_6409# 0
C473 _41_.B1 _57_.CLK 0
C474 a_2603_8213# src[0] 0
C475 a_8822_7485# _68_.D 0
C476 a_3119_8585# a_3227_8207# 0.05722f
C477 a_4074_7235# _40_.B 0
C478 a_6283_7663# a_6704_7663# 0.08968f
C479 _40_.B a_5190_7439# 0
C480 a_6283_7663# a_7473_7663# 0
C481 a_7810_6397# _32_.A 0.00197f
C482 _42_.Y a_6927_5487# 0.00766f
C483 VPWR a_7661_5729# 0.20657f
C484 a_2595_4636# a_2905_4399# 0.01379f
C485 _45_.A _39_.X 0.4799f
C486 a_6999_6031# _32_.A 0
C487 a_3119_8585# a_3170_9295# 0
C488 VPWR u_loop.u_gh.C 6.28244f
C489 VPWR a_7364_7663# 0.29912f
C490 a_4074_7235# src[1] 0
C491 a_5805_2767# a_5879_4399# 0
C492 _36_.A a_3316_5321# 0
C493 a_4833_2767# u_loop.u_d0.A 0.05819f
C494 _53_.A _20_.Y 0
C495 src[1] a_5190_7439# 0
C496 _63_.D a_2755_7637# 0
C497 _62_.D a_3215_8585# 0.00176f
C498 _42_.Y a_6097_4641# 0
C499 a_2656_5309# a_2595_4636# 0
C500 _36_.A a_2235_4949# 0
C501 VPWR _50_.Y 0.42605f
C502 a_7553_7125# a_8643_7423# 0.04251f
C503 _22_.Y _39_.X 0.02773f
C504 _41_.X _25_.A 0.31417f
C505 u_loop.u_gh.C a_2401_4949# 0.06331f
C506 _31_.Y a_6339_8751# 0.00204f
C507 a_2157_4399# _53_.A 0
C508 a_2122_4651# _52_.Y 0
C509 _38_.X a_4167_6147# 0
C510 _56_.Q _39_.B2 0
C511 _41_.C1 a_3388_7351# 0
C512 _22_.Y _45_.A 0.41357f
C513 _57_.CLK _41_.X 0
C514 a_2235_4949# a_2859_4943# 0
C515 _68_.D a_7661_5729# 0
C516 a_2111_7663# _51_.Y 0
C517 a_6339_8751# a_5823_8751# 0.11322f
C518 a_6283_7663# a_6339_8751# 0
C519 _68_.D u_loop.u_gh.C 0.3335f
C520 _68_.D a_7364_7663# 0.01475f
C521 a_2625_2767# a_2861_2767# 0.22264f
C522 _47_.Y _49_.Y 0
C523 a_6633_2767# u_loop.u_gh.C 0
C524 u_loop.u_gh.C _30_.A 0.09328f
C525 _69_.LO a_7553_4949# 0.00112f
C526 a_2235_4949# a_2122_4651# 0.00107f
C527 a_7808_7485# u_loop.u_gh.C 0.01634f
C528 a_7808_7485# a_7364_7663# 0
C529 VPWR a_2767_6031# 0.14228f
C530 a_6891_6409# a_6541_6037# 0.22549f
C531 _56_.CLK _32_.A 0.1019f
C532 VPWR a_7553_7125# 0.5862f
C533 VPWR _48_.Y 0.58788f
C534 VPWR a_7109_6005# 0.22555f
C535 a_2309_6037# _53_.Y 0
C536 a_2767_6031# a_2401_4949# 0
C537 a_2231_2767# u_loop.u_d0.A 0.06728f
C538 a_7456_6409# xb 0
C539 u_loop.u_d7.X u_loop.u_s2.Y 0.02997f
C540 a_6891_6409# u_loop.u_gh.C 0.15855f
C541 a_7167_4233# a_7551_5853# 0
C542 a_7999_7497# a_7387_7125# 0
C543 a_2934_7663# _51_.Y 0
C544 a_3044_9411# a_2755_7637# 0
C545 _53_.A a_2595_4636# 0
C546 u_loop.u_gh.C a_3514_7235# 0
C547 VPWR a_4833_2767# 0.26382f
C548 a_8468_7497# a_8630_7119# 0.00645f
C549 a_7553_7125# _68_.D 0.23686f
C550 a_2877_6005# _64_.Q 0
C551 a_6651_3861# a_7808_5309# 0
C552 a_4963_9673# u_loop.u_gh.C 0.0031f
C553 a_7167_4233# _25_.A 0
C554 a_2309_6037# src[1] 0
C555 _48_.Y _30_.A 0.13588f
C556 u_loop.u_d0.A a_3399_6335# 0
C557 a_7553_7125# a_7808_7485# 0.06418f
C558 a_3549_9661# a_3802_9295# 0
C559 _46_.A u_loop.u_gh.C 0.50774f
C560 a_7631_6335# a_7903_5321# 0
C561 _46_.A a_7364_7663# 0
C562 u_loop.u_d0.A a_6817_3861# 0
C563 a_4167_6147# src[1] 0.05999f
C564 a_5529_4399# _25_.A 0
C565 a_2143_6037# a_2877_6005# 0.07009f
C566 _41_.C1 a_3859_8511# 0
C567 _21_.Y u_loop.u_gh.C 0.0362f
C568 a_2580_7663# _62_.D 0.00731f
C569 a_7539_5487# _25_.A 0.00507f
C570 a_5529_4399# _57_.CLK 0
C571 VPWR a_1920_7663# 0.09218f
C572 a_2766_9427# a_3041_9661# 0.00742f
C573 _63_.D a_1499_6575# 0
C574 a_3239_9269# a_2755_7637# 0
C575 a_7167_4233# a_6817_3861# 0.2298f
C576 VPWR a_7551_5853# 0.14212f
C577 a_5975_4399# u_loop.u_gh.C 0.0031f
C578 a_6891_6409# a_7109_6005# 0.20964f
C579 a_3386_6031# _52_.Y 0
C580 a_8468_5321# xb 0.00252f
C581 a_7553_4949# a_7387_4949# 0.70686f
C582 _55_.CLK _41_.X 0
C583 a_2400_4667# _53_.Y 0.01201f
C584 VPWR _25_.A 0.82683f
C585 x u_loop.u_s2.Y 0.00102f
C586 VPWR a_2231_2767# 0.20375f
C587 a_8121_4917# a_8008_5487# 0.00104f
C588 _42_.Y _32_.A 0
C589 a_5432_9673# a_5085_9269# 0.05116f
C590 u_loop.u_gh.B _27_.Y 0
C591 _30_.Y a_3859_8511# 0.00241f
C592 _36_.A a_5293_5487# 0.00296f
C593 u_loop.u_gh.C a_5363_4399# 0.66511f
C594 VPWR _57_.CLK 0.36822f
C595 _56_.Q _41_.C1 0
C596 a_6895_7663# u_loop.u_gh.C 0.00128f
C597 _48_.Y _21_.Y 0.03662f
C598 a_3684_8585# _39_.B2 0
C599 u_loop.u_gh.C a_8011_7119# 0.01283f
C600 a_6283_7663# a_6541_6037# 0
C601 u_loop.u_d0.A prenl 0.29427f
C602 VPWR a_3399_6335# 0.45212f
C603 u_loop.u_gh.C a_2967_2767# 0
C604 u_loop.u_gl.A2 _27_.Y 0
C605 a_7093_5487# a_7903_5321# 0
C606 _41_.B1 a_5389_5737# 0.00199f
C607 VPWR a_6817_3861# 0.58577f
C608 _31_.Y u_loop.u_gh.C 0.01686f
C609 _56_.CLK a_6444_4399# 0
C610 a_6651_3861# a_7732_4233# 0.10236f
C611 a_2751_5321# u_loop.u_gh.C 0.1664f
C612 prenl a_3361_2767# 0.0025f
C613 _53_.A a_2122_4651# 0.00328f
C614 u_loop.u_d1.X u_loop.u_d3.X 0
C615 u_loop.u_gh.C a_2740_4765# 0.01674f
C616 a_6927_5487# a_7387_7125# 0
C617 _55_.CLK u_loop.u_d0.A 0.00237f
C618 a_6283_7663# u_loop.u_gh.C 0.33035f
C619 a_6283_7663# a_7364_7663# 0.10236f
C620 _36_.A _41_.B1 0.4715f
C621 u_loop.u_gh.C a_5823_8751# 0.33225f
C622 a_3399_6335# a_2401_4949# 0
C623 a_8121_7093# a_7387_7125# 0.07009f
C624 a_4351_4175# prenh 0.0299f
C625 _36_.A a_5389_7119# 0.0012f
C626 _56_.Q a_5377_5487# 0.06831f
C627 a_5069_2767# prenh 0.03074f
C628 _41_.B1 a_4369_6351# 0.00126f
C629 _53_.A a_2125_2767# 0
C630 a_2769_8213# a_3215_8585# 0
C631 u_loop.u_d5.X a_5175_2767# 0.1513f
C632 a_2015_7663# src[0] 0
C633 a_5293_7439# a_5377_7439# 0.06696f
C634 a_6457_2473# u_loop.u_d7.X 0
C635 a_3684_8585# a_3846_8207# 0.00645f
C636 _38_.X a_5293_7439# 0.00251f
C637 a_2766_9427# a_3000_9295# 0.00645f
C638 a_2595_4636# u_loop.u_d0.A 0
C639 a_6891_6409# _25_.A 0
C640 a_5805_2767# u_loop.u_d0.A 0.00456f
C641 _55_.CLK a_7167_4233# 0
C642 a_6633_2767# a_6817_3861# 0
C643 a_7553_7125# a_8011_7119# 0.03462f
C644 a_3802_9295# _30_.Y 0.16052f
C645 a_3333_6409# u_loop.u_gh.C 0.00101f
C646 VPWR _20_.Y 0.36174f
C647 a_6619_4373# _41_.X 0
C648 a_2755_7637# _51_.Y 0
C649 _55_.CLK a_5529_4399# 0.0437f
C650 a_6651_3861# a_6927_5487# 0
C651 a_5649_5737# _67_.D 0
C652 a_6891_6409# _57_.CLK 0.00109f
C653 _48_.Y _31_.Y 0
C654 a_2526_4765# _53_.Y 0.00725f
C655 a_6375_6037# _67_.D 0.21946f
C656 _56_.Q a_5649_5737# 0.00122f
C657 VPWR a_2157_4399# 0.00209f
C658 _36_.A _41_.X 0.01061f
C659 a_2439_4541# u_loop.u_d1.X 0
C660 _56_.Q a_6375_6037# 0.00126f
C661 u_loop.u_gl.A2 u_loop.u_cmp.Y 0
C662 VPWR a_2766_9427# 0.28327f
C663 _39_.X src[0] 0
C664 a_3119_8585# src[0] 0
C665 a_4351_4175# a_4769_4175# 0.13998f
C666 _32_.Y _32_.A 0.26256f
C667 _46_.A _57_.CLK 0
C668 VPWR prenl 0.27405f
C669 u_loop.u_d0.A a_3224_6409# 0
C670 a_5529_4399# a_5805_2767# 0
C671 a_7093_5487# a_5190_5487# 0
C672 _45_.A src[0] 0
C673 VPWR a_6557_8993# 0.21434f
C674 a_4517_9301# a_5607_9599# 0.04251f
C675 _27_.Y a_1835_4373# 0.06687f
C676 VPWR _55_.CLK 0.74624f
C677 u_loop.u_d7.X u_loop.u_d5.X 0
C678 a_5293_7439# _40_.B 0
C679 _46_.Y a_5989_8751# 0
C680 a_7079_8725# a_6799_7663# 0
C681 _42_.Y a_6444_4399# 0.00154f
C682 _39_.X a_5190_7439# 0.15437f
C683 a_2766_9427# _30_.A 0.0551f
C684 a_8011_4943# u_loop.u_gh.C 0.01223f
C685 a_3846_8207# _64_.Q 0
C686 _36_.A u_loop.u_d0.A 0
C687 a_8183_5461# a_8362_5487# 0.0074f
C688 u_loop.u_d0.X u_loop.u_d0.A 0.05064f
C689 a_5293_7439# src[1] 0
C690 _25_.Y a_7903_5321# 0.0031f
C691 a_2580_7663# _63_.Q 0.03864f
C692 _45_.A a_5190_7439# 0.1612f
C693 VPWR a_2595_4636# 0.21393f
C694 _25_.A a_5363_4399# 0
C695 u_loop.u_d0.X a_3361_2767# 0
C696 VPWR a_5805_2767# 0.33939f
C697 a_2439_4541# u_loop.u_gh.B 0
C698 a_7167_4233# a_6619_4373# 0
C699 a_5987_4765# _56_.D 0
C700 a_6904_8751# a_5989_8751# 0.12532f
C701 _22_.Y a_5190_7439# 0
C702 a_7553_4949# a_7631_6335# 0
C703 a_8011_7119# _25_.A 0
C704 a_2580_7663# a_2769_8213# 0
C705 VPWR a_8170_5853# 0
C706 a_8822_5309# u_loop.u_gh.C 0.00288f
C707 a_2595_4636# a_2401_4949# 0.00117f
C708 a_6397_2767# u_loop.u_s2.A 0
C709 a_6619_4373# a_5529_4399# 0.04251f
C710 _38_.X a_3992_7235# 0.03163f
C711 u_loop.u_d0.A a_2122_4651# 0
C712 u_loop.u_gh.C a_3215_8585# 0.00246f
C713 a_7079_8725# a_7017_7905# 0
C714 u_loop.u_gl.A2 a_2439_4541# 0
C715 a_1845_6825# src[1] 0
C716 _55_.D _67_.D 0.00218f
C717 _56_.CLK a_5879_4399# 0.00491f
C718 a_2564_6397# a_2659_6409# 0.04983f
C719 _36_.A a_5529_4399# 0
C720 a_4097_2767# u_loop.u_d3.X 0.37357f
C721 u_loop.u_d4.X a_4076_3561# 0
C722 _56_.Q _55_.D 0.01826f
C723 VPWR a_3224_6409# 0.3014f
C724 u_loop.u_gh.C a_4867_9673# 0.17411f
C725 a_3684_8585# _30_.Y 0.00108f
C726 u_loop.u_d0.A a_2125_2767# 0.09452f
C727 pre src[0] 0.0862f
C728 _32_.A a_7387_7125# 0
C729 a_1499_6575# _51_.Y 0.00138f
C730 x u_loop.u_d5.X 0
C731 _38_.X a_4032_7351# 0.042f
C732 _56_.Q _56_.D 0.1907f
C733 a_6283_7663# _57_.CLK 0
C734 VPWR a_5389_5737# 0.00749f
C735 a_6796_6397# a_6541_6037# 0.06418f
C736 a_6557_8993# _46_.A 0.02613f
C737 VPWR a_6619_4373# 0.39136f
C738 a_4333_2767# a_4076_3561# 0
C739 a_7903_5321# a_7443_5487# 0
C740 _27_.Y u_loop.u_gh.C 0.16736f
C741 VPWR _36_.A 2.07202f
C742 VPWR u_loop.u_d0.X 0.49589f
C743 a_6557_8993# _21_.Y 0
C744 _41_.C1 _64_.Q 0.00201f
C745 VPWR a_4369_6351# 0.00472f
C746 a_3041_9661# a_3044_9411# 0
C747 a_6553_4399# a_6097_4641# 0
C748 a_3992_7235# _40_.B 0.06008f
C749 a_6796_6397# u_loop.u_gh.C 0.00152f
C750 _32_.Y a_6444_4399# 0
C751 a_5569_2767# a_5805_2767# 0.22264f
C752 a_7526_8029# a_7017_7905# 0
C753 a_4351_9301# a_5432_9673# 0.10236f
C754 _36_.A a_2401_4949# 0
C755 VPWR a_2859_4943# 0.14235f
C756 _69_.LO _67_.D 0.07165f
C757 _48_.Y a_4867_9673# 0.00131f
C758 a_7093_5487# a_7553_4949# 0.00905f
C759 a_3083_9537# _62_.D 0.0016f
C760 a_3992_7235# src[1] 0.20655f
C761 a_6633_2767# a_6619_4373# 0
C762 u_loop.u_gl.A2 a_6381_3561# 0
C763 VPWR a_2122_4651# 0.317f
C764 _64_.D a_2659_6409# 0
C765 a_8643_7423# xb 0.00385f
C766 a_2859_4943# a_2401_4949# 0.03462f
C767 _55_.CLK a_5975_4399# 0.00107f
C768 a_4032_7351# _40_.B 0.15999f
C769 a_6651_3861# a_7841_4233# 0
C770 _56_.CLK a_5293_5487# 0.00156f
C771 a_2439_4541# a_1835_4373# 0.04359f
C772 a_3478_4943# u_loop.u_gh.B 0
C773 VPWR a_2233_7905# 0.23778f
C774 a_7732_4233# a_7894_3855# 0.00645f
C775 a_4032_7351# src[1] 0.10995f
C776 u_loop.u_d4.X prenh 0.01709f
C777 VPWR a_2125_2767# 0.35703f
C778 _55_.CLK a_5363_4399# 0.03441f
C779 a_2580_7663# u_loop.u_gh.C 0.24433f
C780 _42_.Y a_5879_4399# 0
C781 a_4439_2767# prenh 0.00498f
C782 a_8011_4943# _25_.A 0.00766f
C783 a_2967_2767# prenl 0
C784 VPWR _63_.D 0.98929f
C785 u_loop.u_cmp.Y u_loop.u_gh.C 0
C786 a_3684_8585# a_3793_8585# 0.00742f
C787 a_6907_8029# a_6541_6037# 0
C788 VPWR a_5129_9661# 0
C789 a_2580_7663# _50_.Y 0
C790 VPWR xb 0.57753f
C791 a_6557_8993# _31_.Y 0
C792 _36_.A a_6891_6409# 0
C793 a_3333_6409# _20_.Y 0
C794 _56_.CLK _41_.B1 0.00106f
C795 VPWR a_6799_7663# 0.20282f
C796 a_4333_2767# prenh 0.0024f
C797 a_5805_2767# a_5363_4399# 0
C798 a_6557_8993# a_6283_7663# 0
C799 a_6449_7663# _46_.Y 0.00239f
C800 a_6557_8993# a_5823_8751# 0.07009f
C801 a_4075_6825# a_4160_6575# 0.14234f
C802 a_5784_4399# _55_.D 0
C803 a_8822_5309# _25_.A 0
C804 u_loop.u_gh.C u_loop.u_d3.X 0
C805 a_6907_8029# u_loop.u_gh.C 0.02003f
C806 a_3316_5321# a_2969_4917# 0.05116f
C807 a_2969_4917# a_3425_5321# 0
C808 a_2309_6037# pre 0
C809 a_2235_4949# a_2969_4917# 0.07009f
C810 a_5784_4399# _56_.D 0.15913f
C811 _28_.A _64_.Q 0
C812 a_3000_9295# a_3044_9411# 0
C813 a_7167_4233# a_7072_4221# 0.04983f
C814 prenh u_loop.u_s2.A 0.00323f
C815 a_2595_4636# a_2740_4765# 0.05722f
C816 _63_.Q _62_.D 0.05052f
C817 _55_.Q a_7348_5487# 0
C818 _68_.D a_6799_7663# 0
C819 a_7387_4949# _67_.D 0
C820 a_7153_6397# a_6891_6409# 0.00171f
C821 _56_.Q a_7387_4949# 0.00275f
C822 u_loop.u_d5.X _56_.D 0
C823 VPWR a_7017_7905# 0.20461f
C824 _56_.CLK _41_.X 0.07644f
C825 a_2143_6037# _28_.A 0
C826 _32_.A a_7565_6409# 0
C827 a_2769_8213# _62_.D 0.23643f
C828 _36_.A a_5649_7119# 0.00124f
C829 a_5541_9673# a_5085_9269# 0
C830 u_loop.u_d2.X prenl 0.00153f
C831 VPWR a_3044_9411# 0.27169f
C832 a_4772_9661# a_4351_9301# 0.08341f
C833 a_7553_4949# _25_.Y 0.28101f
C834 u_loop.u_gl.A2 u_loop.u_gh.B 0.31408f
C835 a_4097_2767# u_loop.u_d1.X 0.00102f
C836 a_6619_4373# a_5363_4399# 0.04359f
C837 a_6891_6409# xb 0
C838 a_2877_6005# _52_.Y 0.00213f
C839 a_6651_3861# a_6444_4399# 0
C840 _64_.D a_2564_6397# 0.15586f
C841 a_2439_4541# u_loop.u_gh.C 0.71166f
C842 a_2231_2767# _27_.Y 0
C843 VPWR _49_.Y 0.75847f
C844 a_2921_6397# _64_.Q 0
C845 VPWR a_3386_6031# 0
C846 _36_.A a_5363_4399# 0
C847 a_6891_6409# a_6799_7663# 0
C848 VPWR a_5085_9269# 0.21125f
C849 _68_.D a_7017_7905# 0
C850 VPWR a_7072_4221# 0.08229f
C851 a_6927_5487# a_6375_6037# 0.0068f
C852 a_6796_6397# _57_.CLK 0.00142f
C853 _38_.X a_3388_7351# 0.15052f
C854 a_2235_4949# a_2877_6005# 0
C855 _39_.B2 a_6447_9117# 0
C856 a_7539_7637# _46_.Y 0
C857 a_4074_7235# src[0] 0.00178f
C858 a_3044_9411# _30_.A 0.5491f
C859 a_4038_8573# _40_.B 0
C860 _56_.CLK u_loop.u_d0.A 0.00985f
C861 _39_.X a_5190_5487# 0
C862 src[0] a_5190_7439# 0.00109f
C863 VPWR a_3239_9269# 0.19944f
C864 _46_.A a_6799_7663# 0.00257f
C865 a_7456_6409# a_7387_7125# 0
C866 u_loop.u_d0.X a_2967_2767# 0
C867 a_2580_7663# a_2689_7663# 0.00742f
C868 _55_.CLK a_8011_4943# 0
C869 _30_.A _49_.Y 0.23153f
C870 a_3333_6409# a_3224_6409# 0.00742f
C871 a_6891_6409# a_7017_7905# 0
C872 u_loop.u_gh.C a_2659_6409# 0.1818f
C873 a_5085_9269# _30_.A 0
C874 a_2751_5321# a_2859_4943# 0.05722f
C875 _41_.B1 a_3348_7235# 0
C876 a_8117_5487# a_6927_5487# 0
C877 _39_.B2 _47_.Y 0.15621f
C878 a_6651_3861# a_7907_4159# 0.04359f
C879 VPWR a_6999_6031# 0.14236f
C880 _55_.D a_7732_4233# 0.0014f
C881 a_2875_2223# a_2861_2767# 0.01305f
C882 a_8468_7497# a_8121_7093# 0.05116f
C883 a_7553_4949# a_7443_5487# 0.00133f
C884 _45_.A a_5293_7439# 0
C885 a_3578_6397# u_loop.u_gh.C 0.00361f
C886 VPWR a_2277_7663# 0
C887 _56_.CLK a_5529_4399# 0.16212f
C888 a_3239_9269# _30_.A 0.02993f
C889 _46_.A a_7017_7905# 0
C890 a_3083_9537# a_2769_8213# 0.00128f
C891 _22_.Y a_5293_7439# 0
C892 _56_.CLK a_7539_5487# 0
C893 a_5786_9661# a_5607_9599# 0.0074f
C894 a_3388_7351# _40_.B 0.02045f
C895 VPWR a_8008_5487# 0.2961f
C896 _62_.D u_loop.u_gh.C 0.06665f
C897 _21_.Y a_3044_9411# 0
C898 a_6895_7663# a_6799_7663# 0.01379f
C899 a_2767_6031# a_2659_6409# 0.05722f
C900 a_3388_7351# src[1] 0.14103f
C901 a_4963_9673# a_5085_9269# 0
C902 u_loop.u_d0.X u_loop.u_d2.X 0
C903 a_8121_4917# a_8165_5309# 0
C904 _62_.D _50_.Y 0.00218f
C905 _38_.X a_3859_8511# 0
C906 a_6927_5487# _55_.D 0
C907 VPWR _56_.CLK 0.82226f
C908 _64_.D _63_.Q 0
C909 _21_.Y _49_.Y 0
C910 a_2603_8213# a_3388_7351# 0
C911 a_2309_6037# src[0] 0
C912 a_3478_4943# u_loop.u_gh.C 0
C913 a_2400_4667# a_3158_4765# 0.06121f
C914 _28_.A a_2397_4399# 0
C915 u_loop.u_gh.C a_4160_6575# 0
C916 a_3381_8573# _62_.D 0
C917 _21_.Y a_5085_9269# 0.04308f
C918 a_4167_6147# src[0] 0.16184f
C919 a_6283_7663# a_6799_7663# 0.11053f
C920 u_loop.u_gh.C u_loop.u_d1.X 0
C921 a_7387_4949# a_7808_5309# 0.08561f
C922 _55_.D a_6097_4641# 0
C923 a_6799_7663# a_5823_8751# 0
C924 VPWR a_6244_8751# 0.09688f
C925 VPWR a_6435_8751# 0
C926 a_6999_6031# a_6891_6409# 0.05722f
C927 a_6553_4399# a_6444_4399# 0.00742f
C928 _41_.B1 _32_.Y 0
C929 VPWR _51_.Y 0.4377f
C930 a_6895_7663# a_7017_7905# 0
C931 a_7631_6335# _67_.D 0.08178f
C932 a_6097_4641# _56_.D 0.00136f
C933 u_loop.u_gh.C a_7348_5487# 0.00335f
C934 _48_.Y _62_.D 0
C935 a_2439_4541# a_2231_2767# 0
C936 a_2595_4636# _27_.Y 0.03364f
C937 a_2766_9427# a_2580_7663# 0
C938 a_7013_8751# u_loop.u_gh.C 0
C939 a_7167_4233# _42_.Y 0
C940 _39_.B2 a_5432_9673# 0.05885f
C941 a_2015_7663# a_2123_8029# 0.05722f
C942 u_loop.u_gh.C a_2564_6397# 0.02165f
C943 a_2769_8213# _63_.Q 0.04773f
C944 _42_.Y a_5529_4399# 0
C945 _32_.A a_5649_5737# 0
C946 a_8577_7497# u_loop.u_gh.C 0
C947 _40_.B a_3859_8511# 0.17716f
C948 a_6283_7663# a_7017_7905# 0.07009f
C949 a_3013_5309# a_2969_4917# 0
C950 u_loop.u_cmp.Y prenl 0
C951 _32_.A a_6375_6037# 0.23427f
C952 VPWR a_3024_8573# 0.08237f
C953 pre a_1845_6825# 0
C954 _32_.Y _41_.X 0
C955 a_7456_6409# a_7565_6409# 0.00742f
C956 u_loop.u_gh.B u_loop.u_gh.C 0.17627f
C957 src[1] a_3859_8511# 0
C958 a_3083_9537# u_loop.u_gh.C 0.69719f
C959 a_7167_4233# a_7275_3855# 0.05722f
C960 a_5569_2767# _56_.CLK 0
C961 _49_.Y a_5823_8751# 0
C962 en _64_.D 0
C963 a_2603_8213# a_3859_8511# 0.04359f
C964 a_1499_7663# _40_.B 0
C965 u_loop.u_gh.C a_6704_7663# 0.0031f
C966 prenl u_loop.u_d3.X 0.00923f
C967 a_7473_7663# a_7364_7663# 0.00742f
C968 _69_.LO a_8183_5461# 0.00187f
C969 a_7473_7663# u_loop.u_gh.C 0
C970 _55_.Q a_6541_6037# 0
C971 a_2847_5321# a_2969_4917# 0
C972 VPWR _42_.Y 0.60262f
C973 u_loop.u_gl.A2 u_loop.u_gh.C 0.14794f
C974 a_1499_7663# src[1] 0
C975 a_5805_2767# u_loop.u_cmp.Y 0.0457f
C976 a_7553_7125# a_8577_7497# 0
C977 a_7387_4949# a_7732_4233# 0
C978 a_4351_9301# a_5541_9673# 0
C979 a_7093_5487# _67_.D 0.28152f
C980 a_4075_6825# u_loop.u_gh.C 0
C981 _55_.Q a_7661_5729# 0
C982 _46_.A a_6244_8751# 0.00311f
C983 a_7093_5487# _56_.Q 0
C984 a_2603_8213# a_1499_7663# 0
C985 _46_.A a_6435_8751# 0.00542f
C986 _55_.Q u_loop.u_gh.C 0.01779f
C987 VPWR a_3348_7235# 0.15466f
C988 _36_.A a_6796_6397# 0
C989 _39_.X _46_.Y 0
C990 a_8822_5309# xb 0
C991 a_3802_9295# _40_.B 0
C992 _64_.D u_loop.u_gh.C 0.30039f
C993 a_3083_9537# _48_.Y 0.00464f
C994 _21_.Y a_6244_8751# 0
C995 u_loop.u_d7.X u_loop.u_q.B 0.09003f
C996 VPWR a_2356_4765# 0
C997 a_3578_6397# a_3399_6335# 0.0074f
C998 VPWR a_4351_9301# 0.45946f
C999 VPWR a_7275_3855# 0.1421f
C1000 a_2309_6037# a_4167_6147# 0
C1001 u_loop.u_gh.C a_6339_8751# 0.167f
C1002 a_1654_6575# src[1] 0.03898f
C1003 _27_.Y a_2122_4651# 0.05831f
C1004 _64_.D _50_.Y 0
C1005 _45_.A _46_.Y 0.0046f
C1006 a_3670_5309# a_3491_5247# 0.0074f
C1007 u_loop.u_d7.X u_loop.u_d6.X 0
C1008 _55_.Q a_7263_4233# 0
C1009 a_5129_9661# a_4867_9673# 0.00171f
C1010 _56_.CLK a_5363_4399# 0.29982f
C1011 _22_.Y _46_.Y 0.00312f
C1012 a_7387_4949# a_6927_5487# 0.00105f
C1013 a_3491_5247# _28_.A 0.16685f
C1014 a_4833_2767# u_loop.u_gh.B 0
C1015 a_2231_2767# u_loop.u_d1.X 0.01946f
C1016 _63_.Q u_loop.u_gh.C 0.15973f
C1017 _20_.Y a_2659_6409# 0
C1018 _57_.CLK a_4160_6575# 0
C1019 _42_.Y a_6891_6409# 0
C1020 a_4772_9661# _39_.B2 0
C1021 a_7258_8751# a_7079_8725# 0.0074f
C1022 a_4351_9301# _30_.A 0.01079f
C1023 a_7348_5487# _25_.A 0.01922f
C1024 _63_.Q _50_.Y 0.25229f
C1025 a_7167_4233# a_7429_4221# 0.00171f
C1026 _55_.Q a_7109_6005# 0
C1027 a_7539_7637# _67_.D 0
C1028 a_7841_4233# _55_.D 0
C1029 a_1654_6575# a_1582_6575# 0
C1030 a_2769_8213# u_loop.u_gh.C 0.06223f
C1031 u_loop.u_gl.A2 a_4833_2767# 0.01728f
C1032 a_2439_4541# a_2595_4636# 0.10295f
C1033 u_loop.u_gh.C a_1835_4373# 0.27677f
C1034 u_loop.u_gh.C a_3477_9661# 0.00311f
C1035 a_7387_4949# a_8183_5461# 0
C1036 a_2769_8213# _50_.Y 0.00239f
C1037 u_loop.u_d5.X a_5069_2767# 0.01908f
C1038 _31_.Y a_6244_8751# 0.16138f
C1039 VPWR _32_.Y 0.649f
C1040 _31_.Y a_6435_8751# 0
C1041 VPWR a_2969_4917# 0.22492f
C1042 a_7999_7497# xa 0
C1043 a_6651_3861# _41_.X 0
C1044 a_2400_4667# a_2309_6037# 0
C1045 x u_loop.u_q.B 0
C1046 u_loop.u_d0.X u_loop.u_d3.X 0
C1047 a_6244_8751# a_5823_8751# 0.09313f
C1048 a_5594_9295# a_5432_9673# 0.00645f
C1049 a_6435_8751# a_5823_8751# 0
C1050 a_2580_7663# a_2233_7905# 0.05116f
C1051 a_2969_4917# a_2401_4949# 0.18639f
C1052 a_3337_8181# a_3388_7351# 0
C1053 a_8577_5321# a_8121_4917# 0
C1054 a_2766_9427# _62_.D 0
C1055 _25_.Y _67_.D 0
C1056 a_2439_4541# a_3224_6409# 0
C1057 a_2580_7663# _63_.D 0
C1058 _56_.Q _25_.Y 0.00412f
C1059 a_1845_6825# src[0] 0.00415f
C1060 a_5293_7439# a_5190_7439# 0.02752f
C1061 a_5085_9269# a_4867_9673# 0.20964f
C1062 a_2595_4636# a_2659_6409# 0
C1063 a_8822_7485# u_loop.u_gh.C 0.003f
C1064 _55_.Q a_7551_5853# 0
C1065 _21_.Y a_4351_9301# 0.48959f
C1066 _39_.B2 _41_.B1 0.14862f
C1067 a_3684_8585# _40_.B 0.05808f
C1068 en u_loop.u_gh.C 0.00484f
C1069 _39_.B2 a_5389_7119# 0
C1070 VPWR a_2769_2223# 0.29972f
C1071 _42_.Y a_5363_4399# 0
C1072 a_8643_7423# a_7387_7125# 0.04359f
C1073 _38_.X _64_.Q 0.04091f
C1074 a_2439_4541# u_loop.u_d0.X 0
C1075 _55_.Q _25_.A 0.08966f
C1076 _46_.Y a_5607_9599# 0
C1077 a_3684_8585# src[1] 0
C1078 VPWR a_4975_9295# 0.14356f
C1079 a_7456_6409# a_6375_6037# 0.10232f
C1080 a_3119_8585# a_3388_7351# 0
C1081 a_3388_7351# a_3227_8207# 0
C1082 VPWR a_2877_6005# 0.22639f
C1083 u_loop.u_gh.C a_6541_6037# 0.03144f
C1084 u_loop.u_d1.X prenl 0.01599f
C1085 a_6891_6409# _32_.Y 0
C1086 _28_.A _52_.Y 0.14819f
C1087 a_3684_8585# a_2603_8213# 0.10236f
C1088 _20_.Y a_2564_6397# 0
C1089 u_loop.u_s2.Y u_loop.u_s2.A 0.12818f
C1090 u_loop.u_gh.C a_2833_4399# 0.00392f
C1091 a_2439_4541# a_2859_4943# 0
C1092 a_8121_7093# a_8165_7485# 0
C1093 a_3224_6409# a_2659_6409# 0
C1094 a_7167_4233# a_6651_3861# 0.10748f
C1095 a_1920_7663# _63_.Q 0
C1096 a_6444_4399# _55_.D 0
C1097 a_6907_8029# a_6799_7663# 0.05722f
C1098 a_2877_6005# a_2401_4949# 0
C1099 a_2439_4541# a_2122_4651# 0.10236f
C1100 u_loop.u_gh.C a_7661_5729# 0.17528f
C1101 a_3316_5321# _28_.A 0.04181f
C1102 _28_.A a_3425_5321# 0
C1103 VPWR a_7387_7125# 0.46703f
C1104 a_7364_7663# u_loop.u_gh.C 0.23669f
C1105 _55_.Q a_6817_3861# 0.01185f
C1106 a_7443_5487# _67_.D 0.00376f
C1107 a_8643_5247# a_7387_4949# 0.04359f
C1108 a_2309_6037# a_2526_4765# 0
C1109 a_6444_4399# _56_.D 0
C1110 a_2235_4949# _28_.A 0.17424f
C1111 a_6557_8993# a_7013_8751# 0
C1112 a_2625_2767# u_loop.u_d0.A 0.03982f
C1113 a_4975_9295# _30_.A 0
C1114 u_loop.u_gh.C _50_.Y 0
C1115 src[0] a_3992_7235# 0.12748f
C1116 _36_.A a_2659_6409# 0
C1117 _64_.Q _53_.Y 0
C1118 _28_.A _28_.Y 0.52798f
C1119 a_2595_4636# u_loop.u_d1.X 0
C1120 a_8121_7093# xa 0
C1121 a_3083_9537# a_2766_9427# 0.10236f
C1122 a_3381_8573# u_loop.u_gh.C 0.00401f
C1123 _64_.Q _40_.B 0.06685f
C1124 a_7553_7125# a_6541_6037# 0
C1125 a_7263_4233# u_loop.u_gh.C 0.00504f
C1126 _68_.D a_7387_7125# 0.32558f
C1127 a_6907_8029# a_7017_7905# 0.09774f
C1128 a_6927_5487# a_7631_6335# 0.00513f
C1129 a_2859_4943# a_2659_6409# 0
C1130 u_loop.u_gh.B prenl 0
C1131 _41_.B1 a_4518_6575# 0.08736f
C1132 VPWR a_6651_3861# 0.48064f
C1133 a_2143_6037# _53_.Y 0.00213f
C1134 a_7109_6005# a_6541_6037# 0.17749f
C1135 a_4032_7351# src[0] 0.2676f
C1136 a_7631_6335# a_8121_7093# 0
C1137 a_7808_7485# a_7387_7125# 0.08638f
C1138 a_4074_7235# a_3992_7235# 0
C1139 _64_.Q src[1] 0.3919f
C1140 a_2767_6031# u_loop.u_gh.C 0.0137f
C1141 a_5911_2767# u_loop.u_s2.Y 0.00162f
C1142 a_7903_7497# _67_.D 0.00152f
C1143 _55_.D a_7907_4159# 0
C1144 _41_.C1 a_5293_5487# 0.00251f
C1145 a_1499_7663# a_2015_7663# 0.11535f
C1146 a_4772_9661# _30_.Y 0
C1147 a_7553_7125# u_loop.u_gh.C 0.03921f
C1148 _48_.Y u_loop.u_gh.C 0.03815f
C1149 _55_.CLK u_loop.u_gh.B 0.00281f
C1150 a_2603_8213# _64_.Q 0
C1151 a_7618_6031# _67_.D 0
C1152 _64_.D _20_.Y 0.01584f
C1153 a_5911_2767# a_5987_4765# 0
C1154 a_7109_6005# u_loop.u_gh.C 0.16667f
C1155 u_loop.u_gl.A2 prenl 0.10717f
C1156 a_2143_6037# src[1] 0
C1157 a_7631_6335# a_8183_5461# 0
C1158 a_4032_7351# a_4074_7235# 0.00657f
C1159 a_2656_5309# _28_.A 0.02655f
C1160 u_loop.u_gl.A2 _55_.CLK 0.0127f
C1161 a_6633_2767# a_6651_3861# 0.0013f
C1162 a_2400_4667# a_2526_4765# 0.17589f
C1163 a_4975_9295# _21_.Y 0.00657f
C1164 _36_.A a_4160_6575# 0
C1165 _55_.Q a_8086_4221# 0
C1166 u_loop.u_d0.A a_5175_2767# 0.08697f
C1167 _41_.B1 _41_.C1 0.1065f
C1168 a_5377_5487# a_5293_5487# 0.06696f
C1169 a_2751_5321# a_2969_4917# 0.20964f
C1170 a_3024_8573# a_3215_8585# 0
C1171 a_7808_5309# _25_.Y 0.16124f
C1172 a_8577_5321# a_8468_5321# 0.00742f
C1173 u_loop.u_d0.X u_loop.u_d1.X 0.07766f
C1174 _55_.Q _55_.CLK 0
C1175 VPWR a_2625_2767# 0.28659f
C1176 a_6283_7663# _32_.Y 0
C1177 _39_.X _67_.D 0
C1178 a_6557_8993# a_6339_8751# 0.20964f
C1179 a_4076_3561# prenh 0.01268f
C1180 a_7551_5853# a_6541_6037# 0
C1181 _45_.A _67_.D 0
C1182 a_2766_9427# _63_.Q 0
C1183 a_7093_5487# a_6927_5487# 0.87924f
C1184 a_1920_7663# u_loop.u_gh.C 0
C1185 _56_.Q _45_.A 0
C1186 a_6541_6037# _25_.A 0
C1187 _20_.Y a_1835_4373# 0
C1188 _63_.D _62_.D 0
C1189 a_4097_2767# prenl 0.0166f
C1190 a_1665_7663# _40_.B 0
C1191 u_loop.u_d4.X u_loop.u_d5.X 0.00342f
C1192 a_7551_5853# a_7661_5729# 0.09774f
C1193 _41_.B1 a_5377_5487# 0.01938f
C1194 VPWR _39_.B2 1.63489f
C1195 a_7551_5853# u_loop.u_gh.C 0.02069f
C1196 a_2689_7663# u_loop.u_gh.C 0
C1197 a_2766_9427# a_2769_8213# 0
C1198 a_7387_4949# a_8121_4917# 0.05348f
C1199 a_6553_4399# a_5529_4399# 0
C1200 u_loop.u_gh.C a_3430_7235# 0
C1201 a_2769_2223# a_2967_2767# 0.00232f
C1202 a_2157_4399# a_1835_4373# 0.0074f
C1203 _57_.CLK a_6541_6037# 0.00365f
C1204 _55_.D a_5879_4399# 0
C1205 a_7661_5729# _25_.A 0.02684f
C1206 a_1665_7663# src[1] 0
C1207 u_loop.u_gh.C _25_.A 0.48073f
C1208 a_4167_6147# a_3992_7235# 0
C1209 a_6447_9117# a_5989_8751# 0.03462f
C1210 u_loop.u_d7.X u_loop.u_d0.A 0.05101f
C1211 u_loop.u_d1.X a_2125_2767# 0.01061f
C1212 a_7258_8751# _46_.A 0.00201f
C1213 a_2231_2767# u_loop.u_gh.C 0
C1214 a_7093_5487# a_8183_5461# 0.04251f
C1215 a_5879_4399# _56_.D 0.00103f
C1216 _36_.A u_loop.u_gh.B 0.10707f
C1217 a_2603_8213# a_1665_7663# 0.00461f
C1218 a_2751_5321# a_2877_6005# 0
C1219 a_2877_6005# a_2740_4765# 0
C1220 _57_.CLK u_loop.u_gh.C 0.02031f
C1221 a_2580_7663# _51_.Y 0
C1222 a_7808_5309# a_7443_5487# 0
C1223 VPWR a_5175_2767# 0.20232f
C1224 a_7387_7125# a_8011_7119# 0
C1225 _39_.B2 _30_.A 0.01177f
C1226 a_4032_7351# a_4167_6147# 0
C1227 VPWR a_6553_4399# 0
C1228 a_5377_5487# _41_.X 0
C1229 _47_.Y a_5989_8751# 0.00123f
C1230 VPWR a_3846_8207# 0
C1231 u_loop.u_gh.C a_3399_6335# 0.30338f
C1232 u_loop.u_gl.A2 _36_.A 0
C1233 a_4038_8573# src[0] 0
C1234 a_2397_4399# _53_.Y 0
C1235 u_loop.u_gh.C a_6817_3861# 0.03511f
C1236 a_4351_9301# a_4867_9673# 0.10421f
C1237 a_7348_5487# xb 0
C1238 en _20_.Y 0.15978f
C1239 _41_.C1 u_loop.u_d0.A 0
C1240 _55_.Q a_6619_4373# 0.01789f
C1241 a_1499_7663# pre 0
C1242 _25_.Y a_7732_4233# 0
C1243 _36_.A a_4075_6825# 0
C1244 a_6283_7663# a_7387_7125# 0.00108f
C1245 a_7631_6335# _32_.A 0.1643f
C1246 a_3044_9411# _62_.D 0
C1247 a_3024_8573# a_2580_7663# 0
C1248 _69_.LO a_8468_5321# 0
C1249 a_3333_6409# a_2877_6005# 0
C1250 a_3684_8585# a_3337_8181# 0.05116f
C1251 a_7109_6005# _25_.A 0
C1252 _62_.D _49_.Y 0.00867f
C1253 a_2356_4765# _27_.Y 0
C1254 a_5649_5737# _41_.X 0
C1255 a_7263_4233# a_6817_3861# 0
C1256 VPWR a_4518_6575# 0.00388f
C1257 a_6375_6037# _41_.X 0.00906f
C1258 a_7066_9117# a_5989_8751# 0
C1259 x u_loop.u_d0.A 0.08888f
C1260 pre a_1654_6575# 0
C1261 a_7109_6005# _57_.CLK 0
C1262 a_3013_5309# _28_.A 0.00232f
C1263 a_7387_4949# a_7456_6409# 0
C1264 _20_.Y u_loop.u_gh.C 0.00504f
C1265 _39_.B2 _46_.A 0.0378f
C1266 VPWR u_loop.u_d7.X 0.68693f
C1267 a_7553_4949# a_7903_5321# 0.21986f
C1268 a_6927_5487# _25_.Y 0
C1269 a_7661_5729# a_7705_5487# 0
C1270 a_7999_7497# a_7903_7497# 0.01379f
C1271 src[0] a_3388_7351# 0.15876f
C1272 a_2157_4399# u_loop.u_gh.C 0.00288f
C1273 u_loop.u_gh.C a_7705_5487# 0.0025f
C1274 a_4097_2767# u_loop.u_d0.X 0
C1275 _39_.B2 _21_.Y 0.22666f
C1276 a_2766_9427# u_loop.u_gh.C 0.23829f
C1277 a_6799_7663# a_6704_7663# 0.04983f
C1278 a_5911_2767# u_loop.u_d5.X 0
C1279 a_3684_8585# a_3119_8585# 0
C1280 prenh a_4769_4175# 0.15529f
C1281 _64_.D a_2233_7905# 0
C1282 a_7443_5487# a_7732_4233# 0
C1283 u_loop.u_gh.C prenl 0
C1284 a_2309_6037# a_2755_6409# 0
C1285 a_2847_5321# _28_.A 0.00488f
C1286 a_6557_8993# u_loop.u_gh.C 0.17361f
C1287 a_8086_4221# u_loop.u_gh.C 0.003f
C1288 VPWR _41_.C1 0.7798f
C1289 u_loop.u_d7.X a_6633_2767# 0.01141f
C1290 a_7093_5487# _32_.A 0.00179f
C1291 _55_.CLK u_loop.u_gh.C 0.05683f
C1292 a_2625_2767# a_2967_2767# 0.00188f
C1293 a_3337_8181# _64_.Q 0
C1294 a_2969_4917# _27_.Y 0
C1295 VPWR a_7894_3855# 0
C1296 a_2625_2767# a_2740_4765# 0
C1297 _32_.A src[1] 0.00142f
C1298 u_loop.u_d0.A _28_.A 0
C1299 a_2595_4636# a_2833_4399# 0.00171f
C1300 a_2015_7663# _64_.Q 0
C1301 a_3083_9537# a_3044_9411# 0.87804f
C1302 a_6796_6397# _32_.Y 0.1576f
C1303 _63_.Q a_2233_7905# 0.00479f
C1304 a_6799_7663# a_6339_8751# 0
C1305 a_7473_7663# a_7017_7905# 0
C1306 a_7387_4949# a_8468_5321# 0.10236f
C1307 VPWR a_5594_9295# 0
C1308 a_1835_4373# a_2122_4651# 0.23366f
C1309 a_2595_4636# u_loop.u_gh.C 0.19367f
C1310 a_5805_2767# u_loop.u_gh.C 0
C1311 VPWR x 0.18985f
C1312 a_3083_9537# _49_.Y 0.25296f
C1313 _63_.D _63_.Q 0.11444f
C1314 _57_.CLK _25_.A 0
C1315 VPWR a_5377_5487# 0.00528f
C1316 a_6927_5487# a_7443_5487# 0.10888f
C1317 a_7631_6335# a_8121_4917# 0
C1318 VPWR _30_.Y 0.64072f
C1319 _41_.C1 _30_.A 0
C1320 _55_.D _41_.X 0
C1321 _39_.B2 _31_.Y 0.02617f
C1322 a_4975_9295# a_4867_9673# 0.05722f
C1323 a_5569_2767# u_loop.u_d7.X 0
C1324 a_8170_5853# a_7661_5729# 0
C1325 u_loop.u_gh.C a_8170_5853# 0
C1326 _63_.D a_2769_8213# 0
C1327 a_3119_8585# _64_.Q 0
C1328 src[0] a_3859_8511# 0
C1329 _25_.A a_6817_3861# 0
C1330 _39_.B2 a_6283_7663# 0.00146f
C1331 a_4518_6825# _41_.B1 0.12827f
C1332 _39_.B2 a_5823_8751# 0.00527f
C1333 a_7732_4233# a_7385_3829# 0.05116f
C1334 a_6553_4399# a_5363_4399# 0
C1335 a_3491_5247# _53_.Y 0
C1336 a_3083_9537# a_3239_9269# 0.10748f
C1337 VPWR a_5649_5737# 0.00739f
C1338 u_loop.u_gh.C a_3224_6409# 0.26145f
C1339 a_7539_7637# _32_.A 0
C1340 a_4833_2767# prenl 0.00292f
C1341 VPWR a_6375_6037# 0.49512f
C1342 _30_.Y _30_.A 0.21891f
C1343 _36_.A a_6541_6037# 0
C1344 a_8468_7497# a_8643_7423# 0.23366f
C1345 VPWR a_6601_8751# 0
C1346 a_6097_4641# u_loop.u_s2.A 0
C1347 a_1499_7663# src[0] 0
C1348 a_8121_7093# a_7903_7497# 0.20964f
C1349 u_loop.u_d0.A _55_.D 0
C1350 _55_.Q a_7072_4221# 0
C1351 a_6619_4373# u_loop.u_gh.C 0.33634f
C1352 VPWR _28_.A 0.74553f
C1353 _56_.CLK a_7348_5487# 0
C1354 u_loop.u_d0.A _56_.D 0
C1355 _36_.A u_loop.u_gh.C 0.01815f
C1356 _63_.Q a_3044_9411# 0
C1357 a_8183_5461# a_7903_7497# 0
C1358 a_4369_6351# u_loop.u_gh.C 0
C1359 a_2015_7663# a_1665_7663# 0.2298f
C1360 a_3024_8573# _62_.D 0.17813f
C1361 _28_.A a_2401_4949# 0.0277f
C1362 _25_.A a_7705_5487# 0.00253f
C1363 a_7093_5487# a_8121_4917# 0.00144f
C1364 VPWR a_8468_7497# 0.30247f
C1365 a_7167_4233# _55_.D 0.00803f
C1366 a_5569_2767# x 0.00319f
C1367 a_1654_6575# src[0] 0.02008f
C1368 u_loop.u_gh.C a_2859_4943# 0.02014f
C1369 a_8822_7485# xb 0
C1370 _25_.Y _32_.A 0
C1371 a_2769_8213# a_3044_9411# 0
C1372 _56_.Q a_6606_4765# 0
C1373 a_7631_6335# a_7456_6409# 0.23366f
C1374 a_5529_4399# _55_.D 0
C1375 _39_.X a_6927_5487# 0
C1376 u_loop.u_gh.C a_2122_4651# 0.22983f
C1377 _20_.Y a_3399_6335# 0
C1378 _56_.Q a_5190_7439# 0
C1379 a_2769_8213# _49_.Y 0
C1380 _39_.X a_8121_7093# 0
C1381 _56_.CLK u_loop.u_gh.B 0.00333f
C1382 a_5529_4399# _56_.D 0.27254f
C1383 a_5911_2767# a_6097_4641# 0
C1384 a_2755_7637# _40_.B 0.00107f
C1385 a_7153_6397# u_loop.u_gh.C 0.00253f
C1386 _21_.Y _30_.Y 0.00114f
C1387 _55_.CLK _25_.A 0.00234f
C1388 _36_.A a_2767_6031# 0
C1389 a_6891_6409# a_6375_6037# 0.10896f
C1390 a_6541_6037# xb 0
C1391 a_2233_7905# u_loop.u_gh.C 0.16744f
C1392 a_8468_7497# _68_.D 0.0014f
C1393 a_2439_4541# a_2969_4917# 0
C1394 u_loop.u_gh.C a_2125_2767# 0
C1395 a_6799_7663# a_6541_6037# 0
C1396 a_2755_7637# src[1] 0
C1397 a_2233_7905# _50_.Y 0
C1398 _63_.D u_loop.u_gh.C 0.00108f
C1399 _36_.A a_7109_6005# 0
C1400 u_loop.u_gl.A2 _56_.CLK 0
C1401 _55_.Q a_8008_5487# 0
C1402 a_2769_8213# a_3239_9269# 0
C1403 VPWR _55_.D 0.47768f
C1404 xb a_7661_5729# 0
C1405 a_5129_9661# u_loop.u_gh.C 0.00316f
C1406 u_loop.u_gh.C xb 0.01823f
C1407 _46_.A a_6375_6037# 0
C1408 a_2143_6037# pre 0.00512f
C1409 a_6601_8751# _46_.A 0.00281f
C1410 a_2603_8213# a_2755_7637# 0.01098f
C1411 _63_.D _50_.Y 0.00858f
C1412 a_3239_9269# a_3477_9661# 0.00171f
C1413 _52_.Y _53_.Y 0
C1414 _55_.CLK a_6817_3861# 0.00234f
C1415 a_6799_7663# u_loop.u_gh.C 0.16805f
C1416 VPWR _56_.D 0.67907f
C1417 a_6397_2767# u_loop.u_s2.Y 0.02806f
C1418 a_6799_7663# a_7364_7663# 0
C1419 _32_.A a_7443_5487# 0
C1420 a_3316_5321# _53_.Y 0
C1421 a_2625_2767# _27_.Y 0
C1422 _42_.Y a_7348_5487# 0
C1423 a_4032_7351# a_3992_7235# 0.16753f
C1424 _39_.B2 a_4867_9673# 0.00952f
C1425 a_2015_7663# a_2111_7663# 0.01379f
C1426 a_2235_4949# _53_.Y 0.26404f
C1427 a_2309_6037# a_1499_7663# 0
C1428 a_6541_6037# a_7017_7905# 0
C1429 a_7093_5487# a_7456_6409# 0
C1430 a_7153_6397# a_7109_6005# 0
C1431 a_2969_4917# a_2659_6409# 0
C1432 _28_.Y _53_.Y 0.05934f
C1433 a_7079_8725# a_5989_8751# 0.04251f
C1434 a_6339_8751# a_6244_8751# 0.04983f
C1435 a_6339_8751# a_6435_8751# 0.01379f
C1436 u_loop.u_gl.B1 a_4351_4175# 0.01626f
C1437 u_loop.u_gh.C a_7017_7905# 0.17563f
C1438 a_7364_7663# a_7017_7905# 0.05116f
C1439 a_6097_4641# a_6141_4399# 0
C1440 VPWR _69_.LO 0.52023f
C1441 VPWR a_4518_6825# 0.52992f
C1442 a_3044_9411# u_loop.u_gh.C 0.08657f
C1443 a_7109_6005# xb 0
C1444 a_6619_4373# _25_.A 0
C1445 u_loop.u_d4.X a_4510_3311# 0.00125f
C1446 a_4439_2767# a_4510_3311# 0
C1447 a_6891_6409# _55_.D 0
C1448 a_3684_8585# src[0] 0
C1449 _36_.A _25_.A 0.0826f
C1450 a_7109_6005# a_6799_7663# 0
C1451 a_3224_6409# a_3399_6335# 0.23366f
C1452 u_loop.u_gh.C _49_.Y 0.08128f
C1453 _25_.Y a_6444_4399# 0
C1454 a_2231_2767# u_loop.u_d0.X 0.1316f
C1455 a_3386_6031# u_loop.u_gh.C 0
C1456 a_6739_2767# a_6651_3861# 0
C1457 a_2905_4399# _53_.Y 0
C1458 _63_.Q _51_.Y 0
C1459 a_5085_9269# u_loop.u_gh.C 0.16688f
C1460 _36_.A _57_.CLK 0.02158f
C1461 a_7072_4221# u_loop.u_gh.C 0.02447f
C1462 a_5569_2767# _56_.D 0
C1463 a_4510_3311# a_4333_2767# 0.00116f
C1464 a_6283_7663# a_6375_6037# 0
C1465 a_6619_4373# a_6817_3861# 0
C1466 a_2656_5309# _53_.Y 0.00208f
C1467 a_3478_4943# a_2969_4917# 0
C1468 a_7539_7637# a_7456_6409# 0
C1469 a_2877_6005# a_2659_6409# 0.20964f
C1470 a_7167_4233# a_7387_4949# 0
C1471 a_1499_6575# src[1] 0.11244f
C1472 a_2751_5321# _28_.A 0.03675f
C1473 _36_.A a_3399_6335# 0
C1474 a_3083_9537# a_4351_9301# 0.10415f
C1475 a_3239_9269# u_loop.u_gh.C 0.18634f
C1476 a_2689_7663# a_2233_7905# 0
C1477 a_2231_2767# a_2122_4651# 0
C1478 _55_.Q _42_.Y 0.28592f
C1479 a_6999_6031# a_6541_6037# 0.03462f
C1480 a_1920_7663# _63_.D 0.16124f
C1481 _48_.Y a_3044_9411# 0
C1482 _39_.X _32_.A 0
C1483 a_7841_4233# a_7385_3829# 0
C1484 a_3024_8573# _63_.Q 0.00399f
C1485 a_4510_3311# u_loop.u_s2.A 0
C1486 _20_.Y a_3224_6409# 0
C1487 a_7263_4233# a_7072_4221# 0
C1488 _45_.A _32_.A 0.00291f
C1489 a_7810_6397# u_loop.u_gh.C 0.00212f
C1490 a_5975_4399# _55_.D 0
C1491 _48_.Y _49_.Y 0.31536f
C1492 a_7551_5853# xb 0
C1493 a_2231_2767# a_2125_2767# 0.41909f
C1494 a_6987_6409# _32_.A 0.00433f
C1495 a_6999_6031# u_loop.u_gh.C 0.01337f
C1496 _25_.Y a_7907_4159# 0
C1497 a_7903_5321# _67_.D 0
C1498 a_3024_8573# a_2769_8213# 0.06418f
C1499 _48_.Y a_5085_9269# 0
C1500 _56_.Q a_7903_5321# 0
C1501 u_loop.u_gh.C a_2277_7663# 0.00328f
C1502 a_1499_6575# a_1582_6575# 0.00726f
C1503 _22_.Y _32_.A 0
C1504 xb _25_.A 0.00303f
C1505 _55_.Q a_7275_3855# 0
C1506 src[0] _64_.Q 0.54504f
C1507 _55_.D a_5363_4399# 0
C1508 a_7456_6409# _25_.Y 0
C1509 VPWR a_7387_4949# 0.45047f
C1510 _41_.B1 a_5377_7439# 0.01938f
C1511 _41_.B1 _38_.X 0.07066f
C1512 u_loop.u_cmp.Y a_5175_2767# 0.00164f
C1513 a_2769_2223# u_loop.u_d1.X 0.01139f
C1514 a_5389_7119# a_5377_7439# 0
C1515 _56_.D a_5363_4399# 0.16557f
C1516 a_8008_5487# a_7661_5729# 0.05116f
C1517 a_2143_6037# src[0] 0
C1518 _53_.A _53_.Y 0.12958f
C1519 en _51_.Y 0
C1520 u_loop.u_gh.B a_2969_4917# 0
C1521 u_loop.u_gh.C a_8008_5487# 0.23698f
C1522 a_2439_4541# a_2625_2767# 0
C1523 a_2400_4667# a_2861_2767# 0
C1524 prenh u_loop.u_s2.Y 0
C1525 _32_.Y a_6704_7663# 0
C1526 VPWR _70_.LO 0.50684f
C1527 _56_.CLK a_7661_5729# 0
C1528 _56_.CLK u_loop.u_gh.C 0.04014f
C1529 _55_.CLK a_6619_4373# 0.0135f
C1530 VPWR a_2875_2223# 0.18636f
C1531 a_2769_8213# a_3348_7235# 0.00108f
C1532 a_6999_6031# a_7109_6005# 0.09774f
C1533 a_7553_4949# a_8630_4943# 0
C1534 u_loop.u_gh.C a_2801_9661# 0.00288f
C1535 u_loop.u_gh.C a_6244_8751# 0.00296f
C1536 u_loop.u_gh.C a_6435_8751# 0
C1537 _22_.Y a_6447_9117# 0
C1538 VPWR a_5989_8751# 0.62481f
C1539 u_loop.u_gh.C _51_.Y 0.00144f
C1540 _63_.D _20_.Y 0
C1541 _68_.D _70_.LO 0.06914f
C1542 a_6449_7663# a_7079_8725# 0
C1543 a_7456_6409# a_7443_5487# 0.00268f
C1544 a_3388_7351# a_3992_7235# 0.06623f
C1545 _41_.B1 _40_.B 0
C1546 a_5190_5487# _67_.D 0
C1547 u_loop.u_d7.X u_loop.u_cmp.Y 0
C1548 _56_.Q a_5190_5487# 0.10504f
C1549 a_5389_7119# _40_.B 0
C1550 a_6891_6409# a_7387_4949# 0
C1551 u_loop.u_q.B u_loop.u_s2.A 0.50453f
C1552 _41_.B1 src[1] 0.10151f
C1553 _55_.Q a_7429_4221# 0
C1554 src[0] a_1665_7663# 0
C1555 a_8577_7497# a_7387_7125# 0
C1556 u_loop.u_d6.X u_loop.u_s2.A 0.04343f
C1557 a_4032_7351# a_3388_7351# 0.00534f
C1558 a_3024_8573# u_loop.u_gh.C 0.00145f
C1559 a_4351_4175# u_loop.u_d0.A 0.0308f
C1560 _30_.A a_5989_8751# 0
C1561 VPWR a_3384_9295# 0.1325f
C1562 u_loop.u_d0.A a_5069_2767# 0.11758f
C1563 a_2595_4636# a_2122_4651# 0
C1564 _42_.Y a_6541_6037# 0
C1565 a_3024_8573# _50_.Y 0
C1566 a_2309_6037# _64_.Q 0.00108f
C1567 a_2755_7637# a_3119_8585# 0
C1568 a_6097_4641# a_6606_4765# 0
C1569 a_7903_5321# a_7999_5321# 0.01379f
C1570 a_2755_7637# a_3227_8207# 0
C1571 _36_.A a_3224_6409# 0
C1572 a_2015_7663# _52_.Y 0
C1573 a_6739_2767# u_loop.u_d7.X 0.1316f
C1574 a_7072_4221# a_6817_3861# 0.06418f
C1575 a_8643_7423# xa 0.10655f
C1576 a_7618_6031# a_7456_6409# 0.00645f
C1577 a_4167_6147# _64_.Q 0.01393f
C1578 a_7093_5487# _41_.X 0.00179f
C1579 a_6449_7663# a_7526_8029# 0
C1580 a_4369_6351# a_3224_6409# 0
C1581 _42_.Y a_7661_5729# 0
C1582 a_2755_7637# a_3170_9295# 0
C1583 _36_.A a_5389_5737# 0.0012f
C1584 a_6796_6397# a_6375_6037# 0.08968f
C1585 _42_.Y u_loop.u_gh.C 0.0019f
C1586 a_2309_6037# a_2143_6037# 0.85278f
C1587 _28_.A _27_.Y 0
C1588 a_5911_2767# u_loop.u_q.B 0
C1589 x u_loop.u_cmp.Y 0.05778f
C1590 a_2479_9269# a_2755_7637# 0
C1591 a_7808_5309# a_7903_5321# 0.04983f
C1592 a_2143_6037# a_4167_6147# 0
C1593 a_2625_2767# u_loop.u_d1.X 0.31702f
C1594 a_3384_9295# _30_.A 0.02652f
C1595 a_1845_6825# a_1654_6575# 0
C1596 u_loop.u_d0.A _53_.Y 0
C1597 _68_.D a_8165_7485# 0
C1598 a_3348_7235# u_loop.u_gh.C 0.01803f
C1599 a_2766_9427# a_3044_9411# 0.11876f
C1600 a_3992_7235# a_3859_8511# 0.00151f
C1601 _36_.A a_4369_6351# 0.08695f
C1602 u_loop.u_gl.B1 a_4333_2767# 0.00173f
C1603 VPWR xa 0.37052f
C1604 _46_.A a_5989_8751# 0.01115f
C1605 u_loop.u_d6.X a_5911_2767# 0.14526f
C1606 a_8008_5487# _25_.A 0.02147f
C1607 a_8170_5853# xb 0
C1608 a_7263_4233# _42_.Y 0
C1609 a_2356_4765# u_loop.u_gh.C 0
C1610 a_7275_3855# u_loop.u_gh.C 0.0122f
C1611 a_4351_9301# u_loop.u_gh.C 0.66474f
C1612 _21_.Y a_5989_8751# 0
C1613 a_5879_4399# u_loop.u_s2.A 0
C1614 VPWR a_7631_6335# 0.44004f
C1615 _56_.CLK _25_.A 0.2448f
C1616 u_loop.u_d0.X a_2122_4651# 0
C1617 a_1920_7663# _51_.Y 0.00188f
C1618 a_4032_7351# a_3859_8511# 0
C1619 VPWR a_5377_7439# 0.00688f
C1620 VPWR a_4351_4175# 0.00562f
C1621 VPWR _38_.X 0.38765f
C1622 VPWR a_5069_2767# 0.28255f
C1623 a_2015_7663# a_1499_6575# 0
C1624 _55_.Q a_6651_3861# 0.00128f
C1625 _68_.D xa 0.01541f
C1626 a_2689_7663# _51_.Y 0
C1627 a_5607_9599# _47_.Y 0.00219f
C1628 _42_.Y a_7109_6005# 0
C1629 a_2766_9427# a_3239_9269# 0
C1630 a_7167_4233# a_7093_5487# 0
C1631 u_loop.u_d0.X a_2125_2767# 0.01139f
C1632 _56_.Q a_7553_4949# 0
C1633 _68_.D a_7631_6335# 0
C1634 a_2309_6037# a_1665_7663# 0
C1635 _32_.Y a_6541_6037# 0.30774f
C1636 _55_.CLK a_7072_4221# 0
C1637 _55_.Q a_8362_5487# 0
C1638 a_2875_2223# a_2967_2767# 0
C1639 _48_.Y a_4351_9301# 0.25405f
C1640 a_6283_7663# _70_.LO 0
C1641 a_1499_7663# a_2123_8029# 0
C1642 a_7093_5487# a_7539_5487# 0
C1643 u_loop.u_d5.X prenh 0
C1644 _38_.X _30_.A 0
C1645 a_2122_4651# a_2125_2767# 0
C1646 VPWR _53_.Y 0.60297f
C1647 a_5911_2767# a_5879_4399# 0
C1648 _32_.Y u_loop.u_gh.C 0.00113f
C1649 a_2969_4917# u_loop.u_gh.C 0.17439f
C1650 VPWR a_6449_7663# 0.59634f
C1651 _31_.Y a_5989_8751# 0.22423f
C1652 a_3083_9537# _39_.B2 0
C1653 a_2533_2223# u_loop.u_d0.A 0
C1654 VPWR _40_.B 1.25672f
C1655 a_2401_4949# _53_.Y 0.01559f
C1656 _39_.B2 a_6704_7663# 0
C1657 a_6283_7663# a_5989_8751# 0.00184f
C1658 VPWR a_7093_5487# 0.58156f
C1659 pre _52_.Y 0.01545f
C1660 a_5989_8751# a_5823_8751# 0.90645f
C1661 _63_.D a_2233_7905# 0.00213f
C1662 a_4160_6575# a_4518_6575# 0.01892f
C1663 VPWR src[1] 1.32542f
C1664 a_3386_6031# a_3224_6409# 0.00645f
C1665 u_loop.u_gh.C a_7429_4221# 0.00396f
C1666 _38_.X a_3514_7235# 0
C1667 a_2742_8029# a_1665_7663# 0
C1668 a_3703_2767# a_3597_2767# 0.41909f
C1669 a_5569_2767# a_5069_2767# 0
C1670 _56_.CLK a_7705_5487# 0
C1671 VPWR a_2603_8213# 0.48412f
C1672 _42_.Y _25_.A 0.0148f
C1673 a_6927_5487# a_7903_5321# 0
C1674 _20_.Y _51_.Y 0.00351f
C1675 a_3348_7235# a_3430_7235# 0
C1676 a_2439_4541# _28_.A 0.00162f
C1677 _30_.A _40_.B 0.0321f
C1678 a_7093_5487# _68_.D 0
C1679 a_7387_4949# a_8011_4943# 0
C1680 _38_.X _21_.Y 0
C1681 a_7109_6005# _32_.Y 0
C1682 _36_.A a_3386_6031# 0
C1683 a_5432_9673# a_5607_9599# 0.23366f
C1684 _39_.B2 a_6339_8751# 0
C1685 a_4975_9295# u_loop.u_gh.C 0.0122f
C1686 a_6619_4373# a_7072_4221# 0
C1687 VPWR a_1582_6575# 0
C1688 _30_.A src[1] 0
C1689 a_2877_6005# u_loop.u_gh.C 0.17379f
C1690 a_7387_7125# a_6541_6037# 0
C1691 _41_.C1 a_4160_6575# 0.02104f
C1692 _55_.CLK _56_.CLK 0.01421f
C1693 a_3491_5247# src[0] 0
C1694 a_2143_6037# a_2526_4765# 0
C1695 a_4517_9301# a_5432_9673# 0.11876f
C1696 u_loop.u_gl.A2 a_6553_4399# 0
C1697 _42_.Y a_6817_3861# 0
C1698 a_2603_8213# _30_.A 0
C1699 a_6557_8993# a_6435_8751# 0
C1700 a_4038_8573# a_3859_8511# 0.0074f
C1701 a_7903_5321# a_8183_5461# 0
C1702 a_5879_4399# a_6141_4399# 0.00171f
C1703 a_7167_4233# _25_.Y 0
C1704 _62_.D _30_.Y 0
C1705 VPWR a_7539_7637# 0.42036f
C1706 pre a_1499_6575# 0
C1707 u_loop.u_gh.B a_4518_6575# 0
C1708 VPWR a_2533_2223# 0.32565f
C1709 a_7093_5487# a_6891_6409# 0.00564f
C1710 a_7387_7125# u_loop.u_gh.C 0.36645f
C1711 a_7364_7663# a_7387_7125# 0
C1712 a_3348_7235# a_3399_6335# 0
C1713 u_loop.u_d4.X u_loop.u_d0.A 0.15856f
C1714 a_3514_7235# _40_.B 0
C1715 a_5529_4399# _25_.Y 0
C1716 a_4439_2767# u_loop.u_d0.A 0.08289f
C1717 a_7553_4949# a_7999_5321# 0
C1718 a_6449_7663# _46_.A 0.03746f
C1719 a_8170_5853# a_8008_5487# 0.00645f
C1720 _28_.A a_2659_6409# 0
C1721 a_7631_6335# a_8011_7119# 0
C1722 a_3684_8585# a_3992_7235# 0
C1723 a_7539_5487# _25_.Y 0
C1724 a_1845_6825# _64_.Q 0
C1725 a_3514_7235# src[1] 0.00415f
C1726 a_7718_7663# u_loop.u_gh.C 0.00248f
C1727 a_7275_3855# a_6817_3861# 0.03462f
C1728 a_2877_6005# a_2767_6031# 0.09774f
C1729 a_6999_6031# _36_.A 0
C1730 a_4975_9295# _48_.Y 0.00108f
C1731 a_6799_7663# a_7017_7905# 0.20964f
C1732 a_2400_4667# a_2397_4399# 0
C1733 _21_.Y _40_.B 0
C1734 a_7539_7637# _68_.D 0.04307f
C1735 a_7553_4949# a_7808_5309# 0.06418f
C1736 a_4333_2767# u_loop.u_d0.A 0.10825f
C1737 _41_.B1 _39_.X 0
C1738 a_6651_3861# a_7661_5729# 0
C1739 a_7079_8725# _39_.X 0
C1740 a_6651_3861# u_loop.u_gh.C 0.36099f
C1741 a_3684_8585# a_4032_7351# 0
C1742 VPWR _25_.Y 0.76446f
C1743 _41_.C1 u_loop.u_gh.B 0
C1744 a_5129_9661# a_5085_9269# 0
C1745 _45_.A _41_.B1 0
C1746 a_2755_7637# src[0] 0
C1747 a_7553_7125# a_7387_7125# 0.90207f
C1748 a_7258_8751# u_loop.u_gh.C 0.00231f
C1749 _32_.Y _25_.A 0
C1750 _45_.A a_7079_8725# 0
C1751 a_6444_4399# a_6606_4765# 0.00645f
C1752 a_2921_6397# a_2659_6409# 0.00171f
C1753 u_loop.u_d0.A u_loop.u_s2.A 0.24895f
C1754 a_7167_4233# a_7443_5487# 0
C1755 a_2769_8213# a_3846_8207# 0
C1756 u_loop.u_gh.C a_8362_5487# 0.00288f
C1757 _22_.Y _41_.B1 0
C1758 _56_.CLK a_6619_4373# 0
C1759 _32_.Y _57_.CLK 0.07f
C1760 a_7263_4233# a_6651_3861# 0
C1761 a_6449_7663# a_6895_7663# 0
C1762 _56_.CLK _36_.A 0.00248f
C1763 _55_.CLK _42_.Y 0.00749f
C1764 _39_.X _41_.X 0
C1765 a_2233_7905# a_2277_7663# 0
C1766 _41_.C1 a_4075_6825# 0.00929f
C1767 VPWR u_loop.u_d4.X 0.24648f
C1768 a_7539_5487# a_7443_5487# 0.01379f
C1769 VPWR a_4439_2767# 0.1834f
C1770 a_2751_5321# _53_.Y 0.00189f
C1771 a_3083_9537# _30_.Y 0.16462f
C1772 a_2740_4765# _53_.Y 0.00191f
C1773 pre _53_.A 0
C1774 a_7539_7637# _46_.A 0
C1775 a_6999_6031# xb 0
C1776 _45_.A _41_.X 0
C1777 src[0] _52_.Y 0
C1778 a_3158_4765# a_2905_4399# 0
C1779 a_2625_2767# u_loop.u_gh.C 0
C1780 a_3044_9411# _49_.Y 0.00508f
C1781 a_6283_7663# a_6449_7663# 0.90036f
C1782 a_5529_4399# u_loop.u_s2.A 0
C1783 a_6449_7663# a_5823_8751# 0
C1784 a_3041_9661# a_3170_9295# 0
C1785 a_6999_6031# a_6799_7663# 0
C1786 a_4772_9661# a_4517_9301# 0.06121f
C1787 a_3316_5321# src[0] 0
C1788 VPWR a_7443_5487# 0.20392f
C1789 VPWR a_4333_2767# 0.28925f
C1790 a_4032_7351# _64_.Q 0
C1791 a_2526_4765# a_2397_4399# 0
C1792 a_5911_2767# u_loop.u_d0.A 0
C1793 _28_.A a_2564_6397# 0
C1794 a_7553_4949# a_7732_4233# 0
C1795 a_3044_9411# a_3239_9269# 0.21686f
C1796 a_6541_6037# a_7565_6409# 0
C1797 a_2123_8029# _64_.Q 0
C1798 _39_.B2 u_loop.u_gh.C 0.16092f
C1799 a_8008_5487# xb 0.00278f
C1800 a_7167_4233# a_7385_3829# 0.20964f
C1801 a_7631_6335# a_8011_4943# 0
C1802 VPWR u_loop.u_s2.A 0.52491f
C1803 u_loop.u_gh.B _28_.A 0
C1804 a_8468_7497# a_8577_7497# 0.00742f
C1805 _68_.D a_7443_5487# 0
C1806 a_2233_7905# _51_.Y 0
C1807 u_loop.u_gh.C a_7565_6409# 0
C1808 VPWR a_7903_7497# 0.2074f
C1809 a_7808_7485# a_7443_5487# 0
C1810 VPWR a_3337_8181# 0.21151f
C1811 _42_.Y a_6619_4373# 0.00394f
C1812 a_5529_4399# a_5911_2767# 0
C1813 src[0] a_1499_6575# 0.31594f
C1814 a_6444_4399# a_6397_2767# 0
C1815 a_7539_7637# a_8011_7119# 0
C1816 a_3348_7235# a_3224_6409# 0
C1817 u_loop.u_gh.C a_8165_5309# 0.00316f
C1818 _63_.D _51_.Y 0.00529f
C1819 VPWR a_7618_6031# 0
C1820 a_6651_3861# a_7551_5853# 0
C1821 a_2309_6037# a_2755_7637# 0
C1822 a_7553_4949# a_6927_5487# 0
C1823 VPWR a_2015_7663# 0.24748f
C1824 _39_.X a_8643_7423# 0
C1825 a_6553_4399# u_loop.u_gh.C 0
C1826 a_3846_8207# u_loop.u_gh.C 0
C1827 _55_.CLK _32_.Y 0
C1828 a_3549_9661# u_loop.u_gh.C 0.00282f
C1829 _53_.A a_3158_4765# 0
C1830 _39_.B2 _48_.Y 0.00131f
C1831 a_6651_3861# _25_.A 0
C1832 VPWR a_7385_3829# 0.21156f
C1833 a_6601_8751# a_6339_8751# 0.00171f
C1834 a_7539_7637# a_6283_7663# 0.04359f
C1835 _56_.Q a_5987_4765# 0
C1836 _68_.D a_7903_7497# 0.00832f
C1837 a_5190_5487# _32_.A 0.02147f
C1838 a_3000_9295# a_3170_9295# 0
C1839 _25_.Y a_5363_4399# 0
C1840 a_2877_6005# _20_.Y 0
C1841 _64_.D _28_.A 0.00648f
C1842 a_7808_7485# a_7903_7497# 0.04983f
C1843 a_3024_8573# _63_.D 0
C1844 a_3802_9295# a_3859_8511# 0
C1845 VPWR a_5911_2767# 0.24084f
C1846 a_2969_4917# a_2595_4636# 0
C1847 a_7553_4949# a_8183_5461# 0.0025f
C1848 a_8362_5487# _25_.A 0
C1849 a_2755_6409# _64_.Q 0
C1850 VPWR a_3119_8585# 0.20693f
C1851 VPWR _39_.X 1.04504f
C1852 a_7093_5487# a_8011_4943# 0
C1853 VPWR a_3227_8207# 0.1421f
C1854 a_2015_7663# _30_.A 0
C1855 a_2769_2223# prenl 0
C1856 a_2309_6037# _52_.Y 0.13301f
C1857 a_4518_6825# a_4160_6575# 0.27101f
C1858 a_7109_6005# a_7565_6409# 0
C1859 u_loop.u_q.B a_6397_2767# 0.01517f
C1860 a_6651_3861# a_6817_3861# 0.90207f
C1861 _56_.Q _67_.D 0
C1862 VPWR _45_.A 0.99513f
C1863 a_7903_5321# a_8121_4917# 0.20964f
C1864 VPWR a_3170_9295# 0.20811f
C1865 a_2123_8029# a_1665_7663# 0.03462f
C1866 a_2309_6037# a_3316_5321# 0
C1867 u_loop.u_d7.X u_loop.u_gh.C 0.00234f
C1868 u_loop.u_gh.B _56_.D 0.03044f
C1869 u_loop.u_d6.X a_6397_2767# 0.29452f
C1870 VPWR a_2479_9269# 0.42857f
C1871 a_2309_6037# a_2235_4949# 0
C1872 VPWR _22_.Y 0.4697f
C1873 a_2356_4765# a_2122_4651# 0.00645f
C1874 _39_.X _68_.D 0.00198f
C1875 a_2309_6037# _28_.Y 0
C1876 a_3119_8585# _30_.A 0
C1877 a_4833_2767# a_5175_2767# 0.00188f
C1878 _39_.X a_7808_7485# 0
C1879 _45_.A _68_.D 0.15755f
C1880 u_loop.u_gl.A2 _56_.D 0
C1881 a_6457_2473# u_loop.u_s2.Y 0.00353f
C1882 _55_.Q _55_.D 0.11299f
C1883 _28_.A a_1835_4373# 0.0011f
C1884 _41_.C1 u_loop.u_gh.C 0.03611f
C1885 _30_.A a_3170_9295# 0.01862f
C1886 a_2603_8213# a_3215_8585# 0.00188f
C1887 _45_.A a_7808_7485# 0
C1888 a_3024_8573# a_3044_9411# 0
C1889 _27_.Y _53_.Y 0.03103f
C1890 _36_.A _32_.Y 0.00303f
C1891 a_4510_3311# prenh 0.01589f
C1892 _22_.Y _68_.D 0
C1893 u_loop.u_gh.C a_7894_3855# 0
C1894 a_2479_9269# _30_.A 0.13624f
C1895 _39_.X a_6891_6409# 0
C1896 _22_.Y a_7808_7485# 0
C1897 a_3793_8585# a_2769_8213# 0
C1898 VPWR a_6141_4399# 0.00258f
C1899 a_5569_2767# a_5911_2767# 0.00188f
C1900 a_2400_4667# _52_.Y 0
C1901 a_2969_4917# a_2859_4943# 0.09774f
C1902 _45_.A a_6891_6409# 0
C1903 a_5594_9295# u_loop.u_gh.C 0
C1904 a_5363_4399# u_loop.u_s2.A 0
C1905 _41_.B1 src[0] 0.00319f
C1906 a_7903_5321# a_7907_4159# 0.00173f
C1907 a_5389_7119# src[0] 0
C1908 a_6987_6409# a_6891_6409# 0.01379f
C1909 _30_.Y u_loop.u_gh.C 0.07234f
C1910 _39_.X _46_.A 0
C1911 VPWR pre 0.44285f
C1912 a_2656_5309# a_2309_6037# 0
C1913 a_8165_5309# _25_.A 0
C1914 _64_.Q a_3388_7351# 0.21473f
C1915 _55_.CLK a_6651_3861# 0.26845f
C1916 a_6397_2767# a_5879_4399# 0
C1917 a_8643_5247# a_7553_4949# 0.04251f
C1918 a_2877_6005# a_3224_6409# 0.05116f
C1919 u_loop.u_d0.A a_3158_4765# 0.0017f
C1920 _48_.Y _41_.C1 0.00162f
C1921 a_2400_4667# a_2235_4949# 0
C1922 _51_.Y a_2277_7663# 0
C1923 a_4518_6825# a_4075_6825# 0.02665f
C1924 _45_.A _46_.A 0.01485f
C1925 _55_.Q _69_.LO 0
C1926 a_6375_6037# a_6541_6037# 0.72986f
C1927 a_3684_8585# a_3859_8511# 0.23366f
C1928 a_7903_7497# a_8011_7119# 0.05722f
C1929 a_2400_4667# _28_.Y 0.00197f
C1930 _25_.Y a_8011_4943# 0
C1931 u_loop.u_d0.X a_2769_2223# 0.00944f
C1932 _41_.B1 a_5190_7439# 0.10075f
C1933 a_5541_9673# a_4517_9301# 0
C1934 a_8630_7119# a_8121_7093# 0
C1935 _22_.Y _46_.A 0.02242f
C1936 a_5389_7119# a_5190_7439# 0.0129f
C1937 _39_.X a_5649_7119# 0
C1938 a_4351_9301# a_3044_9411# 0.00133f
C1939 VPWR a_5607_9599# 0.47436f
C1940 _36_.A a_2877_6005# 0
C1941 u_loop.u_gh.C a_6375_6037# 0.30497f
C1942 a_6601_8751# u_loop.u_gh.C 0.00222f
C1943 a_3670_5309# u_loop.u_gh.C 0.00231f
C1944 a_2625_2767# prenl 0
C1945 _56_.Q a_5784_4399# 0
C1946 _45_.A a_5649_7119# 0
C1947 a_2875_2223# u_loop.u_d1.X 0.1316f
C1948 VPWR a_4517_9301# 0.51783f
C1949 _48_.Y _30_.Y 0.01237f
C1950 a_4351_9301# _49_.Y 0.00464f
C1951 a_5911_2767# a_5363_4399# 0
C1952 _28_.A u_loop.u_gh.C 0.45559f
C1953 a_4351_9301# a_5085_9269# 0.05811f
C1954 a_6907_8029# a_6449_7663# 0.03462f
C1955 a_2603_8213# a_2580_7663# 0
C1956 a_2400_4667# a_2905_4399# 0
C1957 a_6244_8751# a_6435_8751# 0
C1958 _57_.CLK a_4518_6575# 0
C1959 a_8117_5487# a_7661_5729# 0
C1960 _41_.X a_5190_7439# 0
C1961 _56_.Q a_7808_5309# 0
C1962 a_8117_5487# u_loop.u_gh.C 0
C1963 u_loop.u_q.B prenh 0
C1964 a_8468_7497# u_loop.u_gh.C 0.23761f
C1965 a_8468_5321# a_7903_5321# 0
C1966 _45_.A a_6895_7663# 0.00444f
C1967 _39_.X _31_.Y 0
C1968 _39_.B2 a_6557_8993# 0
C1969 a_2625_2767# a_2595_4636# 0
C1970 a_8577_5321# u_loop.u_gh.C 0
C1971 a_7553_7125# a_6375_6037# 0
C1972 _64_.Q a_3859_8511# 0
C1973 VPWR a_3158_4765# 0.08325f
C1974 a_4517_9301# _30_.A 0.00117f
C1975 a_3793_8585# u_loop.u_gh.C 0
C1976 u_loop.u_gl.B1 a_4076_3561# 0.08109f
C1977 a_6619_4373# a_6651_3861# 0.01027f
C1978 a_6283_7663# _39_.X 0.01166f
C1979 _45_.A _31_.Y 0
C1980 a_7013_8751# a_5989_8751# 0
C1981 _22_.Y a_6895_7663# 0
C1982 _39_.X a_5823_8751# 0
C1983 a_7109_6005# a_6375_6037# 0.05843f
C1984 _32_.A _46_.Y 0
C1985 _41_.C1 _25_.A 0
C1986 a_2921_6397# u_loop.u_gh.C 0.00406f
C1987 u_loop.u_d7.X a_6817_3861# 0
C1988 a_2235_4949# a_2526_4765# 0
C1989 a_6283_7663# _45_.A 0.17332f
C1990 _45_.A a_5823_8751# 0
C1991 a_2526_4765# _28_.Y 0
C1992 _55_.Q a_7387_4949# 0.00211f
C1993 _22_.Y _31_.Y 0
C1994 a_2439_4541# _53_.Y 0.01056f
C1995 a_1499_7663# _64_.Q 0.00868f
C1996 _41_.B1 a_4167_6147# 0
C1997 _22_.Y a_6283_7663# 0.22314f
C1998 _22_.Y a_5823_8751# 0
C1999 a_7553_7125# a_8468_7497# 0.12532f
C2000 _55_.D u_loop.u_gh.C 0.24843f
C2001 a_7553_4949# a_8121_4917# 0.17589f
C2002 _41_.C1 a_3399_6335# 0.00266f
C2003 _55_.CLK a_6553_4399# 0
C2004 a_4963_9673# a_4517_9301# 0
C2005 a_5377_5487# _25_.A 0.02568f
C2006 u_loop.u_gh.C _56_.D 0.02729f
C2007 a_6817_3861# a_7894_3855# 0
C2008 _21_.Y a_5607_9599# 0.00106f
C2009 a_2400_4667# _53_.A 0
C2010 a_5529_4399# a_6606_4765# 0
C2011 a_2526_4765# a_2905_4399# 0
C2012 _21_.Y a_4517_9301# 0.61967f
C2013 a_2625_2767# u_loop.u_d0.X 0.09265f
C2014 a_7263_4233# _55_.D 0.00146f
C2015 a_5190_5487# a_5879_4399# 0
C2016 VPWR src[0] 2.56297f
C2017 _69_.LO a_6541_6037# 0
C2018 a_3348_7235# _51_.Y 0
C2019 a_3083_9537# a_3384_9295# 0
C2020 a_3337_8181# a_3215_8585# 0
C2021 u_loop.u_s2.Y a_6097_4641# 0
C2022 a_6375_6037# _25_.A 0
C2023 u_loop.u_gl.B1 prenh 0.00304f
C2024 a_6339_8751# a_5989_8751# 0.2298f
C2025 a_3386_6031# a_2877_6005# 0
C2026 _69_.LO u_loop.u_gh.C 0.00209f
C2027 a_4975_9295# a_5085_9269# 0.09774f
C2028 VPWR a_6606_4765# 0
C2029 _36_.A _39_.B2 0.09108f
C2030 _55_.CLK u_loop.u_d7.X 0
C2031 a_5987_4765# a_6097_4641# 0.09774f
C2032 _57_.CLK a_6375_6037# 0.26836f
C2033 a_7808_5309# a_7999_5321# 0
C2034 VPWR a_5190_7439# 0.60782f
C2035 a_6798_4399# u_loop.u_gh.C 0.00351f
C2036 a_8577_7497# xa 0
C2037 src[0] _30_.A 0
C2038 a_7553_4949# a_7907_4159# 0
C2039 a_6927_5487# _67_.D 0.16683f
C2040 a_1845_6825# a_1499_6575# 0.01147f
C2041 _56_.Q a_6927_5487# 0
C2042 a_2625_2767# a_2125_2767# 0
C2043 a_1499_7663# a_1665_7663# 0.88863f
C2044 _31_.Y a_5607_9599# 0.00386f
C2045 a_8121_7093# _67_.D 0
C2046 a_8117_5487# _25_.A 0
C2047 u_loop.u_d0.A a_6397_2767# 0.00105f
C2048 _62_.D _40_.B 0.09771f
C2049 u_loop.u_d7.X a_5805_2767# 0
C2050 a_3119_8585# a_3215_8585# 0.01379f
C2051 a_8577_5321# _25_.A 0
C2052 a_5607_9599# a_5823_8751# 0
C2053 _28_.A a_3399_6335# 0
C2054 _56_.Q a_6097_4641# 0.00158f
C2055 u_loop.u_d4.X u_loop.u_d3.X 0.00342f
C2056 _62_.D src[1] 0
C2057 a_2766_9427# _30_.Y 0
C2058 a_4439_2767# u_loop.u_d3.X 0
C2059 _53_.A a_2526_4765# 0
C2060 a_8183_5461# _67_.D 0
C2061 a_4160_6575# _40_.B 0
C2062 a_2603_8213# _62_.D 0.32589f
C2063 a_5190_5487# a_5293_5487# 0.02752f
C2064 src[0] a_3514_7235# 0
C2065 x prenl 0
C2066 u_loop.u_gh.B a_4351_4175# 0.1823f
C2067 _42_.Y a_7275_3855# 0
C2068 a_5529_4399# a_6397_2767# 0
C2069 a_4160_6575# src[1] 0.23729f
C2070 a_7387_4949# a_6541_6037# 0
C2071 a_6651_3861# a_7072_4221# 0.08638f
C2072 a_4333_2767# u_loop.u_d3.X 0.00315f
C2073 u_loop.u_cmp.Y u_loop.u_s2.A 0.14338f
C2074 a_2751_5321# a_3158_4765# 0
C2075 _55_.D _25_.A 0
C2076 a_7066_9117# a_6904_8751# 0.00645f
C2077 _39_.B2 a_6799_7663# 0
C2078 u_loop.u_gl.A2 a_4351_4175# 0.0081f
C2079 a_3684_8585# _64_.Q 0
C2080 a_7093_5487# a_7348_5487# 0.06418f
C2081 u_loop.u_gl.A2 a_5069_2767# 0.00248f
C2082 _55_.Q a_7631_6335# 0
C2083 a_2400_4667# u_loop.u_d0.A 0.00314f
C2084 a_7387_4949# a_7661_5729# 0
C2085 VPWR a_2309_6037# 0.60151f
C2086 _41_.B1 a_5190_5487# 0.09641f
C2087 a_7387_4949# u_loop.u_gh.C 0.50878f
C2088 _25_.A _56_.D 0
C2089 a_2580_7663# a_2015_7663# 0
C2090 _41_.B1 prenh 0
C2091 a_7553_4949# a_8468_5321# 0.12532f
C2092 _41_.C1 a_3224_6409# 0
C2093 u_loop.u_d0.A a_4076_3561# 0.0763f
C2094 VPWR a_4167_6147# 0.22246f
C2095 x a_5805_2767# 0.00212f
C2096 src[0] a_5649_7119# 0
C2097 a_6601_8751# a_6557_8993# 0
C2098 a_6987_6409# a_6796_6397# 0
C2099 VPWR a_6397_2767# 0.346f
C2100 a_1499_7663# a_2111_7663# 0.00188f
C2101 a_2309_6037# a_2401_4949# 0
C2102 _55_.D a_6817_3861# 0.23677f
C2103 _55_.CLK a_6375_6037# 0
C2104 _41_.B1 a_5293_7439# 0.01894f
C2105 a_3083_9537# _40_.B 0.00547f
C2106 _70_.LO u_loop.u_gh.C 0
C2107 a_6449_7663# a_6704_7663# 0.06418f
C2108 _39_.B2 a_7017_7905# 0
C2109 a_8121_4917# a_8630_4943# 0
C2110 a_6449_7663# a_7473_7663# 0
C2111 a_2921_6397# _20_.Y 0
C2112 _36_.A _41_.C1 0.09101f
C2113 a_2875_2223# u_loop.u_gh.C 0
C2114 _32_.A a_5987_4765# 0
C2115 u_loop.u_cmp.Y a_5911_2767# 0.02399f
C2116 a_5649_7119# a_5190_7439# 0.01157f
C2117 a_5190_5487# _41_.X 0.15438f
C2118 _69_.LO _25_.A 0
C2119 _41_.C1 a_4369_6351# 0.00881f
C2120 a_2533_2223# u_loop.u_d1.X 0.0136f
C2121 _39_.B2 _49_.Y 0.00325f
C2122 a_2603_8213# a_3083_9537# 0
C2123 VPWR a_2742_8029# 0
C2124 a_6633_2767# a_6397_2767# 0.22264f
C2125 u_loop.u_gh.C a_5989_8751# 0.06326f
C2126 _41_.B1 a_4769_4175# 0
C2127 a_5377_5487# a_5389_5737# 0
C2128 _39_.B2 a_5085_9269# 0.0228f
C2129 a_4075_6825# _40_.B 0
C2130 _42_.Y a_7429_4221# 0
C2131 _64_.D _53_.Y 0
C2132 a_2595_4636# _28_.A 0
C2133 _38_.X a_2769_8213# 0
C2134 a_6449_7663# a_6339_8751# 0
C2135 a_7061_7663# u_loop.u_gh.C 0.0025f
C2136 _55_.Q a_7093_5487# 0
C2137 _32_.A _67_.D 0.1411f
C2138 _36_.A a_5377_5487# 0.05841f
C2139 VPWR a_2400_4667# 0.59693f
C2140 a_7553_7125# _70_.LO 0
C2141 a_4075_6825# src[1] 0.0437f
C2142 pre _27_.Y 0
C2143 _56_.Q _32_.A 0.006f
C2144 a_3549_9661# a_3044_9411# 0
C2145 a_2143_6037# _64_.Q 0.01063f
C2146 u_loop.u_d0.A a_2526_4765# 0
C2147 VPWR a_4076_3561# 0.78147f
C2148 VPWR a_7903_5321# 0.20739f
C2149 a_5190_5487# u_loop.u_d0.A 0
C2150 a_2400_4667# a_2401_4949# 0.00431f
C2151 VPWR a_5786_9661# 0
C2152 _64_.D src[1] 0
C2153 u_loop.u_d0.A prenh 0.79427f
C2154 a_4517_9301# a_4867_9673# 0.21971f
C2155 a_8086_4221# _55_.D 0
C2156 a_8822_7485# xa 0
C2157 a_3384_9295# u_loop.u_gh.C 0.01836f
C2158 _28_.A a_3224_6409# 0
C2159 _48_.Y a_5989_8751# 0
C2160 _55_.CLK _55_.D 0.00679f
C2161 _36_.A a_5649_5737# 0.00124f
C2162 u_loop.u_gh.C a_8165_7485# 0.00399f
C2163 _63_.Q _40_.B 0
C2164 a_8121_7093# a_7999_7497# 0
C2165 _36_.A a_6375_6037# 0
C2166 a_3670_5309# _36_.A 0
C2167 _55_.CLK _56_.D 0.01219f
C2168 _41_.B1 a_3992_7235# 0
C2169 a_1835_4373# _53_.Y 0.02313f
C2170 a_3549_9661# a_3239_9269# 0.01379f
C2171 _63_.Q src[1] 0
C2172 u_loop.u_d4.X u_loop.u_d1.X 0
C2173 a_2769_8213# _40_.B 0.02685f
C2174 a_4439_2767# u_loop.u_d1.X 0
C2175 a_5529_4399# a_5190_5487# 0
C2176 _64_.D a_1582_6575# 0
C2177 a_4975_9295# a_4351_9301# 0
C2178 _36_.A _28_.A 0
C2179 a_2603_8213# _63_.Q 0.16514f
C2180 a_7387_4949# _25_.A 0.34681f
C2181 a_2769_8213# src[1] 0
C2182 a_7631_6335# a_6541_6037# 0.04251f
C2183 u_loop.u_d0.A a_4769_4175# 0.06047f
C2184 _41_.B1 a_4032_7351# 0
C2185 u_loop.u_gh.C xa 0.00355f
C2186 a_7364_7663# xa 0
C2187 a_6444_4399# u_loop.u_s2.Y 0
C2188 a_2603_8213# a_2769_8213# 0.89658f
C2189 _64_.Q a_1665_7663# 0.00215f
C2190 a_4333_2767# u_loop.u_d1.X 0
C2191 u_loop.u_d7.X a_7072_4221# 0
C2192 a_7631_6335# a_7661_5729# 0.00902f
C2193 a_6397_2767# a_5363_4399# 0
C2194 _28_.A a_2122_4651# 0.0034f
C2195 _42_.Y a_6651_3861# 0
C2196 VPWR a_2526_4765# 0.22545f
C2197 _27_.Y a_3158_4765# 0.17009f
C2198 a_7631_6335# u_loop.u_gh.C 0.28433f
C2199 a_6927_5487# a_7732_4233# 0
C2200 VPWR a_5190_5487# 0.58099f
C2201 a_3337_8181# _62_.D 0
C2202 a_7387_4949# a_6817_3861# 0
C2203 a_7348_5487# a_7443_5487# 0.04983f
C2204 _39_.B2 a_6244_8751# 0
C2205 VPWR prenh 1.58546f
C2206 a_4351_4175# u_loop.u_gh.C 0.20324f
C2207 _38_.X u_loop.u_gh.C 0.00795f
C2208 _55_.CLK a_6798_4399# 0
C2209 a_2526_4765# a_2401_4949# 0
C2210 a_6375_6037# xb 0
C2211 _55_.Q _25_.Y 0.10504f
C2212 u_loop.u_d4.X u_loop.u_gh.B 0.00116f
C2213 _56_.Q a_8121_4917# 0
C2214 a_8468_5321# a_8630_4943# 0.00645f
C2215 VPWR a_5293_7439# 0.00297f
C2216 a_6799_7663# a_6375_6037# 0
C2217 a_6619_4373# _55_.D 0.0092f
C2218 a_6651_3861# a_7275_3855# 0
C2219 a_7553_7125# xa 0
C2220 a_6449_7663# a_6541_6037# 0
C2221 u_loop.u_q.B u_loop.u_s2.Y 0.45652f
C2222 a_3044_9411# _30_.Y 0.27225f
C2223 _56_.Q a_6444_4399# 0.04048f
C2224 a_1499_7663# a_2755_7637# 0.04359f
C2225 _53_.Y a_2833_4399# 0
C2226 a_6619_4373# _56_.D 0
C2227 en src[1] 0.22413f
C2228 u_loop.u_d4.X u_loop.u_gl.A2 0.00341f
C2229 u_loop.u_gl.A2 a_4439_2767# 0
C2230 a_7553_7125# a_7631_6335# 0
C2231 a_2309_6037# a_3333_6409# 0
C2232 _36_.A _56_.D 0
C2233 _62_.D a_3119_8585# 0.01321f
C2234 _30_.Y _49_.Y 0.15349f
C2235 a_7093_5487# a_6541_6037# 0.00195f
C2236 a_5594_9295# a_5085_9269# 0
C2237 a_8468_7497# xb 0.00171f
C2238 u_loop.u_d6.X u_loop.u_s2.Y 0.01659f
C2239 u_loop.u_gh.C _53_.Y 0.10058f
C2240 VPWR a_1845_6825# 0.00806f
C2241 VPWR a_4769_4175# 0.00908f
C2242 a_6449_7663# u_loop.u_gh.C 0.06203f
C2243 a_6449_7663# a_7364_7663# 0.12532f
C2244 _62_.D a_3170_9295# 0
C2245 a_6375_6037# a_7017_7905# 0
C2246 u_loop.u_gh.C _40_.B 0.33037f
C2247 u_loop.u_gl.A2 a_4333_2767# 0.01009f
C2248 a_7079_8725# a_6904_8751# 0.23366f
C2249 a_7093_5487# a_7661_5729# 0.18639f
C2250 a_7093_5487# u_loop.u_gh.C 0.06193f
C2251 a_6927_5487# a_8183_5461# 0.04359f
C2252 a_7167_4233# a_7553_4949# 0
C2253 en a_1582_6575# 0.00134f
C2254 a_2479_9269# _62_.D 0
C2255 _30_.Y a_3239_9269# 0.00268f
C2256 _50_.Y _40_.B 0
C2257 a_1499_7663# _52_.Y 0
C2258 a_2400_4667# a_2751_5321# 0.00117f
C2259 u_loop.u_gh.C src[1] 0.05057f
C2260 a_2400_4667# a_2740_4765# 0.03462f
C2261 _55_.Q a_7443_5487# 0
C2262 _45_.A a_4160_6575# 0
C2263 a_2603_8213# u_loop.u_gh.C 0.33156f
C2264 a_4833_2767# a_5069_2767# 0.22264f
C2265 _55_.CLK a_7387_4949# 0
C2266 a_4518_6825# _36_.A 0
C2267 _50_.Y src[1] 0
C2268 a_6619_4373# a_6798_4399# 0.0074f
C2269 u_loop.u_gl.A2 u_loop.u_s2.A 0
C2270 u_loop.u_d4.X a_4097_2767# 0
C2271 a_7456_6409# _67_.D 0.06297f
C2272 a_4439_2767# a_4097_2767# 0.00188f
C2273 a_2603_8213# _50_.Y 0.24742f
C2274 a_2875_2223# prenl 0.00101f
C2275 _56_.CLK _41_.C1 0
C2276 _48_.Y _40_.B 0.00257f
C2277 _39_.B2 a_4351_9301# 0.00442f
C2278 a_7539_7637# a_6541_6037# 0
C2279 u_loop.u_gh.C a_1582_6575# 0
C2280 a_7631_6335# a_7551_5853# 0
C2281 VPWR a_3992_7235# 0.11848f
C2282 a_5879_4399# u_loop.u_s2.Y 0.00194f
C2283 a_4097_2767# a_4333_2767# 0.22264f
C2284 VPWR a_7553_4949# 0.57822f
C2285 _21_.Y a_5293_7439# 0
C2286 a_7093_5487# a_7109_6005# 0.00231f
C2287 _38_.X a_3430_7235# 0
C2288 a_7631_6335# _25_.A 0
C2289 a_2439_4541# a_3158_4765# 0.08341f
C2290 a_5987_4765# a_5879_4399# 0.05722f
C2291 a_8121_4917# a_7999_5321# 0
C2292 a_6557_8993# a_5989_8751# 0.18639f
C2293 a_3083_9537# a_3119_8585# 0
C2294 a_7539_7637# u_loop.u_gh.C 0.30224f
C2295 a_7539_7637# a_7364_7663# 0.23366f
C2296 a_6999_6031# a_6375_6037# 0
C2297 a_1499_7663# a_1499_6575# 0
C2298 _57_.CLK a_7631_6335# 0
C2299 VPWR a_4032_7351# 0.24171f
C2300 _55_.Q a_7385_3829# 0.00493f
C2301 a_3083_9537# a_3170_9295# 0.07009f
C2302 _64_.D a_2015_7663# 0
C2303 prenh a_5363_4399# 0
C2304 _56_.CLK a_5377_5487# 0.00862f
C2305 _69_.LO xb 0.00241f
C2306 _45_.A a_6704_7663# 0.02535f
C2307 _30_.A a_3992_7235# 0
C2308 VPWR a_2123_8029# 0.15172f
C2309 a_2111_7663# a_1665_7663# 0
C2310 _41_.B1 a_3388_7351# 0
C2311 a_2479_9269# a_3083_9537# 0.04359f
C2312 _45_.A a_7473_7663# 0
C2313 a_6457_2473# u_loop.u_q.B 0
C2314 a_2751_5321# a_2526_4765# 0
C2315 a_2526_4765# a_2740_4765# 0.09774f
C2316 a_7841_4233# a_7732_4233# 0.00742f
C2317 _56_.Q a_5879_4399# 0
C2318 _63_.Q a_3337_8181# 0.0013f
C2319 _22_.Y a_6704_7663# 0.15942f
C2320 a_1654_6575# a_1499_6575# 0.03438f
C2321 _25_.Y a_7661_5729# 0.00328f
C2322 u_loop.u_d0.A a_3597_2767# 0.09272f
C2323 a_2309_6037# _27_.Y 0
C2324 a_2015_7663# _63_.Q 0.00578f
C2325 _25_.Y u_loop.u_gh.C 0.01827f
C2326 a_4032_7351# _30_.A 0
C2327 a_7553_7125# a_7539_7637# 0.00866f
C2328 a_7072_4221# _55_.D 0.16945f
C2329 a_6927_5487# _32_.A 0.0046f
C2330 a_3491_5247# _64_.Q 0
C2331 a_2769_8213# a_3337_8181# 0.18639f
C2332 a_3597_2767# a_3361_2767# 0.22264f
C2333 a_2625_2767# a_2769_2223# 0.00402f
C2334 a_7903_5321# a_8011_4943# 0.05722f
C2335 a_2231_2767# _53_.Y 0
C2336 a_7093_5487# a_7551_5853# 0.03462f
C2337 a_8121_7093# _32_.A 0
C2338 VPWR _46_.Y 0.47196f
C2339 a_4769_4175# a_5363_4399# 0
C2340 a_6449_7663# _57_.CLK 0
C2341 a_3430_7235# src[1] 0.00109f
C2342 a_8643_5247# a_8183_5461# 0.01237f
C2343 _32_.A a_6097_4641# 0
C2344 a_7093_5487# _25_.A 0.03888f
C2345 a_8117_5487# a_8008_5487# 0.00742f
C2346 _22_.Y a_6339_8751# 0
C2347 _63_.Q a_3119_8585# 0.00337f
C2348 _63_.Q a_3227_8207# 0.00166f
C2349 a_2875_2223# u_loop.u_d0.X 0.00404f
C2350 a_4439_2767# u_loop.u_gh.C 0
C2351 _41_.C1 a_3348_7235# 0
C2352 a_6541_6037# a_7443_5487# 0
C2353 VPWR a_6904_8751# 0.3066f
C2354 _57_.CLK src[1] 0
C2355 u_loop.u_gl.A2 a_6141_4399# 0
C2356 a_2769_8213# a_3119_8585# 0.2298f
C2357 a_2309_6037# a_2580_7663# 0
C2358 a_2769_8213# a_3227_8207# 0.03462f
C2359 a_4975_9295# _39_.B2 0.00365f
C2360 u_loop.u_d6.X u_loop.u_d5.X 0.00342f
C2361 a_4351_4175# prenl 0
C2362 a_2479_9269# _63_.Q 0
C2363 a_3399_6335# src[1] 0
C2364 a_7443_5487# a_7661_5729# 0.20964f
C2365 a_2769_8213# a_3170_9295# 0
C2366 u_loop.u_gh.C a_7443_5487# 0.16683f
C2367 a_4333_2767# u_loop.u_gh.C 0.00114f
C2368 a_8121_4917# a_7732_4233# 0
C2369 _56_.Q a_5293_5487# 0.01376f
C2370 u_loop.u_d1.X a_3158_4765# 0
C2371 a_2400_4667# _27_.Y 0.73736f
C2372 src[0] a_2659_6409# 0
C2373 a_2755_7637# _64_.Q 0
C2374 a_3477_9661# a_3170_9295# 0
C2375 VPWR a_3597_2767# 0.29479f
C2376 _55_.CLK a_4351_4175# 0
C2377 a_2479_9269# a_2769_8213# 0
C2378 VPWR a_8630_7119# 0
C2379 a_3083_9537# a_4517_9301# 0.00133f
C2380 u_loop.u_gh.C u_loop.u_s2.A 0
C2381 a_2157_4399# _53_.Y 0
C2382 _64_.D pre 0
C2383 a_7618_6031# a_6541_6037# 0
C2384 a_4351_9301# _30_.Y 0
C2385 a_2143_6037# a_2755_7637# 0
C2386 _42_.Y a_6375_6037# 0
C2387 _56_.Q _41_.B1 0.12303f
C2388 a_2742_8029# a_2580_7663# 0.00645f
C2389 a_7903_7497# u_loop.u_gh.C 0.19333f
C2390 _56_.CLK _56_.D 0.20783f
C2391 _46_.A _46_.Y 0.25579f
C2392 _20_.Y src[1] 0.04588f
C2393 a_5784_4399# a_5879_4399# 0.04983f
C2394 _53_.A a_1889_2767# 0
C2395 a_6927_5487# a_8121_4917# 0.00104f
C2396 a_2766_9427# _40_.B 0
C2397 a_3337_8181# u_loop.u_gh.C 0.18824f
C2398 _62_.D src[0] 0
C2399 a_7553_7125# a_7443_5487# 0
C2400 a_7618_6031# u_loop.u_gh.C 0
C2401 _64_.Q _52_.Y 0
C2402 u_loop.u_d4.X a_4833_2767# 0.37357f
C2403 VPWR a_8630_4943# 0
C2404 a_6739_2767# a_6397_2767# 0.00188f
C2405 a_6557_8993# a_6449_7663# 0
C2406 a_3703_2767# u_loop.u_d0.A 0.06716f
C2407 a_2015_7663# u_loop.u_gh.C 0.15422f
C2408 a_7551_5853# _25_.Y 0
C2409 a_3337_8181# _50_.Y 0
C2410 a_6799_7663# a_5989_8751# 0
C2411 a_3703_2767# a_3361_2767# 0.00188f
C2412 u_loop.u_gh.C a_7385_3829# 0.16827f
C2413 a_2015_7663# _50_.Y 0
C2414 _39_.X a_6541_6037# 0
C2415 _25_.Y _25_.A 0.17442f
C2416 _69_.LO a_8008_5487# 0.00388f
C2417 a_2143_6037# _52_.Y 0.40867f
C2418 a_2603_8213# a_2766_9427# 0
C2419 src[0] a_4160_6575# 0.46735f
C2420 _46_.A a_6904_8751# 0.04243f
C2421 a_7907_4159# a_7732_4233# 0.23366f
C2422 a_3381_8573# a_3337_8181# 0
C2423 a_2235_4949# _64_.Q 0
C2424 u_loop.u_d0.A u_loop.u_s2.Y 0.43048f
C2425 _41_.X _67_.D 0.00931f
C2426 _20_.Y a_1582_6575# 0
C2427 a_8121_4917# a_8183_5461# 0
C2428 a_6444_4399# a_6097_4641# 0.05116f
C2429 VPWR a_3388_7351# 0.20597f
C2430 a_4833_2767# a_4333_2767# 0
C2431 _45_.A a_6541_6037# 0
C2432 a_7061_7663# a_6799_7663# 0.00171f
C2433 _56_.Q _41_.X 0.00244f
C2434 _64_.Q _28_.Y 0
C2435 a_2595_4636# _53_.Y 0.00405f
C2436 a_5911_2767# u_loop.u_gh.C 0
C2437 u_loop.u_gl.A2 a_3158_4765# 0
C2438 pre a_1835_4373# 0
C2439 a_6987_6409# a_6541_6037# 0
C2440 a_7553_7125# a_7903_7497# 0.2298f
C2441 a_3119_8585# u_loop.u_gh.C 0.16711f
C2442 _39_.X u_loop.u_gh.C 0.03422f
C2443 u_loop.u_gh.C a_3227_8207# 0.01792f
C2444 _39_.X a_7364_7663# 0
C2445 _27_.Y a_2526_4765# 0.04303f
C2446 a_2143_6037# a_2235_4949# 0
C2447 a_7263_4233# a_7385_3829# 0
C2448 a_2755_7637# a_1665_7663# 0.04251f
C2449 _25_.Y a_6817_3861# 0
C2450 a_3119_8585# _50_.Y 0
C2451 _36_.A a_5377_7439# 0.05679f
C2452 _45_.A u_loop.u_gh.C 0.56418f
C2453 a_2143_6037# _28_.Y 0
C2454 _45_.A a_7364_7663# 0.03876f
C2455 u_loop.u_gh.C a_3170_9295# 0.17722f
C2456 _36_.A a_4351_4175# 0
C2457 _36_.A _38_.X 0
C2458 a_7618_6031# a_7109_6005# 0
C2459 a_6987_6409# u_loop.u_gh.C 0.00152f
C2460 src[0] a_2564_6397# 0
C2461 a_5529_4399# u_loop.u_s2.Y 0
C2462 a_1499_6575# _64_.Q 0.0412f
C2463 a_6927_5487# a_7907_4159# 0
C2464 a_3381_8573# a_3119_8585# 0.00171f
C2465 a_2479_9269# u_loop.u_gh.C 0.28053f
C2466 _22_.Y u_loop.u_gh.C 0.03404f
C2467 _31_.Y _46_.Y 0
C2468 _42_.Y _55_.D 0.05326f
C2469 a_2309_6037# a_2659_6409# 0.2298f
C2470 a_7093_5487# a_8170_5853# 0
C2471 a_7551_5853# a_7443_5487# 0.05722f
C2472 a_7061_7663# a_7017_7905# 0
C2473 _32_.Y a_6375_6037# 0.28318f
C2474 a_5529_4399# a_5987_4765# 0.03462f
C2475 a_2479_9269# _50_.Y 0
C2476 a_6927_5487# a_7456_6409# 0
C2477 VPWR a_3703_2767# 0.19068f
C2478 a_6283_7663# _46_.Y 0.24955f
C2479 _42_.Y _56_.D 0
C2480 _46_.Y a_5823_8751# 0.00158f
C2481 a_7443_5487# _25_.A 0.03605f
C2482 a_2143_6037# a_1499_6575# 0
C2483 en pre 0.17169f
C2484 a_7553_7125# _39_.X 0.00196f
C2485 a_1665_7663# _52_.Y 0
C2486 _41_.C1 a_4158_7235# 0
C2487 a_7553_4949# a_8011_4943# 0.03462f
C2488 u_loop.u_d7.X a_6651_3861# 0
C2489 a_2400_4667# a_2439_4541# 0.60605f
C2490 xb xa 0
C2491 a_2969_4917# _28_.A 0.02237f
C2492 _31_.Y a_6904_8751# 0
C2493 a_3224_6409# src[1] 0
C2494 a_7553_7125# _45_.A 0
C2495 a_7167_4233# _67_.D 0
C2496 VPWR u_loop.u_s2.Y 0.7085f
C2497 a_3384_9295# a_3044_9411# 0.02761f
C2498 a_3388_7351# a_3514_7235# 0.00462f
C2499 _25_.Y a_7705_5487# 0
C2500 a_2656_5309# a_2143_6037# 0
C2501 VPWR a_3859_8511# 0.41009f
C2502 a_7387_4949# a_8008_5487# 0
C2503 a_6904_8751# a_5823_8751# 0.10236f
C2504 a_7631_6335# xb 0.00101f
C2505 _36_.A _40_.B 0
C2506 u_loop.u_gh.C a_6141_4399# 0.00316f
C2507 u_loop.u_cmp.Y prenh 0.0045f
C2508 a_1920_7663# a_2015_7663# 0.04983f
C2509 _56_.Q a_5529_4399# 0.00627f
C2510 a_7553_7125# _22_.Y 0
C2511 a_6987_6409# a_7109_6005# 0
C2512 VPWR a_5987_4765# 0.15772f
C2513 u_loop.u_d0.A a_1889_2767# 0.32319f
C2514 a_4075_6825# src[0] 0.18307f
C2515 a_2859_4943# _53_.Y 0
C2516 a_7093_5487# _36_.A 0
C2517 a_2861_2767# u_loop.u_d0.A 0.06742f
C2518 a_7903_7497# _25_.A 0
C2519 _36_.A src[1] 0.15732f
C2520 a_2122_4651# _53_.Y 0.02791f
C2521 pre u_loop.u_gh.C 0
C2522 a_2861_2767# a_3361_2767# 0
C2523 _64_.D src[0] 0.02909f
C2524 a_4369_6351# src[1] 0.14991f
C2525 VPWR a_1499_7663# 0.50444f
C2526 _55_.CLK _25_.Y 0
C2527 a_4167_6147# a_4160_6575# 0
C2528 a_6633_2767# u_loop.u_s2.Y 0.02505f
C2529 a_2400_4667# a_2659_6409# 0
C2530 a_3384_9295# a_3239_9269# 0.05722f
C2531 _30_.A a_3859_8511# 0.00481f
C2532 VPWR _67_.D 0.6829f
C2533 a_2125_2767# _53_.Y 0
C2534 VPWR _56_.Q 1.37517f
C2535 a_1499_6575# a_1665_7663# 0
C2536 a_6457_2473# u_loop.u_d0.A 0.01216f
C2537 a_2877_6005# _28_.A 0
C2538 u_loop.u_d4.X prenl 0.00699f
C2539 a_4439_2767# prenl 0.0268f
C2540 a_7387_7125# a_6375_6037# 0.00109f
C2541 u_loop.u_gh.C a_5607_9599# 0.34149f
C2542 a_5879_4399# a_6097_4641# 0.20964f
C2543 _63_.Q src[0] 0
C2544 VPWR a_1654_6575# 0.00365f
C2545 a_7443_5487# a_7705_5487# 0.00171f
C2546 a_2309_6037# a_2564_6397# 0.06418f
C2547 VPWR a_3802_9295# 0.07842f
C2548 a_4517_9301# u_loop.u_gh.C 0.05444f
C2549 a_2934_7663# a_2755_7637# 0.0074f
C2550 a_6449_7663# a_6799_7663# 0.2298f
C2551 a_8468_5321# a_8183_5461# 0
C2552 a_2439_4541# a_2526_4765# 0.05348f
C2553 _68_.D _67_.D 0
C2554 a_6817_3861# a_7385_3829# 0.18639f
C2555 _63_.D src[1] 0.00134f
C2556 a_7093_5487# xb 0
C2557 _45_.A _25_.A 0
C2558 _39_.X _57_.CLK 0
C2559 a_4333_2767# prenl 0.03474f
C2560 a_2533_2223# u_loop.u_d0.X 0.29952f
C2561 _41_.B1 _64_.Q 0
C2562 a_3597_2767# u_loop.u_d2.X 0.00315f
C2563 _55_.D a_7429_4221# 0
C2564 VPWR a_1889_2767# 0.37115f
C2565 a_5989_8751# a_6244_8751# 0.06418f
C2566 a_2603_8213# _63_.D 0
C2567 VPWR a_2861_2767# 0.28584f
C2568 a_5989_8751# a_6435_8751# 0
C2569 a_8468_7497# a_7387_7125# 0.10236f
C2570 a_2921_6397# a_2877_6005# 0
C2571 _45_.A _57_.CLK 0.2055f
C2572 a_6987_6409# _57_.CLK 0
C2573 _39_.B2 _41_.C1 0.00625f
C2574 u_loop.u_d0.A u_loop.u_d5.X 0.04324f
C2575 a_3802_9295# _30_.A 0.01644f
C2576 u_loop.u_d7.X a_5175_2767# 0
C2577 u_loop.u_gh.C a_3158_4765# 0.02626f
C2578 prenl u_loop.u_s2.A 0
C2579 _22_.Y _57_.CLK 0
C2580 _42_.Y a_7387_4949# 0.25386f
C2581 a_6891_6409# _67_.D 0.02094f
C2582 a_6619_4373# _25_.Y 0
C2583 a_6449_7663# a_7017_7905# 0.18639f
C2584 _48_.Y a_4517_9301# 0.00848f
C2585 a_7456_6409# _32_.A 0.04048f
C2586 a_2526_4765# a_2659_6409# 0
C2587 a_7810_6397# a_7631_6335# 0.0074f
C2588 VPWR a_6457_2473# 0.00457f
C2589 a_5529_4399# a_5784_4399# 0.06418f
C2590 a_3044_9411# _40_.B 0.00328f
C2591 a_4167_6147# a_4075_6825# 0
C2592 a_1920_7663# pre 0
C2593 a_5594_9295# _39_.B2 0
C2594 en src[0] 0.09468f
C2595 a_2309_6037# _64_.D 0.21461f
C2596 u_loop.u_s2.Y a_5363_4399# 0
C2597 _39_.B2 _30_.Y 0
C2598 _49_.Y _40_.B 0.27911f
C2599 a_7387_4949# a_7275_3855# 0
C2600 a_5805_2767# u_loop.u_s2.A 0.01109f
C2601 a_2603_8213# a_3044_9411# 0.00221f
C2602 a_6381_3561# prenh 0
C2603 a_5987_4765# a_5363_4399# 0
C2604 _49_.Y src[1] 0.0016f
C2605 a_2400_4667# u_loop.u_gh.B 0
C2606 _55_.CLK a_7385_3829# 0
C2607 a_7631_6335# a_8008_5487# 0.0015f
C2608 VPWR a_5784_4399# 0.08579f
C2609 _56_.Q a_5649_7119# 0
C2610 a_2603_8213# _49_.Y 0
C2611 a_8643_5247# a_8468_5321# 0.23366f
C2612 a_3239_9269# _40_.B 0.00395f
C2613 a_3802_9295# _21_.Y 0
C2614 u_loop.u_gh.B a_4076_3561# 0.00155f
C2615 a_2766_9427# a_3170_9295# 0.05116f
C2616 VPWR a_3684_8585# 0.29437f
C2617 u_loop.u_gh.C src[0] 0.12242f
C2618 a_6651_3861# _55_.D 0.32597f
C2619 _41_.C1 a_4518_6575# 0.0017f
C2620 VPWR u_loop.u_d5.X 0.26601f
C2621 u_loop.u_gl.A2 a_2400_4667# 0
C2622 a_2479_9269# a_2766_9427# 0.23366f
C2623 _32_.A a_5879_4399# 0
C2624 VPWR a_7808_5309# 0.08228f
C2625 _56_.Q a_5363_4399# 0.00502f
C2626 u_loop.u_gl.A2 a_4076_3561# 0.36795f
C2627 _53_.A a_2397_4399# 0
C2628 a_2309_6037# a_1835_4373# 0
C2629 a_2603_8213# a_3239_9269# 0
C2630 a_3491_5247# a_3316_5321# 0.23366f
C2631 a_6927_5487# _41_.X 0.24529f
C2632 a_6375_6037# a_7565_6409# 0
C2633 u_loop.u_gh.C a_6606_4765# 0
C2634 a_3703_2767# u_loop.u_d2.X 0
C2635 _22_.Y a_6557_8993# 0
C2636 a_5432_9673# _47_.Y 0.00343f
C2637 a_5805_2767# a_5911_2767# 0.41909f
C2638 a_2235_4949# a_3491_5247# 0.04359f
C2639 a_8121_4917# a_7907_4159# 0
C2640 _55_.Q a_7903_5321# 0
C2641 a_3684_8585# _30_.A 0.00555f
C2642 a_6283_7663# _67_.D 0
C2643 a_2742_8029# _63_.Q 0
C2644 _48_.Y src[0] 0
C2645 a_7167_4233# a_7732_4233# 0
C2646 pre _20_.Y 0.20787f
C2647 u_loop.u_d7.X x 0
C2648 a_7093_5487# a_8008_5487# 0.12532f
C2649 VPWR _64_.Q 2.59827f
C2650 _68_.D a_7999_7497# 0.00146f
C2651 a_7093_5487# _56_.CLK 0
C2652 xb a_7443_5487# 0
C2653 a_2861_2767# a_2967_2767# 0.41909f
C2654 _55_.CLK a_6141_4399# 0
C2655 u_loop.u_gh.B prenh 0.21871f
C2656 u_loop.u_d0.A a_6097_4641# 0
C2657 a_7808_7485# a_7999_7497# 0
C2658 a_5569_2767# u_loop.u_d5.X 0.37578f
C2659 _64_.Q a_2401_4949# 0
C2660 _41_.C1 a_5377_5487# 0
C2661 u_loop.u_gl.B1 a_4510_3311# 0
C2662 VPWR a_2143_6037# 0.48056f
C2663 _42_.Y a_7631_6335# 0
C2664 a_2400_4667# a_1835_4373# 0.04251f
C2665 a_7167_4233# a_6927_5487# 0
C2666 VPWR a_7732_4233# 0.30183f
C2667 _36_.A _39_.X 0.01059f
C2668 u_loop.u_gl.A2 prenh 0.27451f
C2669 a_3597_2767# u_loop.u_d3.X 0.01908f
C2670 a_2143_6037# a_2401_4949# 0
C2671 a_2015_7663# a_2233_7905# 0.20964f
C2672 _51_.Y src[1] 0.29419f
C2673 u_loop.u_d6.X u_loop.u_q.B 0.03612f
C2674 a_2875_2223# a_2769_2223# 0.41909f
C2675 a_8468_5321# a_8121_4917# 0.05116f
C2676 _36_.A _45_.A 0.11917f
C2677 a_5975_4399# a_5784_4399# 0
C2678 a_1920_7663# src[0] 0
C2679 a_2309_6037# u_loop.u_gh.C 0.05105f
C2680 _63_.D a_3337_8181# 0
C2681 a_7539_5487# a_6927_5487# 0
C2682 _38_.X a_3348_7235# 0.10654f
C2683 a_5529_4399# a_6097_4641# 0.18639f
C2684 a_4167_6147# u_loop.u_gh.C 0.00162f
C2685 a_2015_7663# _63_.D 0.00394f
C2686 _41_.B1 _32_.A 0
C2687 src[0] a_3430_7235# 0
C2688 a_7618_6031# xb 0
C2689 a_3024_8573# _40_.B 0
C2690 a_6553_4399# _55_.D 0
C2691 u_loop.u_gh.C a_6397_2767# 0
C2692 _36_.A _22_.Y 0
C2693 a_6444_4399# a_5879_4399# 0
C2694 u_loop.u_gh.B a_4769_4175# 0.03277f
C2695 a_4160_6575# a_3992_7235# 0
C2696 a_5784_4399# a_5363_4399# 0.08638f
C2697 a_2235_4949# _52_.Y 0
C2698 VPWR a_6927_5487# 0.46942f
C2699 a_3316_5321# a_3425_5321# 0.00742f
C2700 a_2861_2767# u_loop.u_d2.X 0.01641f
C2701 _28_.Y _52_.Y 0
C2702 _64_.Q a_3514_7235# 0
C2703 VPWR a_8121_7093# 0.21256f
C2704 _57_.CLK src[0] 0
C2705 u_loop.u_d5.X a_5363_4399# 0
C2706 a_2235_4949# a_3316_5321# 0.10236f
C2707 a_2603_8213# a_3024_8573# 0.08638f
C2708 a_2235_4949# a_3425_5321# 0
C2709 a_6651_3861# a_7387_4949# 0
C2710 u_loop.u_gl.A2 a_4769_4175# 0.014f
C2711 a_4032_7351# a_4160_6575# 0
C2712 a_2309_6037# a_2767_6031# 0.03462f
C2713 VPWR a_6097_4641# 0.23432f
C2714 _63_.D a_3119_8585# 0
C2715 _63_.D a_3227_8207# 0
C2716 VPWR a_1665_7663# 0.64408f
C2717 src[0] a_3399_6335# 0.01239f
C2718 _32_.A _41_.X 0.13347f
C2719 a_2742_8029# u_loop.u_gh.C 0
C2720 a_7093_5487# _42_.Y 0
C2721 a_2235_4949# _28_.Y 0.28344f
C2722 a_2479_9269# a_2233_7905# 0
C2723 _39_.X a_6799_7663# 0
C2724 VPWR a_8183_5461# 0.41558f
C2725 a_3348_7235# _40_.B 0.00373f
C2726 a_1499_6575# _52_.Y 0
C2727 u_loop.u_d7.X _55_.D 0
C2728 a_2356_4765# _53_.Y 0
C2729 a_2755_6409# a_2659_6409# 0.01379f
C2730 u_loop.u_q.B a_5879_4399# 0
C2731 _68_.D a_8121_7093# 0.00206f
C2732 _45_.A a_6799_7663# 0.03585f
C2733 a_2400_4667# u_loop.u_gh.C 0.09381f
C2734 a_3348_7235# src[1] 0.20438f
C2735 u_loop.u_d6.X a_5879_4399# 0
C2736 a_4076_3561# u_loop.u_gh.C 0.00217f
C2737 a_7903_5321# u_loop.u_gh.C 0.18707f
C2738 _22_.Y a_6799_7663# 0.00149f
C2739 a_2603_8213# a_3348_7235# 0.00109f
C2740 a_5786_9661# u_loop.u_gh.C 0.00288f
C2741 a_2595_4636# a_3158_4765# 0.04983f
C2742 _20_.Y src[0] 0.00684f
C2743 a_6891_6409# a_6927_5487# 0.001f
C2744 _39_.X a_7017_7905# 0
C2745 a_6796_6397# _67_.D 0.0016f
C2746 VPWR a_2397_4399# 0
C2747 a_3337_8181# a_3239_9269# 0
C2748 u_loop.u_cmp.Y u_loop.u_s2.Y 0.05302f
C2749 a_3044_9411# a_3119_8585# 0
C2750 a_3670_5309# _28_.A 0.00198f
C2751 a_2656_5309# a_2235_4949# 0.08968f
C2752 a_3703_2767# u_loop.u_d3.X 0.1513f
C2753 _45_.A a_7017_7905# 0.02203f
C2754 a_4075_6825# a_3992_7235# 0
C2755 a_2656_5309# _28_.Y 0.1576f
C2756 a_8008_5487# a_7443_5487# 0
C2757 a_3044_9411# a_3170_9295# 0.18122f
C2758 _55_.Q a_7553_4949# 0
C2759 a_3119_8585# _49_.Y 0
C2760 a_2969_4917# _53_.Y 0
C2761 VPWR a_2111_7663# 0.00524f
C2762 _22_.Y a_7017_7905# 0
C2763 a_1499_7663# a_2580_7663# 0.10236f
C2764 _63_.D pre 0
C2765 _56_.CLK a_7443_5487# 0
C2766 a_5529_4399# _32_.A 0
C2767 a_2479_9269# a_3044_9411# 0.04251f
C2768 _49_.Y a_3170_9295# 0
C2769 a_4032_7351# a_4075_6825# 0
C2770 a_7387_7125# xa 0
C2771 a_2861_2767# _27_.Y 0
C2772 a_2526_4765# a_2833_4399# 0
C2773 a_5377_5487# _56_.D 0
C2774 a_2015_7663# a_2277_7663# 0.00171f
C2775 a_3239_9269# a_3119_8585# 0
C2776 a_3239_9269# a_3227_8207# 0
C2777 a_6739_2767# u_loop.u_s2.Y 0.01141f
C2778 _32_.Y src[1] 0
C2779 a_4518_6825# _41_.C1 0.01102f
C2780 a_7013_8751# a_6904_8751# 0.00742f
C2781 VPWR a_8643_5247# 0.43844f
C2782 u_loop.u_gh.C a_2526_4765# 0.17297f
C2783 a_7631_6335# a_7387_7125# 0
C2784 a_7903_7497# a_8008_5487# 0
C2785 a_3597_2767# u_loop.u_d1.X 0.00343f
C2786 _42_.Y _25_.Y 0.13041f
C2787 _55_.CLK a_6606_4765# 0
C2788 a_3333_6409# _64_.Q 0
C2789 a_2309_6037# a_3399_6335# 0.04251f
C2790 a_3239_9269# a_3170_9295# 0.20964f
C2791 a_4510_3311# u_loop.u_d0.A 0.05651f
C2792 u_loop.u_gh.C prenh 0.17636f
C2793 _46_.Y a_6704_7663# 0
C2794 a_2755_6409# a_2564_6397# 0
C2795 a_3491_5247# u_loop.u_d0.A 0.00128f
C2796 a_5975_4399# a_6097_4641# 0
C2797 a_4167_6147# a_3399_6335# 0.00364f
C2798 VPWR _32_.A 0.80671f
C2799 _39_.B2 a_5989_8751# 0.00285f
C2800 a_2235_4949# _53_.A 0
C2801 a_2143_6037# a_3333_6409# 0
C2802 a_6097_4641# a_5363_4399# 0.07009f
C2803 a_8121_7093# a_8011_7119# 0.09774f
C2804 _63_.Q a_2123_8029# 0.00287f
C2805 a_2767_6031# a_2526_4765# 0
C2806 a_3224_6409# src[0] 0.00126f
C2807 _68_.D _32_.A 0
C2808 a_2309_6037# _20_.Y 0
C2809 a_2400_4667# a_2231_2767# 0
C2810 _46_.Y a_6339_8751# 0
C2811 a_2015_7663# _51_.Y 0.0016f
C2812 a_6449_7663# a_7387_7125# 0.00174f
C2813 a_1845_6825# u_loop.u_gh.C 0
C2814 u_loop.u_gh.C a_4769_4175# 0.00126f
C2815 a_7903_5321# _25_.A 0.05506f
C2816 _53_.A a_2905_4399# 0
C2817 _42_.Y a_7443_5487# 0
C2818 a_4158_7235# _40_.B 0
C2819 _36_.A src[0] 0.00747f
C2820 a_7093_5487# a_7387_7125# 0
C2821 VPWR a_6447_9117# 0.14318f
C2822 a_4369_6351# src[0] 0.00254f
C2823 a_6339_8751# a_6904_8751# 0
C2824 a_6891_6409# _32_.A 0.03689f
C2825 a_4158_7235# src[1] 0.00358f
C2826 VPWR a_4510_3311# 0.00697f
C2827 a_3044_9411# a_4517_9301# 0.00469f
C2828 VPWR a_3491_5247# 0.45132f
C2829 a_4833_2767# prenh 0.02925f
C2830 a_5529_4399# a_6444_4399# 0.12532f
C2831 a_6381_3561# u_loop.u_s2.Y 0.00181f
C2832 a_4517_9301# _49_.Y 0
C2833 a_2533_2223# a_2769_2223# 0.22264f
C2834 _46_.A _32_.A 0
C2835 _36_.A a_5190_7439# 0.11744f
C2836 a_2479_9269# a_2801_9661# 0.0074f
C2837 a_3491_5247# a_2401_4949# 0.04251f
C2838 VPWR _47_.Y 0.38963f
C2839 a_7553_4949# a_6541_6037# 0
C2840 _55_.CLK a_6397_2767# 0
C2841 a_1499_7663# a_2659_6409# 0
C2842 u_loop.u_q.B u_loop.u_d0.A 0.29417f
C2843 a_4517_9301# a_5085_9269# 0.17402f
C2844 a_7093_5487# a_6651_3861# 0
C2845 _55_.D _56_.D 0
C2846 u_loop.u_cmp.Y a_5784_4399# 0
C2847 VPWR a_8121_4917# 0.21152f
C2848 a_2235_4949# a_2847_5321# 0
C2849 a_2439_4541# a_2861_2767# 0
C2850 a_3703_2767# u_loop.u_d1.X 0.00211f
C2851 u_loop.u_gh.C a_3992_7235# 0
C2852 a_7553_4949# a_7661_5729# 0
C2853 u_loop.u_d6.X u_loop.u_d0.A 0.00602f
C2854 a_3024_8573# a_3119_8585# 0.04983f
C2855 a_7553_4949# u_loop.u_gh.C 0.04268f
C2856 _39_.B2 a_5377_7439# 0.05422f
C2857 _39_.B2 _38_.X 0
C2858 _63_.D src[0] 0
C2859 a_3316_5321# u_loop.u_d0.A 0
C2860 VPWR a_6444_4399# 0.28306f
C2861 _42_.Y a_7385_3829# 0.00121f
C2862 a_5805_2767# a_6397_2767# 0
C2863 a_3337_8181# a_3348_7235# 0
C2864 u_loop.u_cmp.Y u_loop.u_d5.X 0.01365f
C2865 a_6927_5487# a_8011_4943# 0
C2866 a_4097_2767# a_3597_2767# 0
C2867 a_7539_7637# a_7387_7125# 0.00684f
C2868 a_5190_5487# _25_.A 0.15303f
C2869 a_4160_6575# a_3859_8511# 0
C2870 VPWR a_7066_9117# 0
C2871 a_4032_7351# u_loop.u_gh.C 0
C2872 a_5879_4399# _41_.X 0
C2873 a_2479_9269# a_3024_8573# 0
C2874 VPWR a_2755_7637# 0.42391f
C2875 a_2309_6037# a_3224_6409# 0.12532f
C2876 a_7718_7663# a_7539_7637# 0.0074f
C2877 _32_.A a_5363_4399# 0
C2878 a_4076_3561# prenl 0.17421f
C2879 a_7387_4949# a_6375_6037# 0
C2880 a_2123_8029# u_loop.u_gh.C 0.0123f
C2881 a_4167_6147# a_3224_6409# 0
C2882 _46_.A a_6447_9117# 0
C2883 a_7275_3855# a_7385_3829# 0.09774f
C2884 a_8183_5461# a_8011_4943# 0
C2885 a_6798_4399# _55_.D 0
C2886 a_5069_2767# a_5175_2767# 0.41909f
C2887 _48_.Y a_3992_7235# 0
C2888 a_6633_2767# a_6444_4399# 0
C2889 prenh a_6817_3861# 0
C2890 a_3348_7235# a_3119_8585# 0
C2891 a_5541_9673# a_5432_9673# 0.00742f
C2892 _55_.CLK a_7903_5321# 0
C2893 _39_.B2 a_6449_7663# 0
C2894 _21_.Y a_6447_9117# 0
C2895 pre _51_.Y 0
C2896 VPWR u_loop.u_q.B 0.32777f
C2897 a_2656_5309# a_2847_5321# 0
C2898 a_2309_6037# _36_.A 0
C2899 _41_.B1 a_5293_5487# 0.01678f
C2900 _39_.B2 _40_.B 0.04603f
C2901 VPWR a_7907_4159# 0.43216f
C2902 a_2400_4667# a_2595_4636# 0.21963f
C2903 _36_.A a_4167_6147# 0.15317f
C2904 a_6283_7663# _32_.A 0
C2905 a_2755_7637# _30_.A 0
C2906 VPWR _52_.Y 0.60973f
C2907 _46_.A _47_.Y 0
C2908 a_4167_6147# a_4369_6351# 0.05476f
C2909 VPWR a_5432_9673# 0.29853f
C2910 _46_.Y u_loop.u_gh.C 0
C2911 VPWR u_loop.u_d6.X 0.42636f
C2912 a_7364_7663# _46_.Y 0
C2913 VPWR a_7456_6409# 0.29594f
C2914 _39_.B2 src[1] 0
C2915 a_7348_5487# _67_.D 0.16124f
C2916 a_8577_5321# a_7387_4949# 0
C2917 u_loop.u_gl.B1 u_loop.u_d0.A 0.11364f
C2918 a_3083_9537# a_3859_8511# 0
C2919 _21_.Y _47_.Y 0.0056f
C2920 VPWR a_3316_5321# 0.30354f
C2921 VPWR a_2235_4949# 0.51362f
C2922 a_3384_9295# _30_.Y 0
C2923 a_6651_3861# _25_.Y 0
C2924 u_loop.u_gl.A2 u_loop.u_s2.Y 0
C2925 a_2769_8213# a_3388_7351# 0
C2926 a_3316_5321# a_2401_4949# 0.12532f
C2927 _41_.B1 a_5389_7119# 0.00207f
C2928 a_3425_5321# a_2401_4949# 0
C2929 VPWR _28_.Y 0.51104f
C2930 a_2533_2223# a_2625_2767# 0.00377f
C2931 a_3846_8207# _40_.B 0
C2932 u_loop.u_gh.C a_6904_8751# 0.23334f
C2933 a_5529_4399# a_5879_4399# 0.2298f
C2934 _68_.D a_7456_6409# 0
C2935 a_2235_4949# a_2401_4949# 0.9011f
C2936 u_loop.u_d1.X a_1889_2767# 0
C2937 u_loop.u_gh.C a_2755_6409# 0.00507f
C2938 a_2861_2767# u_loop.u_d1.X 0.07636f
C2939 a_6633_2767# u_loop.u_d6.X 0.00315f
C2940 a_4075_6825# a_3859_8511# 0
C2941 a_7808_7485# a_7456_6409# 0
C2942 _28_.Y a_2401_4949# 0.23011f
C2943 prenl prenh 0.26035f
C2944 a_7387_7125# a_7443_5487# 0
C2945 _39_.X _32_.Y 0
C2946 _41_.C1 a_5377_7439# 0
C2947 _41_.C1 a_4351_4175# 0
C2948 _38_.X _41_.C1 0.06541f
C2949 a_7429_4221# a_7385_3829# 0
C2950 a_6447_9117# a_5823_8751# 0
C2951 VPWR a_1499_6575# 0.56415f
C2952 _55_.CLK prenh 0.00103f
C2953 a_7553_4949# _25_.A 0.37262f
C2954 _41_.B1 _41_.X 0
C2955 _45_.A _32_.Y 0
C2956 VPWR a_8468_5321# 0.29679f
C2957 _53_.A u_loop.u_d0.A 0
C2958 a_6891_6409# a_7456_6409# 0
C2959 VPWR a_5879_4399# 0.24003f
C2960 _31_.Y _47_.Y 0.00252f
C2961 u_loop.u_d0.A a_5293_5487# 0
C2962 a_3083_9537# a_3802_9295# 0.08638f
C2963 a_8630_7119# u_loop.u_gh.C 0
C2964 a_4038_8573# u_loop.u_gh.C 0.00288f
C2965 a_2400_4667# a_2859_4943# 0
C2966 a_5569_2767# u_loop.u_d6.X 0
C2967 a_2595_4636# a_2526_4765# 0.20964f
C2968 a_6444_4399# a_5363_4399# 0.10236f
C2969 _22_.Y _32_.Y 0
C2970 a_2580_7663# a_1665_7663# 0.12532f
C2971 a_2742_8029# a_2233_7905# 0
C2972 a_1499_7663# _64_.D 0
C2973 src[1] a_4518_6575# 0.06369f
C2974 VPWR a_2656_5309# 0.08325f
C2975 VPWR u_loop.u_gl.B1 0.66581f
C2976 _55_.Q _67_.D 0
C2977 _47_.Y a_5823_8751# 0.26439f
C2978 a_6651_3861# a_7443_5487# 0
C2979 a_2400_4667# a_2122_4651# 0.12532f
C2980 _55_.Q _56_.Q 0.00227f
C2981 a_7903_7497# a_7387_7125# 0.10748f
C2982 _63_.Q a_3859_8511# 0
C2983 u_loop.u_cmp.Y a_6097_4641# 0
C2984 a_8643_5247# a_8822_5309# 0.0074f
C2985 a_7553_4949# a_6817_3861# 0
C2986 a_2742_8029# _63_.D 0
C2987 a_2656_5309# a_2401_4949# 0.06418f
C2988 _21_.Y a_5432_9673# 0.0021f
C2989 a_2769_8213# a_3859_8511# 0.04176f
C2990 _69_.LO a_7387_4949# 0
C2991 _41_.B1 u_loop.u_d0.A 0
C2992 _55_.CLK a_4769_4175# 0.00107f
C2993 _41_.C1 _40_.B 0.01242f
C2994 VPWR a_4772_9661# 0.08426f
C2995 a_1499_7663# _63_.Q 0.00804f
C2996 a_4351_9301# a_5607_9599# 0.04359f
C2997 _64_.D a_1654_6575# 0.00103f
C2998 a_3684_8585# a_4160_6575# 0
C2999 a_7553_7125# a_8630_7119# 0
C3000 a_7631_6335# a_6375_6037# 0.04348f
C3001 a_2309_6037# a_3386_6031# 0
C3002 _64_.Q a_2659_6409# 0
C3003 a_4351_9301# a_4517_9301# 0.68865f
C3004 _41_.C1 src[1] 0.49847f
C3005 u_loop.u_gh.C a_3388_7351# 0.01817f
C3006 a_5190_5487# a_5389_5737# 0.0129f
C3007 _56_.CLK a_6606_4765# 0
C3008 src[0] _51_.Y 0
C3009 _39_.X a_7387_7125# 0.24822f
C3010 a_3578_6397# _64_.Q 0
C3011 a_8468_7497# xa 0.00246f
C3012 VPWR _53_.A 0.77028f
C3013 a_2143_6037# a_2659_6409# 0.10748f
C3014 _57_.CLK _46_.Y 0
C3015 _36_.A a_5190_5487# 0.12938f
C3016 VPWR a_5293_5487# 0.00397f
C3017 _30_.Y _40_.B 0.01255f
C3018 _45_.A a_7387_7125# 0.00269f
C3019 _36_.A prenh 0.00235f
C3020 a_6651_3861# a_7385_3829# 0.07009f
C3021 a_4772_9661# _30_.A 0
C3022 _62_.D _64_.Q 0
C3023 _22_.Y a_7387_7125# 0
C3024 a_6796_6397# _32_.A 0.02628f
C3025 u_loop.u_gh.B a_5784_4399# 0
C3026 a_7718_7663# _45_.A 0.00198f
C3027 a_3802_9295# a_2769_8213# 0
C3028 a_2122_4651# a_2526_4765# 0.05116f
C3029 u_loop.u_d4.X a_5175_2767# 0
C3030 a_2751_5321# a_3316_5321# 0
C3031 a_6449_7663# a_6375_6037# 0
C3032 _55_.CLK a_7553_4949# 0
C3033 a_5432_9673# a_5823_8751# 0.00118f
C3034 a_3684_8585# a_3083_9537# 0
C3035 a_8121_4917# a_8011_4943# 0.09774f
C3036 VPWR _41_.B1 0.52805f
C3037 a_2235_4949# a_2751_5321# 0.11053f
C3038 _64_.Q a_4160_6575# 0.00459f
C3039 a_2235_4949# a_2740_4765# 0
C3040 VPWR a_5389_7119# 0.00749f
C3041 a_7093_5487# a_5649_5737# 0
C3042 a_5529_4399# _41_.X 0
C3043 VPWR a_7079_8725# 0.45033f
C3044 u_loop.u_gl.A2 a_5784_4399# 0
C3045 a_1499_7663# en 0
C3046 _28_.A _53_.Y 0.0696f
C3047 a_7093_5487# a_6375_6037# 0
C3048 a_2751_5321# _28_.Y 0
C3049 a_5975_4399# a_5879_4399# 0.01379f
C3050 a_4772_9661# a_4963_9673# 0
C3051 a_1835_4373# a_1889_2767# 0
C3052 u_loop.u_gh.C u_loop.u_s2.Y 0
C3053 _36_.A a_4769_4175# 0
C3054 u_loop.u_d0.A a_3361_2767# 0.05034f
C3055 u_loop.u_gh.C a_3859_8511# 0.27755f
C3056 a_1665_7663# a_2659_6409# 0
C3057 a_5879_4399# a_5363_4399# 0.10748f
C3058 a_5987_4765# u_loop.u_gh.C 0.0122f
C3059 a_3684_8585# a_4075_6825# 0
C3060 a_4772_9661# _21_.Y 0.17121f
C3061 _28_.A src[1] 0
C3062 _50_.Y a_3859_8511# 0
C3063 a_3348_7235# src[0] 0.03733f
C3064 a_6541_6037# _67_.D 0.26883f
C3065 a_2439_4541# a_2397_4399# 0
C3066 VPWR _41_.X 0.83078f
C3067 en a_1654_6575# 0.04743f
C3068 _64_.Q a_2564_6397# 0
C3069 a_8117_5487# a_7093_5487# 0
C3070 _56_.Q a_6541_6037# 0
C3071 _55_.Q a_7808_5309# 0
C3072 a_1499_7663# u_loop.u_gh.C 0.29723f
C3073 a_5529_4399# u_loop.u_d0.A 0
C3074 a_8630_4943# _25_.A 0
C3075 a_3793_8585# _40_.B 0
C3076 _20_.Y a_2755_6409# 0
C3077 a_7661_5729# _67_.D 0.00136f
C3078 VPWR a_7526_8029# 0
C3079 a_1499_7663# _50_.Y 0.00406f
C3080 a_4975_9295# a_4517_9301# 0.03462f
C3081 u_loop.u_gh.C _67_.D 0.20345f
C3082 a_2143_6037# a_2564_6397# 0.08561f
C3083 a_2656_5309# a_2751_5321# 0.04983f
C3084 _56_.Q u_loop.u_gh.C 0.08649f
C3085 a_3430_7235# a_3388_7351# 0.00657f
C3086 _48_.Y a_3859_8511# 0.00174f
C3087 a_3337_8181# a_3846_8207# 0
C3088 a_7539_7637# a_6375_6037# 0
C3089 _39_.B2 _39_.X 0.00278f
C3090 a_2603_8213# a_3793_8585# 0
C3091 _69_.LO a_7631_6335# 0
C3092 a_3684_8585# _63_.Q 0
C3093 _36_.A a_3992_7235# 0
C3094 a_2847_5321# a_2401_4949# 0
C3095 a_1654_6575# u_loop.u_gh.C 0.00832f
C3096 _39_.B2 _45_.A 0.03134f
C3097 VPWR u_loop.u_d0.A 2.74317f
C3098 a_3802_9295# u_loop.u_gh.C 0.02003f
C3099 a_4518_6825# _38_.X 0
C3100 a_6557_8993# a_6904_8751# 0.05116f
C3101 a_4369_6351# a_3992_7235# 0
C3102 a_3684_8585# a_2769_8213# 0.12499f
C3103 a_7079_8725# _46_.A 0.16693f
C3104 VPWR a_3361_2767# 0.28764f
C3105 a_6927_5487# a_7348_5487# 0.08638f
C3106 a_4075_6825# _64_.Q 0.00353f
C3107 _22_.Y _39_.B2 0.00338f
C3108 u_loop.u_d7.X u_loop.u_s2.A 0
C3109 a_3388_7351# a_3399_6335# 0
C3110 _36_.A a_4032_7351# 0
C3111 a_7903_5321# a_8008_5487# 0.00135f
C3112 a_7553_7125# _67_.D 0
C3113 a_6891_6409# _41_.X 0
C3114 a_3597_2767# prenl 0.00505f
C3115 a_2861_2767# u_loop.u_gh.C 0
C3116 _64_.D _64_.Q 0.11543f
C3117 VPWR a_7167_4233# 0.2087f
C3118 a_7109_6005# _67_.D 0.0452f
C3119 a_6633_2767# u_loop.u_d0.A 0
C3120 a_8577_7497# a_8121_7093# 0
C3121 VPWR a_5529_4399# 0.54705f
C3122 VPWR a_8643_7423# 0.45571f
C3123 a_5432_9673# a_4867_9673# 0
C3124 _55_.Q a_7732_4233# 0.00278f
C3125 a_3549_9661# a_3170_9295# 0
C3126 a_2143_6037# _64_.D 0.16393f
C3127 VPWR a_3000_9295# 0
C3128 VPWR a_5541_9673# 0
C3129 _41_.B1 a_5363_4399# 0
C3130 _63_.Q _64_.Q 0
C3131 a_2309_6037# a_3348_7235# 0
C3132 _27_.Y _52_.Y 0
C3133 u_loop.u_gh.B a_6097_4641# 0
C3134 a_1499_7663# a_1920_7663# 0.09313f
C3135 a_4518_6825# src[1] 0.04295f
C3136 a_2769_8213# _64_.Q 0
C3137 _68_.D a_8643_7423# 0
C3138 u_loop.u_d7.X a_5911_2767# 0
C3139 a_5569_2767# u_loop.u_d0.A 0.01495f
C3140 a_2580_7663# a_2755_7637# 0.23366f
C3141 a_2123_8029# a_2233_7905# 0.09774f
C3142 a_2143_6037# _63_.Q 0
C3143 a_7387_4949# a_7631_6335# 0
C3144 a_1499_7663# a_2689_7663# 0
C3145 x u_loop.u_s2.A 0.0259f
C3146 a_7079_8725# _31_.Y 0
C3147 a_2235_4949# _27_.Y 0.00204f
C3148 _55_.Q a_6927_5487# 0
C3149 a_3000_9295# _30_.A 0
C3150 a_2877_6005# src[0] 0
C3151 u_loop.u_gl.A2 a_6097_4641# 0
C3152 _63_.D a_2123_8029# 0.00211f
C3153 _70_.LO xa 0.00185f
C3154 VPWR a_2401_4949# 0.60314f
C3155 a_6375_6037# a_7443_5487# 0
C3156 a_7551_5853# _67_.D 0.00151f
C3157 a_2439_4541# a_3491_5247# 0.00366f
C3158 a_6283_7663# a_7079_8725# 0
C3159 a_7079_8725# a_5823_8751# 0.04359f
C3160 u_loop.u_gh.C a_7999_5321# 0.00344f
C3161 _27_.Y _28_.Y 0
C3162 a_5784_4399# u_loop.u_gh.C 0.01777f
C3163 _41_.X a_5363_4399# 0
C3164 a_7385_3829# a_7894_3855# 0
C3165 VPWR _68_.D 0.38911f
C3166 _67_.D _25_.A 0.02745f
C3167 _39_.B2 a_5607_9599# 0.13427f
C3168 a_3684_8585# u_loop.u_gh.C 0.24503f
C3169 _39_.X _41_.C1 0
C3170 a_4158_7235# src[0] 0.00237f
C3171 _56_.Q _25_.A 0.05465f
C3172 _56_.CLK a_5190_5487# 0.00676f
C3173 VPWR a_6633_2767# 0.30918f
C3174 u_loop.u_cmp.Y u_loop.u_q.B 0
C3175 VPWR _30_.A 1.59476f
C3176 a_3013_5309# a_2751_5321# 0.00171f
C3177 _64_.D a_1665_7663# 0
C3178 _25_.Y _55_.D 0.00139f
C3179 VPWR a_7808_7485# 0.08228f
C3180 _56_.CLK prenh 0
C3181 _55_.Q a_8183_5461# 0
C3182 _57_.CLK _67_.D 0
C3183 _39_.B2 a_4517_9301# 0.13082f
C3184 a_7808_5309# u_loop.u_gh.C 0.02127f
C3185 _45_.A _41_.C1 0
C3186 a_3684_8585# _50_.Y 0
C3187 _56_.Q _57_.CLK 0
C3188 u_loop.u_d6.X u_loop.u_cmp.Y 0.00682f
C3189 u_loop.u_d0.X a_3597_2767# 0
C3190 en _64_.Q 0
C3191 _67_.D a_6817_3861# 0
C3192 u_loop.u_d0.A a_5363_4399# 0.00185f
C3193 VPWR a_6891_6409# 0.20843f
C3194 a_3703_2767# prenl 0.00514f
C3195 a_2751_5321# a_2847_5321# 0.01379f
C3196 a_6799_7663# _46_.Y 0
C3197 a_2400_4667# a_2356_4765# 0
C3198 _63_.Q a_1665_7663# 0.00107f
C3199 _68_.D a_7808_7485# 0.17295f
C3200 a_7999_7497# u_loop.u_gh.C 0.00512f
C3201 VPWR a_5569_2767# 0.30006f
C3202 a_7093_5487# a_7387_4949# 0.00965f
C3203 _32_.A a_7348_5487# 0
C3204 a_4772_9661# a_4867_9673# 0.04983f
C3205 a_2231_2767# a_1889_2767# 0.00188f
C3206 VPWR a_4963_9673# 0
C3207 _30_.Y a_3170_9295# 0
C3208 u_loop.u_d0.A a_2967_2767# 0.04718f
C3209 a_5975_4399# a_5529_4399# 0
C3210 a_6449_7663# _70_.LO 0
C3211 VPWR _46_.A 0.93237f
C3212 _56_.CLK a_4769_4175# 0
C3213 a_3224_6409# a_3388_7351# 0
C3214 a_8165_7485# xa 0
C3215 a_8468_7497# a_7903_7497# 0
C3216 a_2479_9269# _30_.Y 0
C3217 a_6799_7663# a_6904_8751# 0
C3218 a_6739_2767# u_loop.u_d6.X 0
C3219 VPWR _21_.Y 0.62379f
C3220 u_loop.u_gh.C _64_.Q 0.38334f
C3221 _55_.CLK u_loop.u_s2.Y 0.00345f
C3222 a_5529_4399# a_5363_4399# 0.87828f
C3223 _39_.X a_6375_6037# 0
C3224 _46_.Y a_7017_7905# 0
C3225 a_6449_7663# a_5989_8751# 0
C3226 a_3793_8585# a_3337_8181# 0
C3227 a_4833_2767# u_loop.u_d5.X 0
C3228 _55_.CLK a_5987_4765# 0.00327f
C3229 VPWR a_5649_7119# 0.00739f
C3230 a_7553_7125# a_7999_7497# 0
C3231 _45_.A a_6375_6037# 0
C3232 a_2309_6037# a_2877_6005# 0.18639f
C3233 VPWR a_5975_4399# 0.00524f
C3234 a_2143_6037# u_loop.u_gh.C 0.51072f
C3235 a_2439_4541# _52_.Y 0
C3236 a_6987_6409# a_6375_6037# 0
C3237 _20_.Y a_1654_6575# 0.00459f
C3238 u_loop.u_gh.C a_7732_4233# 0.23735f
C3239 a_8630_7119# xb 0
C3240 a_2400_4667# a_2969_4917# 0
C3241 _22_.Y a_6375_6037# 0
C3242 a_2439_4541# a_3316_5321# 0.00107f
C3243 _53_.A _27_.Y 0.25323f
C3244 _21_.Y _30_.A 0.00164f
C3245 VPWR a_5363_4399# 0.47314f
C3246 a_7553_4949# a_8008_5487# 0.00598f
C3247 a_8468_7497# _39_.X 0
C3248 a_2439_4541# a_2235_4949# 0
C3249 en a_1665_7663# 0
C3250 u_loop.u_d0.A u_loop.u_d2.X 0.1438f
C3251 a_6927_5487# a_6541_6037# 0.001f
C3252 a_7999_5321# _25_.A 0.00238f
C3253 _55_.CLK _56_.Q 0.24478f
C3254 _39_.B2 src[0] 0
C3255 a_2356_4765# a_2526_4765# 0
C3256 VPWR a_8011_7119# 0.1421f
C3257 a_2439_4541# _28_.Y 0.00193f
C3258 a_8630_4943# xb 0
C3259 u_loop.u_gl.B1 u_loop.u_d3.X 0.00763f
C3260 VPWR a_2967_2767# 0.19339f
C3261 u_loop.u_d2.X a_3361_2767# 0.37357f
C3262 VPWR _31_.Y 0.5993f
C3263 VPWR a_2751_5321# 0.21143f
C3264 a_3384_9295# _40_.B 0.00113f
C3265 a_2143_6037# a_2767_6031# 0
C3266 a_7539_7637# _70_.LO 0
C3267 VPWR a_2740_4765# 0.14235f
C3268 _62_.D a_2755_7637# 0
C3269 a_6927_5487# a_7661_5729# 0.07009f
C3270 _55_.D a_7385_3829# 0.00324f
C3271 a_2659_6409# _52_.Y 0.00387f
C3272 a_6927_5487# u_loop.u_gh.C 0.33109f
C3273 u_loop.u_d0.X a_3703_2767# 0
C3274 VPWR a_6283_7663# 0.49541f
C3275 a_7808_5309# _25_.A 0.00546f
C3276 VPWR a_5823_8751# 0.54243f
C3277 _38_.X a_5377_7439# 0
C3278 _55_.Q a_7841_4233# 0
C3279 a_2533_2223# a_2875_2223# 0.00188f
C3280 a_8121_7093# u_loop.u_gh.C 0.16912f
C3281 a_2861_2767# prenl 0
C3282 a_2751_5321# a_2401_4949# 0.2298f
C3283 a_6381_3561# u_loop.u_q.B 0.01129f
C3284 a_2740_4765# a_2401_4949# 0
C3285 _39_.B2 a_5190_7439# 0.0872f
C3286 a_7387_4949# _25_.Y 0.17335f
C3287 _68_.D a_8011_7119# 0
C3288 u_loop.u_gh.B a_4510_3311# 0
C3289 u_loop.u_gh.C a_1665_7663# 0.02826f
C3290 a_3491_5247# u_loop.u_gh.B 0
C3291 u_loop.u_gh.C a_6097_4641# 0.1665f
C3292 _21_.Y _46_.A 0
C3293 a_2235_4949# a_2659_6409# 0
C3294 a_2400_4667# a_2877_6005# 0
C3295 a_5594_9295# a_4517_9301# 0
C3296 _50_.Y a_1665_7663# 0
C3297 _31_.Y _30_.A 0
C3298 a_6449_7663# xa 0
C3299 _30_.Y a_4517_9301# 0
C3300 a_8183_5461# u_loop.u_gh.C 0.28815f
C3301 a_6283_7663# _68_.D 0
C3302 u_loop.u_gl.A2 a_4510_3311# 0.13437f
C3303 a_1920_7663# _64_.Q 0
C3304 x VGND 1.06893f
C3305 prenl VGND 1.39016f
C3306 prenh VGND 0.84575f
C3307 xb VGND 0.99108f
C3308 pre VGND 1.15475f
C3309 en VGND 0.83767f
C3310 xa VGND 1.07523f
C3311 src[0] VGND 1.83001f
C3312 src[1] VGND 3.20656f
C3313 VPWR VGND 0.27372p
C3314 a_6457_2473# VGND 0.00114f
C3315 a_2875_2223# VGND 0.27019f
C3316 a_2769_2223# VGND 0.4486f
C3317 a_2533_2223# VGND 0.46549f
C3318 u_loop.u_d7.X VGND 0.75599f
C3319 u_loop.u_d0.X VGND 0.36658f
C3320 a_6739_2767# VGND 0.29027f
C3321 a_6633_2767# VGND 0.4918f
C3322 a_6397_2767# VGND 0.42219f
C3323 u_loop.u_d6.X VGND 0.34053f
C3324 a_5911_2767# VGND 0.23791f
C3325 a_5805_2767# VGND 0.39156f
C3326 a_5569_2767# VGND 0.38234f
C3327 u_loop.u_d5.X VGND 0.25952f
C3328 a_5175_2767# VGND 0.22422f
C3329 a_5069_2767# VGND 0.41338f
C3330 a_4833_2767# VGND 0.40123f
C3331 u_loop.u_d4.X VGND 0.23538f
C3332 a_4439_2767# VGND 0.22938f
C3333 a_4333_2767# VGND 0.3822f
C3334 a_4097_2767# VGND 0.37465f
C3335 u_loop.u_d3.X VGND 0.24308f
C3336 a_3703_2767# VGND 0.23919f
C3337 a_3597_2767# VGND 0.39222f
C3338 a_3361_2767# VGND 0.38311f
C3339 u_loop.u_d2.X VGND 0.23452f
C3340 a_2967_2767# VGND 0.22994f
C3341 a_2861_2767# VGND 0.41526f
C3342 a_2625_2767# VGND 0.43298f
C3343 u_loop.u_d1.X VGND 0.43733f
C3344 a_2231_2767# VGND 0.237f
C3345 a_2125_2767# VGND 0.40003f
C3346 a_1889_2767# VGND 0.41517f
C3347 a_4510_3311# VGND 0.4478f
C3348 u_loop.u_q.B VGND 0.48377f
C3349 a_6381_3561# VGND 0
C3350 u_loop.u_s2.A VGND 0.63283f
C3351 a_4076_3561# VGND 0.0192f
C3352 u_loop.u_s2.Y VGND 0.56155f
C3353 u_loop.u_cmp.Y VGND 0.47473f
C3354 a_7894_3855# VGND 0
C3355 a_7275_3855# VGND 0.00766f
C3356 a_8086_4221# VGND 0.00236f
C3357 a_7841_4233# VGND 0.00105f
C3358 a_7429_4221# VGND 0.0061f
C3359 a_7263_4233# VGND 0.00856f
C3360 a_7072_4221# VGND 0.07536f
C3361 a_4769_4175# VGND 0.45748f
C3362 a_4351_4175# VGND 0.30062f
C3363 u_loop.u_gl.B1 VGND 0.65809f
C3364 a_7732_4233# VGND 0.28262f
C3365 a_7907_4159# VGND 0.6303f
C3366 a_7167_4233# VGND 0.2701f
C3367 a_7385_3829# VGND 0.19193f
C3368 a_6817_3861# VGND 0.34282f
C3369 a_6651_3861# VGND 0.68467f
C3370 a_6798_4399# VGND 0.00448f
C3371 a_6553_4399# VGND 0.00118f
C3372 _55_.D VGND 0.71179f
C3373 a_6141_4399# VGND 0.00579f
C3374 a_5975_4399# VGND 0.00863f
C3375 a_6606_4765# VGND 0
C3376 a_5987_4765# VGND 0.00574f
C3377 a_5784_4399# VGND 0.07859f
C3378 _55_.Q VGND 1.32939f
C3379 a_6444_4399# VGND 0.32033f
C3380 a_6619_4373# VGND 0.64825f
C3381 a_5879_4399# VGND 0.27197f
C3382 a_6097_4641# VGND 0.19057f
C3383 a_5529_4399# VGND 0.30696f
C3384 a_5363_4399# VGND 0.56592f
C3385 u_loop.u_gl.A2 VGND 0.84536f
C3386 a_2905_4399# VGND 0.01032f
C3387 a_2833_4399# VGND 0.00858f
C3388 a_2397_4399# VGND 0.00112f
C3389 a_2157_4399# VGND 0.00221f
C3390 u_loop.u_d0.A VGND 3.50358f
C3391 a_3158_4765# VGND 0.08104f
C3392 a_2740_4765# VGND 0.01317f
C3393 a_2356_4765# VGND 0
C3394 _27_.Y VGND 0.43575f
C3395 a_2526_4765# VGND 0.2112f
C3396 a_2595_4636# VGND 0.2797f
C3397 a_2439_4541# VGND 0.576f
C3398 a_2400_4667# VGND 0.32338f
C3399 a_2122_4651# VGND 0.27775f
C3400 a_1835_4373# VGND 0.59665f
C3401 _53_.A VGND 1.20627f
C3402 a_8011_4943# VGND 0.00673f
C3403 a_8822_5309# VGND 0.00221f
C3404 a_8577_5321# VGND 0
C3405 a_8165_5309# VGND 0.00595f
C3406 a_7999_5321# VGND 0.00896f
C3407 a_7808_5309# VGND 0.07946f
C3408 _55_.CLK VGND 0.68911f
C3409 a_3478_4943# VGND 0
C3410 _56_.D VGND 0.37999f
C3411 u_loop.u_gh.B VGND 0.92183f
C3412 a_2859_4943# VGND 0.0083f
C3413 a_3670_5309# VGND 0.00137f
C3414 a_3425_5321# VGND 0
C3415 a_3013_5309# VGND 0.00525f
C3416 a_2847_5321# VGND 0.00845f
C3417 a_2656_5309# VGND 0.0941f
C3418 a_8468_5321# VGND 0.27885f
C3419 a_8643_5247# VGND 0.61013f
C3420 a_7903_5321# VGND 0.26386f
C3421 a_8121_4917# VGND 0.19007f
C3422 a_7553_4949# VGND 0.30824f
C3423 _25_.Y VGND 0.38462f
C3424 a_7387_4949# VGND 0.61854f
C3425 _42_.Y VGND 0.38836f
C3426 a_3316_5321# VGND 0.26967f
C3427 a_3491_5247# VGND 0.59797f
C3428 a_2751_5321# VGND 0.2844f
C3429 a_2969_4917# VGND 0.18031f
C3430 a_2401_4949# VGND 0.3347f
C3431 _28_.Y VGND 0.37818f
C3432 a_2235_4949# VGND 0.57976f
C3433 _53_.Y VGND 0.60125f
C3434 a_8362_5487# VGND 0.00232f
C3435 a_8117_5487# VGND 0.00103f
C3436 a_7705_5487# VGND 0.00516f
C3437 a_7539_5487# VGND 0.00784f
C3438 a_8170_5853# VGND 0
C3439 a_5377_5487# VGND 0.17765f
C3440 a_5293_5487# VGND 0.13298f
C3441 a_7551_5853# VGND 0.00584f
C3442 a_7348_5487# VGND 0.08092f
C3443 a_8008_5487# VGND 0.2706f
C3444 a_8183_5461# VGND 0.63401f
C3445 a_7443_5487# VGND 0.2592f
C3446 a_7661_5729# VGND 0.18206f
C3447 a_7093_5487# VGND 0.30174f
C3448 a_6927_5487# VGND 0.55301f
C3449 _56_.CLK VGND 0.74929f
C3450 _41_.X VGND 0.39483f
C3451 a_5649_5737# VGND 0
C3452 a_5389_5737# VGND 0
C3453 a_5190_5487# VGND 0.31844f
C3454 _25_.A VGND 1.74924f
C3455 _56_.Q VGND 1.47586f
C3456 _28_.A VGND 2.17369f
C3457 _69_.LO VGND 0.1668f
C3458 a_7618_6031# VGND 0
C3459 _67_.D VGND 0.7282f
C3460 a_6999_6031# VGND 0.00653f
C3461 a_7810_6397# VGND 0.00136f
C3462 a_7565_6409# VGND 0
C3463 a_7153_6397# VGND 0.00524f
C3464 a_3386_6031# VGND 0
C3465 a_6987_6409# VGND 0.0074f
C3466 a_6796_6397# VGND 0.09424f
C3467 a_4369_6351# VGND 0.37657f
C3468 a_2767_6031# VGND 0.0143f
C3469 a_3578_6397# VGND 0.00244f
C3470 a_3333_6409# VGND 0.0011f
C3471 a_2921_6397# VGND 0.00623f
C3472 a_2755_6409# VGND 0.01432f
C3473 a_2564_6397# VGND 0.08474f
C3474 a_7456_6409# VGND 0.26482f
C3475 a_7631_6335# VGND 0.56829f
C3476 a_6891_6409# VGND 0.26557f
C3477 a_7109_6005# VGND 0.1781f
C3478 a_6541_6037# VGND 0.32518f
C3479 _32_.Y VGND 0.41646f
C3480 a_6375_6037# VGND 0.5844f
C3481 _32_.A VGND 1.93724f
C3482 a_4167_6147# VGND 0.32753f
C3483 a_3224_6409# VGND 0.28087f
C3484 a_3399_6335# VGND 0.61875f
C3485 a_2659_6409# VGND 0.30326f
C3486 a_2877_6005# VGND 0.19823f
C3487 a_2309_6037# VGND 0.35332f
C3488 a_2143_6037# VGND 0.64332f
C3489 _52_.Y VGND 0.41698f
C3490 a_4518_6575# VGND 0.32357f
C3491 _57_.CLK VGND 0.61867f
C3492 a_1654_6575# VGND 0.1043f
C3493 a_1582_6575# VGND 0.00222f
C3494 a_4518_6825# VGND 0.01167f
C3495 a_4075_6825# VGND 0.00398f
C3496 _64_.D VGND 0.62518f
C3497 a_1845_6825# VGND 0
C3498 a_4160_6575# VGND 0.54202f
C3499 a_1499_6575# VGND 0.35078f
C3500 _20_.Y VGND 0.76462f
C3501 a_8011_7119# VGND 0.00684f
C3502 a_8822_7485# VGND 0.00221f
C3503 a_8577_7497# VGND 0
C3504 a_8165_7485# VGND 0.00595f
C3505 a_5649_7119# VGND 0
C3506 a_5389_7119# VGND 0
C3507 a_7999_7497# VGND 0.00829f
C3508 a_7808_7485# VGND 0.07817f
C3509 a_4158_7235# VGND 0
C3510 a_4074_7235# VGND 0
C3511 a_5377_7439# VGND 0.17786f
C3512 a_5293_7439# VGND 0.13304f
C3513 _41_.C1 VGND 0.78543f
C3514 a_3514_7235# VGND 0
C3515 a_3430_7235# VGND 0
C3516 a_8468_7497# VGND 0.27981f
C3517 a_8643_7423# VGND 0.61514f
C3518 a_7903_7497# VGND 0.27404f
C3519 a_8121_7093# VGND 0.19548f
C3520 a_7553_7125# VGND 0.32153f
C3521 a_7387_7125# VGND 0.6162f
C3522 _39_.X VGND 0.62653f
C3523 a_5190_7439# VGND 0.32897f
C3524 _36_.A VGND 1.18174f
C3525 _41_.B1 VGND 0.77926f
C3526 a_3992_7235# VGND 0.4014f
C3527 a_4032_7351# VGND 0.2761f
C3528 _38_.X VGND 0.53273f
C3529 a_3348_7235# VGND 0.43635f
C3530 a_3388_7351# VGND 0.23667f
C3531 _64_.Q VGND 1.31338f
C3532 _70_.LO VGND 0.19713f
C3533 _68_.D VGND 0.89794f
C3534 a_7718_7663# VGND 0.00137f
C3535 a_7473_7663# VGND 0
C3536 _45_.A VGND 2.34905f
C3537 a_7061_7663# VGND 0.00525f
C3538 a_6895_7663# VGND 0.00779f
C3539 a_7526_8029# VGND 0
C3540 a_2934_7663# VGND 0.00253f
C3541 a_2689_7663# VGND 0.00205f
C3542 a_6907_8029# VGND 0.00788f
C3543 a_6704_7663# VGND 0.09595f
C3544 a_7364_7663# VGND 0.26281f
C3545 a_7539_7637# VGND 0.59799f
C3546 a_6799_7663# VGND 0.29509f
C3547 a_7017_7905# VGND 0.20166f
C3548 a_6449_7663# VGND 0.34561f
C3549 _22_.Y VGND 0.63115f
C3550 a_6283_7663# VGND 0.59582f
C3551 _46_.Y VGND 0.3407f
C3552 a_2277_7663# VGND 0.00615f
C3553 a_2111_7663# VGND 0.00863f
C3554 a_2742_8029# VGND 0
C3555 a_2123_8029# VGND 0.00562f
C3556 a_1920_7663# VGND 0.08f
C3557 a_2580_7663# VGND 0.31367f
C3558 a_2755_7637# VGND 0.61804f
C3559 a_2015_7663# VGND 0.26896f
C3560 a_2233_7905# VGND 0.18588f
C3561 a_1665_7663# VGND 0.32539f
C3562 a_1499_7663# VGND 0.70608f
C3563 _51_.Y VGND 0.93041f
C3564 a_3846_8207# VGND 0
C3565 a_3227_8207# VGND 0.00711f
C3566 a_4038_8573# VGND 0.00236f
C3567 a_3793_8585# VGND 0.00106f
C3568 a_3381_8573# VGND 0.00612f
C3569 a_3215_8585# VGND 0.00934f
C3570 a_3024_8573# VGND 0.08159f
C3571 _63_.D VGND 0.51618f
C3572 a_3684_8585# VGND 0.27883f
C3573 a_3859_8511# VGND 0.64264f
C3574 a_3119_8585# VGND 0.27735f
C3575 a_3337_8181# VGND 0.19229f
C3576 a_2769_8213# VGND 0.32375f
C3577 a_2603_8213# VGND 0.63972f
C3578 _50_.Y VGND 0.32196f
C3579 _63_.Q VGND 1.00697f
C3580 a_7258_8751# VGND 0.00141f
C3581 a_7013_8751# VGND 0
C3582 _46_.A VGND 1.67962f
C3583 a_6601_8751# VGND 0.0066f
C3584 a_6435_8751# VGND 0.0076f
C3585 a_7066_9117# VGND 0
C3586 a_6447_9117# VGND 0.01371f
C3587 a_6244_8751# VGND 0.081f
C3588 a_6904_8751# VGND 0.27965f
C3589 a_7079_8725# VGND 0.61574f
C3590 a_6339_8751# VGND 0.27902f
C3591 a_6557_8993# VGND 0.20917f
C3592 a_5989_8751# VGND 0.35069f
C3593 _31_.Y VGND 0.8309f
C3594 a_5823_8751# VGND 0.69293f
C3595 _47_.Y VGND 0.36877f
C3596 _62_.D VGND 0.68762f
C3597 _40_.B VGND 1.33534f
C3598 _39_.B2 VGND 1.32256f
C3599 a_4975_9295# VGND 0.00473f
C3600 a_5786_9661# VGND 0.00221f
C3601 a_5541_9673# VGND 0
C3602 a_3384_9295# VGND 0.00575f
C3603 a_5129_9661# VGND 0.00579f
C3604 a_4963_9673# VGND 0.00863f
C3605 a_4772_9661# VGND 0.08015f
C3606 a_3000_9295# VGND 0
C3607 a_3802_9295# VGND 0.07994f
C3608 a_3549_9661# VGND 0.0092f
C3609 a_3477_9661# VGND 0.00609f
C3610 a_3041_9661# VGND 0.00112f
C3611 a_2801_9661# VGND 0.00448f
C3612 _30_.A VGND 0.87923f
C3613 a_5432_9673# VGND 0.26669f
C3614 a_5607_9599# VGND 0.59555f
C3615 a_4867_9673# VGND 0.25753f
C3616 a_5085_9269# VGND 0.18951f
C3617 a_4517_9301# VGND 0.31794f
C3618 _21_.Y VGND 0.40475f
C3619 a_4351_9301# VGND 0.51312f
C3620 _48_.Y VGND 0.34626f
C3621 _49_.Y VGND 0.36228f
C3622 _30_.Y VGND 0.38362f
C3623 a_3170_9295# VGND 0.19197f
C3624 a_3239_9269# VGND 0.2717f
C3625 a_3044_9411# VGND 0.312f
C3626 a_3083_9537# VGND 0.52126f
C3627 u_loop.u_gh.C VGND 14.0179f
C3628 a_2766_9427# VGND 0.29871f
C3629 a_2479_9269# VGND 0.67316f
.ends
