* NGSPICE file created from r2flat.ext - technology: sky130A

.subckt r2flat VGND VPWR en pre prenh prenl src[0] src[1] x xa xb
X0 VGND VPWR VGND VGND sky130_fd_pr__nfet_01v8 ad=0.143 pd=1.62 as=103.71135 ps=1.09923k w=0.55 l=0.59
X1 VPWR VGND VPWR VPWR sky130_fd_pr__pfet_01v8_hvt ad=0.2262 pd=2.26 as=155.89841 ps=1.50948k w=0.87 l=0.59
X2 a_7903_7497# a_7387_7125# a_7808_7485# VGND sky130_fd_pr__special_nfet_01v8 ad=0.0594 pd=0.69 as=0.066 ps=0.745 w=0.36 l=0.15
X3 VGND _28_.A _28_.Y VGND sky130_fd_pr__nfet_01v8 ad=0.169 pd=1.82 as=0.08775 ps=0.92 w=0.65 l=0.15
X4 VPWR a_2509_4641# a_2399_4765# VPWR sky130_fd_pr__pfet_01v8_hvt ad=0.07035 pd=0.755 as=0.1155 ps=0.97 w=0.42 l=0.15
X5 a_8577_5321# a_7387_4949# a_8468_5321# VGND sky130_fd_pr__special_nfet_01v8 ad=0.0669 pd=0.75 as=0.0711 ps=0.755 w=0.36 l=0.15
X6 VPWR VGND VPWR VPWR sky130_fd_pr__pfet_01v8_hvt ad=0.2262 pd=2.26 as=0 ps=0 w=0.87 l=0.59
X7 _28_.A a_3491_5247# VGND VGND sky130_fd_pr__nfet_01v8 ad=0.08775 pd=0.92 as=0.2087 ps=2.02 w=0.65 l=0.15
X8 VPWR VGND VPWR VPWR sky130_fd_pr__pfet_01v8_hvt ad=0.2262 pd=2.26 as=0 ps=0 w=0.87 l=0.59
X9 _42_.Y _55_.Q VPWR VPWR sky130_fd_pr__pfet_01v8_hvt ad=0.135 pd=1.27 as=0.26 ps=2.52 w=1 l=0.15
X10 VPWR VGND VPWR VPWR sky130_fd_pr__pfet_01v8_hvt ad=0.2262 pd=2.26 as=0 ps=0 w=0.87 l=0.59
X11 VGND a_1499_6575# _34_.X VGND sky130_fd_pr__nfet_01v8 ad=0.23075 pd=2.01 as=0.091 ps=0.93 w=0.65 l=0.15
X12 VGND _45_.A a_5377_7439# VGND sky130_fd_pr__nfet_01v8 ad=0.08775 pd=0.92 as=0.08775 ps=0.92 w=0.65 l=0.15
X13 a_7999_5321# a_7553_4949# a_7903_5321# VGND sky130_fd_pr__special_nfet_01v8 ad=0.1401 pd=1.1 as=0.0594 ps=0.69 w=0.36 l=0.15
X14 VPWR VGND VPWR VPWR sky130_fd_pr__pfet_01v8_hvt ad=0.2262 pd=2.26 as=0 ps=0 w=0.87 l=0.59
X15 VGND _25_.A _25_.Y VGND sky130_fd_pr__nfet_01v8 ad=0.169 pd=1.82 as=0.08775 ps=0.92 w=0.65 l=0.15
X16 VPWR VGND VPWR VPWR sky130_fd_pr__pfet_01v8_hvt ad=0.2262 pd=2.26 as=0 ps=0 w=0.87 l=0.59
X17 a_4867_9673# a_4351_9301# a_4772_9661# VGND sky130_fd_pr__special_nfet_01v8 ad=0.0594 pd=0.69 as=0.066 ps=0.745 w=0.36 l=0.15
X18 VPWR VGND VPWR VPWR sky130_fd_pr__pfet_01v8_hvt ad=0.2262 pd=2.26 as=0 ps=0 w=0.87 l=0.59
X19 VGND VPWR VGND VGND sky130_fd_pr__nfet_01v8 ad=0.143 pd=1.62 as=0 ps=0 w=0.55 l=0.59
X20 a_5805_2767# a_5569_2767# VPWR VPWR sky130_fd_pr__pfet_01v8_hvt ad=0.1092 pd=1.36 as=0.0567 ps=0.69 w=0.42 l=0.5
X21 VPWR a_5085_9269# a_4975_9295# VPWR sky130_fd_pr__pfet_01v8_hvt ad=0.07035 pd=0.755 as=0.1155 ps=0.97 w=0.42 l=0.15
X22 VGND _34_.X a_7387_6575# VGND sky130_fd_pr__nfet_01v8 ad=0.1228 pd=1.065 as=0.1134 ps=1.38 w=0.42 l=0.15
X23 VPWR VGND VPWR VPWR sky130_fd_pr__pfet_01v8_hvt ad=0.2262 pd=2.26 as=0 ps=0 w=0.87 l=0.59
X24 u_loop.u_d6.X a_5911_2767# VPWR VPWR sky130_fd_pr__pfet_01v8_hvt ad=0.26 pd=2.52 as=0.14075 ps=1.325 w=1 l=0.15
X25 VPWR a_5276_2197# a_5036_2381# VPWR sky130_fd_pr__pfet_01v8_hvt ad=0.19265 pd=1.415 as=0.2173 ps=2.17 w=0.82 l=0.25
X26 a_7553_4949# a_7387_4949# VGND VGND sky130_fd_pr__nfet_01v8 ad=0.1092 pd=1.36 as=0.0567 ps=0.69 w=0.42 l=0.15
X27 _53_.Y _53_.A VGND VGND sky130_fd_pr__nfet_01v8 ad=0.08775 pd=0.92 as=0.169 ps=1.82 w=0.65 l=0.15
X28 a_2755_7637# a_2580_7663# a_2934_7663# VGND sky130_fd_pr__nfet_01v8 ad=0.1092 pd=1.36 as=0.06405 ps=0.725 w=0.42 l=0.15
X29 VGND _23_.A _23_.Y VGND sky130_fd_pr__nfet_01v8 ad=0.169 pd=1.82 as=0.08775 ps=0.92 w=0.65 l=0.15
X30 VPWR VGND VPWR VPWR sky130_fd_pr__pfet_01v8_hvt ad=0.2262 pd=2.26 as=0 ps=0 w=0.87 l=0.59
X31 a_6557_8993# a_6339_8751# VGND VGND sky130_fd_pr__nfet_01v8 ad=0.0999 pd=0.985 as=0.1346 ps=1.15 w=0.64 l=0.15
X32 a_8800_6031# a_8583_6031# VGND VGND sky130_fd_pr__nfet_01v8 ad=0.17225 pd=1.83 as=0.1228 ps=1.065 w=0.65 l=0.25
X33 a_6633_2767# a_6397_2767# VPWR VPWR sky130_fd_pr__pfet_01v8_hvt ad=0.1092 pd=1.36 as=0.0567 ps=0.69 w=0.42 l=0.5
X34 VGND VPWR VGND VGND sky130_fd_pr__nfet_01v8 ad=0.143 pd=1.62 as=0 ps=0 w=0.55 l=0.59
X35 a_3578_6397# u_loop.u_gh.C VGND VGND sky130_fd_pr__nfet_01v8 ad=0.06405 pd=0.725 as=0.12495 ps=1.015 w=0.42 l=0.15
X36 a_7810_6397# _55_.RESET_B VGND VGND sky130_fd_pr__nfet_01v8 ad=0.06405 pd=0.725 as=0.12495 ps=1.015 w=0.42 l=0.15
X37 a_4292_2223# a_4075_2223# VPWR VPWR sky130_fd_pr__pfet_01v8_hvt ad=0.2173 pd=2.17 as=0.19265 ps=1.415 w=0.82 l=0.25
X38 VPWR VGND VPWR VPWR sky130_fd_pr__pfet_01v8_hvt ad=0.2262 pd=2.26 as=0 ps=0 w=0.87 l=0.59
X39 VGND VPWR VGND VGND sky130_fd_pr__nfet_01v8 ad=0.143 pd=1.62 as=0 ps=0 w=0.55 l=0.59
X40 VGND VPWR VGND VGND sky130_fd_pr__nfet_01v8 ad=0.143 pd=1.62 as=0 ps=0 w=0.55 l=0.59
X41 a_2861_2767# a_2625_2767# VGND VGND sky130_fd_pr__nfet_01v8 ad=0.1092 pd=1.36 as=0.0567 ps=0.69 w=0.42 l=0.5
X42 output7.A u_loop.u_gl.B1 VGND VGND sky130_fd_pr__nfet_01v8 ad=0.091 pd=0.93 as=0.17225 ps=1.83 w=0.65 l=0.15
X43 VGND VPWR VGND VGND sky130_fd_pr__nfet_01v8 ad=0.143 pd=1.62 as=0 ps=0 w=0.55 l=0.59
X44 VPWR VGND VPWR VPWR sky130_fd_pr__pfet_01v8_hvt ad=0.2262 pd=2.26 as=0 ps=0 w=0.87 l=0.59
X45 VPWR _40_.B _49_.Y VPWR sky130_fd_pr__pfet_01v8_hvt ad=0.26 pd=2.52 as=0.135 ps=1.27 w=1 l=0.15
X46 VGND VPWR VGND VGND sky130_fd_pr__nfet_01v8 ad=0.143 pd=1.62 as=0 ps=0 w=0.55 l=0.59
X47 VPWR VGND VPWR VPWR sky130_fd_pr__pfet_01v8_hvt ad=0.2262 pd=2.26 as=0 ps=0 w=0.87 l=0.59
X48 VPWR VGND VPWR VPWR sky130_fd_pr__pfet_01v8_hvt ad=0.2262 pd=2.26 as=0 ps=0 w=0.87 l=0.59
X49 VPWR a_8468_7497# a_8643_7423# VPWR sky130_fd_pr__pfet_01v8_hvt ad=0.1134 pd=1.38 as=0.0567 ps=0.69 w=0.42 l=0.15
X50 _62_.D _40_.B VGND VGND sky130_fd_pr__nfet_01v8 ad=0.08775 pd=0.92 as=0.169 ps=1.82 w=0.65 l=0.15
X51 _21_.Y _39_.B2 VGND VGND sky130_fd_pr__nfet_01v8 ad=0.08775 pd=0.92 as=0.169 ps=1.82 w=0.65 l=0.15
X52 VGND _55_.RESET_B a_8165_7485# VGND sky130_fd_pr__nfet_01v8 ad=0.1346 pd=1.15 as=0.0441 ps=0.63 w=0.42 l=0.15
X53 _57_.CLK _45_.A VPWR VPWR sky130_fd_pr__pfet_01v8_hvt ad=0.135 pd=1.27 as=0.26 ps=2.52 w=1 l=0.15
X54 u_loop.u_d3.X a_3703_2767# VGND VGND sky130_fd_pr__nfet_01v8 ad=0.169 pd=1.82 as=0.097 ps=0.975 w=0.65 l=0.15
X55 a_4769_4175# u_loop.u_gh.B a_4351_4175# VGND sky130_fd_pr__nfet_01v8 ad=0.08775 pd=0.92 as=0.08775 ps=0.92 w=0.65 l=0.15
X56 VPWR _35_.A_N a_4075_6825# VPWR sky130_fd_pr__pfet_01v8_hvt ad=0.135 pd=1.27 as=0.275 ps=2.55 w=1 l=0.15
X57 VGND a_3491_5247# a_3425_5321# VGND sky130_fd_pr__nfet_01v8 ad=0.12495 pd=1.015 as=0.0669 ps=0.75 w=0.42 l=0.15
X58 VPWR VGND VPWR VPWR sky130_fd_pr__pfet_01v8_hvt ad=0.2262 pd=2.26 as=0 ps=0 w=0.87 l=0.59
X59 VGND VPWR VGND VGND sky130_fd_pr__nfet_01v8 ad=0.143 pd=1.62 as=0 ps=0 w=0.55 l=0.59
X60 VGND VPWR VGND VGND sky130_fd_pr__nfet_01v8 ad=0.143 pd=1.62 as=0 ps=0 w=0.55 l=0.59
X61 a_6799_7663# a_6283_7663# a_6704_7663# VGND sky130_fd_pr__special_nfet_01v8 ad=0.0594 pd=0.69 as=0.066 ps=0.745 w=0.36 l=0.15
X62 VGND a_5190_5487# _41_.X VGND sky130_fd_pr__nfet_01v8 ad=0.169 pd=1.82 as=0.08775 ps=0.92 w=0.65 l=0.15
X63 a_3348_7235# _23_.A VGND VGND sky130_fd_pr__nfet_01v8 ad=0.0567 pd=0.69 as=0.0567 ps=0.69 w=0.42 l=0.15
X64 VGND _35_.B a_3992_7235# VGND sky130_fd_pr__nfet_01v8 ad=0.10187 pd=0.99 as=0.0567 ps=0.69 w=0.42 l=0.15
X65 VPWR VGND VPWR VPWR sky130_fd_pr__pfet_01v8_hvt ad=0.2262 pd=2.26 as=0 ps=0 w=0.87 l=0.59
X66 VGND VPWR VGND VGND sky130_fd_pr__nfet_01v8 ad=0.143 pd=1.62 as=0 ps=0 w=0.55 l=0.59
X67 VPWR VGND VPWR VPWR sky130_fd_pr__pfet_01v8_hvt ad=0.2262 pd=2.26 as=0 ps=0 w=0.87 l=0.59
X68 VPWR a_3684_8585# a_3859_8511# VPWR sky130_fd_pr__pfet_01v8_hvt ad=0.1134 pd=1.38 as=0.0567 ps=0.69 w=0.42 l=0.15
X69 _55_.CLK _56_.Q VGND VGND sky130_fd_pr__nfet_01v8 ad=0.08775 pd=0.92 as=0.169 ps=1.82 w=0.65 l=0.15
X70 u_loop.u_d0.X a_2231_2767# VPWR VPWR sky130_fd_pr__pfet_01v8_hvt ad=0.26 pd=2.52 as=0.14075 ps=1.325 w=1 l=0.15
X71 VPWR _45_.A _22_.Y VPWR sky130_fd_pr__pfet_01v8_hvt ad=0.26 pd=2.52 as=0.135 ps=1.27 w=1 l=0.15
X72 a_1499_6575# _34_.B1 VPWR VPWR sky130_fd_pr__pfet_01v8_hvt ad=0.3675 pd=1.735 as=0.14 ps=1.28 w=1 l=0.15
X73 VPWR _55_.CLK a_6651_3861# VPWR sky130_fd_pr__pfet_01v8_hvt ad=0.0864 pd=0.91 as=0.1664 ps=1.8 w=0.64 l=0.15
X74 VGND VPWR VGND VGND sky130_fd_pr__nfet_01v8 ad=0.143 pd=1.62 as=0 ps=0 w=0.55 l=0.59
X75 VPWR a_7539_7637# a_7526_8029# VPWR sky130_fd_pr__pfet_01v8_hvt ad=0.0819 pd=0.81 as=0.0567 ps=0.69 w=0.42 l=0.15
X76 a_8121_7093# a_7903_7497# VPWR VPWR sky130_fd_pr__pfet_01v8_hvt ad=0.12915 pd=1.185 as=0.2184 ps=2.2 w=0.84 l=0.15
X77 _55_.RESET_B a_7715_6575# VGND VGND sky130_fd_pr__nfet_01v8 ad=0.2079 pd=1.83 as=0.1856 ps=1.26 w=0.42 l=0.15
X78 a_7618_6031# a_6541_6037# a_7456_6409# VPWR sky130_fd_pr__pfet_01v8_hvt ad=0.0567 pd=0.69 as=0.0588 ps=0.7 w=0.42 l=0.15
X79 VGND VPWR VGND VGND sky130_fd_pr__nfet_01v8 ad=0.143 pd=1.62 as=0 ps=0 w=0.55 l=0.59
X80 VGND _39_.B2 _47_.Y VGND sky130_fd_pr__nfet_01v8 ad=0.169 pd=1.82 as=0.08775 ps=0.92 w=0.65 l=0.15
X81 _50_.Y _63_.Q VPWR VPWR sky130_fd_pr__pfet_01v8_hvt ad=0.135 pd=1.27 as=0.26 ps=2.52 w=1 l=0.15
X82 VPWR u_loop.u_gh.B output6.A VPWR sky130_fd_pr__pfet_01v8_hvt ad=0.135 pd=1.27 as=0.135 ps=1.27 w=1 l=0.15
X83 a_7017_7905# a_6799_7663# VGND VGND sky130_fd_pr__nfet_01v8 ad=0.0999 pd=0.985 as=0.1346 ps=1.15 w=0.64 l=0.15
X84 u_loop.u_d5.X a_5175_2767# VPWR VPWR sky130_fd_pr__pfet_01v8_hvt ad=0.26 pd=2.52 as=0.14075 ps=1.325 w=1 l=0.15
X85 a_6447_9117# _55_.RESET_B VPWR VPWR sky130_fd_pr__pfet_01v8_hvt ad=0.1092 pd=1.36 as=0.07035 ps=0.755 w=0.42 l=0.15
X86 VPWR u_loop.u_d0.X a_2533_2223# VPWR sky130_fd_pr__pfet_01v8_hvt ad=0.0567 pd=0.69 as=0.1092 ps=1.36 w=0.42 l=0.15
X87 a_6904_8751# a_5989_8751# a_6557_8993# VGND sky130_fd_pr__special_nfet_01v8 ad=0.0711 pd=0.755 as=0.0999 ps=0.985 w=0.36 l=0.15
X88 VGND VPWR VGND VGND sky130_fd_pr__nfet_01v8 ad=0.143 pd=1.62 as=0 ps=0 w=0.55 l=0.59
X89 VPWR u_loop.u_d0.A a_4076_3561# VPWR sky130_fd_pr__pfet_01v8_hvt ad=0.14 pd=1.28 as=0.14 ps=1.28 w=1 l=0.15
X90 _41_.B1 _35_.B a_4518_6575# VGND sky130_fd_pr__nfet_01v8 ad=0.10563 pd=0.975 as=0.08775 ps=0.92 w=0.65 l=0.15
X91 VGND VPWR VGND VGND sky130_fd_pr__nfet_01v8 ad=0.143 pd=1.62 as=0 ps=0 w=0.55 l=0.59
X92 a_5432_9673# a_4517_9301# a_5085_9269# VGND sky130_fd_pr__special_nfet_01v8 ad=0.0711 pd=0.755 as=0.0999 ps=0.985 w=0.36 l=0.15
X93 a_8468_7497# a_7387_7125# a_8121_7093# VPWR sky130_fd_pr__pfet_01v8_hvt ad=0.0588 pd=0.7 as=0.12915 ps=1.185 w=0.42 l=0.15
X94 a_6541_6037# a_6375_6037# VPWR VPWR sky130_fd_pr__pfet_01v8_hvt ad=0.1664 pd=1.8 as=0.0864 ps=0.91 w=0.64 l=0.15
X95 VGND _35_.B a_4160_6575# VGND sky130_fd_pr__nfet_01v8 ad=0.169 pd=1.82 as=0.08775 ps=0.92 w=0.65 l=0.15
X96 a_7348_5487# _67_.D VGND VGND sky130_fd_pr__nfet_01v8 ad=0.066 pd=0.745 as=0.2205 ps=1.89 w=0.42 l=0.15
X97 u_loop.u_cmp.Y input5.X VPWR VPWR sky130_fd_pr__pfet_01v8_hvt ad=0.26 pd=2.52 as=0.26 ps=2.52 w=1 l=0.15
X98 a_7167_4233# a_6651_3861# a_7072_4221# VGND sky130_fd_pr__special_nfet_01v8 ad=0.0594 pd=0.69 as=0.066 ps=0.745 w=0.36 l=0.15
X99 VGND VPWR VGND VGND sky130_fd_pr__nfet_01v8 ad=0.143 pd=1.62 as=0 ps=0 w=0.55 l=0.59
X100 VGND a_3031_4373# a_2965_4399# VGND sky130_fd_pr__nfet_01v8 ad=0.12495 pd=1.015 as=0.0669 ps=0.75 w=0.42 l=0.15
X101 VPWR VGND VPWR VPWR sky130_fd_pr__pfet_01v8_hvt ad=0.2262 pd=2.26 as=0 ps=0 w=0.87 l=0.59
X102 VPWR _32_.A _32_.Y VPWR sky130_fd_pr__pfet_01v8_hvt ad=0.26 pd=2.52 as=0.135 ps=1.27 w=1 l=0.15
X103 VGND u_loop.u_d0.A a_1775_4399# VGND sky130_fd_pr__nfet_01v8 ad=0.0567 pd=0.69 as=0.1092 ps=1.36 w=0.42 l=0.15
X104 a_4076_3561# u_loop.u_d0.A VPWR VPWR sky130_fd_pr__pfet_01v8_hvt ad=0.14 pd=1.28 as=0.145 ps=1.29 w=1 l=0.15
X105 VPWR VGND VPWR VPWR sky130_fd_pr__pfet_01v8_hvt ad=0.2262 pd=2.26 as=0 ps=0 w=0.87 l=0.59
X106 VGND a_8643_5247# a_8577_5321# VGND sky130_fd_pr__nfet_01v8 ad=0.12495 pd=1.015 as=0.0669 ps=0.75 w=0.42 l=0.15
X107 a_5529_4399# a_5363_4399# VGND VGND sky130_fd_pr__nfet_01v8 ad=0.1092 pd=1.36 as=0.0567 ps=0.69 w=0.42 l=0.15
X108 a_3491_5247# u_loop.u_gh.C VPWR VPWR sky130_fd_pr__pfet_01v8_hvt ad=0.0567 pd=0.69 as=0.0819 ps=0.81 w=0.42 l=0.15
X109 a_8165_5309# a_8121_4917# a_7999_5321# VGND sky130_fd_pr__nfet_01v8 ad=0.0441 pd=0.63 as=0.1401 ps=1.1 w=0.42 l=0.15
X110 a_4517_9301# a_4351_9301# VGND VGND sky130_fd_pr__nfet_01v8 ad=0.1092 pd=1.36 as=0.0567 ps=0.69 w=0.42 l=0.15
X111 VGND VPWR VGND VGND sky130_fd_pr__nfet_01v8 ad=0.143 pd=1.62 as=0 ps=0 w=0.55 l=0.59
X112 a_4369_6351# a_4167_6147# _36_.A VGND sky130_fd_pr__nfet_01v8 ad=0.08775 pd=0.92 as=0.08775 ps=0.92 w=0.65 l=0.15
X113 VGND a_2861_2767# a_2967_2767# VGND sky130_fd_pr__nfet_01v8 ad=0.097 pd=0.975 as=0.1092 ps=1.36 w=0.42 l=0.5
X114 VPWR VGND VPWR VPWR sky130_fd_pr__pfet_01v8_hvt ad=0.2262 pd=2.26 as=0 ps=0 w=0.87 l=0.59
X115 VPWR VGND VPWR VPWR sky130_fd_pr__pfet_01v8_hvt ad=0.2262 pd=2.26 as=0 ps=0 w=0.87 l=0.59
X116 a_3070_6549# a_3196_6733# VPWR VPWR sky130_fd_pr__pfet_01v8_hvt ad=0.2173 pd=2.17 as=0.2726 ps=1.61 w=0.82 l=0.25
X117 u_loop.u_q.Y u_loop.u_q.B VGND VGND sky130_fd_pr__nfet_01v8 ad=0.08775 pd=0.92 as=0.169 ps=1.82 w=0.65 l=0.15
X118 a_6339_8751# a_5823_8751# a_6244_8751# VGND sky130_fd_pr__special_nfet_01v8 ad=0.0594 pd=0.69 as=0.066 ps=0.745 w=0.36 l=0.15
X119 VGND _46_.A _46_.Y VGND sky130_fd_pr__nfet_01v8 ad=0.169 pd=1.82 as=0.08775 ps=0.92 w=0.65 l=0.15
X120 VGND _63_.Q _63_.D VGND sky130_fd_pr__nfet_01v8 ad=0.169 pd=1.82 as=0.08775 ps=0.92 w=0.65 l=0.15
X121 a_6907_8029# _55_.RESET_B VPWR VPWR sky130_fd_pr__pfet_01v8_hvt ad=0.1092 pd=1.36 as=0.07035 ps=0.755 w=0.42 l=0.15
X122 VGND a_4160_6575# _41_.B1 VGND sky130_fd_pr__nfet_01v8 ad=0.169 pd=1.82 as=0.08775 ps=0.92 w=0.65 l=0.15
X123 a_7364_7663# a_6449_7663# a_7017_7905# VGND sky130_fd_pr__special_nfet_01v8 ad=0.0711 pd=0.755 as=0.0999 ps=0.985 w=0.36 l=0.15
X124 VGND VPWR VGND VGND sky130_fd_pr__nfet_01v8 ad=0.143 pd=1.62 as=0 ps=0 w=0.55 l=0.59
X125 VGND VPWR VGND VGND sky130_fd_pr__nfet_01v8 ad=0.143 pd=1.62 as=0 ps=0 w=0.55 l=0.59
X126 a_7551_5853# _55_.RESET_B VPWR VPWR sky130_fd_pr__pfet_01v8_hvt ad=0.1092 pd=1.36 as=0.07035 ps=0.755 w=0.42 l=0.15
X127 VGND VPWR VGND VGND sky130_fd_pr__nfet_01v8 ad=0.143 pd=1.62 as=0 ps=0 w=0.55 l=0.59
X128 VGND VPWR VGND VGND sky130_fd_pr__nfet_01v8 ad=0.143 pd=1.62 as=0 ps=0 w=0.55 l=0.59
X129 a_4867_9673# a_4517_9301# a_4772_9661# VPWR sky130_fd_pr__pfet_01v8_hvt ad=0.07245 pd=0.765 as=0.0651 ps=0.73 w=0.42 l=0.15
X130 VPWR a_1624_7119# a_1735_7119# VPWR sky130_fd_pr__pfet_01v8_hvt ad=0.2726 pd=1.61 as=0.2173 ps=2.17 w=0.82 l=0.25
X131 a_4518_6575# _35_.B _41_.B1 VGND sky130_fd_pr__nfet_01v8 ad=0.169 pd=1.82 as=0.10563 ps=0.975 w=0.65 l=0.15
X132 VPWR VGND VPWR VPWR sky130_fd_pr__pfet_01v8_hvt ad=0.2262 pd=2.26 as=0 ps=0 w=0.87 l=0.59
X133 VPWR _30_.Y a_3802_9295# VPWR sky130_fd_pr__pfet_01v8_hvt ad=0.1092 pd=1.36 as=0.0651 ps=0.73 w=0.42 l=0.15
X134 VPWR a_7079_8725# a_7066_9117# VPWR sky130_fd_pr__pfet_01v8_hvt ad=0.0819 pd=0.81 as=0.0567 ps=0.69 w=0.42 l=0.15
X135 VGND VPWR VGND VGND sky130_fd_pr__nfet_01v8 ad=0.143 pd=1.62 as=0 ps=0 w=0.55 l=0.59
X136 a_3491_5247# a_3316_5321# a_3670_5309# VGND sky130_fd_pr__nfet_01v8 ad=0.1092 pd=1.36 as=0.06405 ps=0.725 w=0.42 l=0.15
X137 a_5764_2223# a_5547_2223# VPWR VPWR sky130_fd_pr__pfet_01v8_hvt ad=0.2173 pd=2.17 as=0.19265 ps=1.415 w=0.82 l=0.25
X138 VGND VPWR VGND VGND sky130_fd_pr__nfet_01v8 ad=0.143 pd=1.62 as=0 ps=0 w=0.55 l=0.59
X139 u_loop.u_q.B u_loop.u_q.Y a_6381_3561# VPWR sky130_fd_pr__pfet_01v8_hvt ad=0.26 pd=2.52 as=0.105 ps=1.21 w=1 l=0.15
X140 _30_.Y _30_.A VPWR VPWR sky130_fd_pr__pfet_01v8_hvt ad=0.135 pd=1.27 as=0.26 ps=2.52 w=1 l=0.15
X141 VGND VPWR VGND VGND sky130_fd_pr__nfet_01v8 ad=0.143 pd=1.62 as=0 ps=0 w=0.55 l=0.59
X142 VGND u_loop.u_gl.B1 output7.A VGND sky130_fd_pr__nfet_01v8 ad=0.091 pd=0.93 as=0.091 ps=0.93 w=0.65 l=0.15
X143 VPWR VGND VPWR VPWR sky130_fd_pr__pfet_01v8_hvt ad=0.2262 pd=2.26 as=0 ps=0 w=0.87 l=0.59
X144 VPWR VGND VPWR VPWR sky130_fd_pr__pfet_01v8_hvt ad=0.2262 pd=2.26 as=0 ps=0 w=0.87 l=0.59
X145 _55_.D _55_.Q VPWR VPWR sky130_fd_pr__pfet_01v8_hvt ad=0.135 pd=1.27 as=0.26 ps=2.52 w=1 l=0.15
X146 a_4975_9295# a_4351_9301# a_4867_9673# VPWR sky130_fd_pr__pfet_01v8_hvt ad=0.1155 pd=0.97 as=0.07245 ps=0.765 w=0.42 l=0.15
X147 a_8183_5461# _55_.RESET_B VPWR VPWR sky130_fd_pr__pfet_01v8_hvt ad=0.0567 pd=0.69 as=0.0819 ps=0.81 w=0.42 l=0.15
X148 VPWR VGND VPWR VPWR sky130_fd_pr__pfet_01v8_hvt ad=0.2262 pd=2.26 as=0 ps=0 w=0.87 l=0.59
X149 VPWR VGND VPWR VPWR sky130_fd_pr__pfet_01v8_hvt ad=0.2262 pd=2.26 as=0 ps=0 w=0.87 l=0.59
X150 VPWR a_1624_6031# a_1735_6031# VPWR sky130_fd_pr__pfet_01v8_hvt ad=0.2726 pd=1.61 as=0.2173 ps=2.17 w=0.82 l=0.25
X151 VPWR VGND VPWR VPWR sky130_fd_pr__pfet_01v8_hvt ad=0.2262 pd=2.26 as=0 ps=0 w=0.87 l=0.59
X152 a_4769_4175# u_loop.u_gh.B a_4351_4175# VGND sky130_fd_pr__nfet_01v8 ad=0.08775 pd=0.92 as=0.08775 ps=0.92 w=0.65 l=0.15
X153 a_2479_9269# a_2766_9427# VPWR VPWR sky130_fd_pr__pfet_01v8_hvt ad=0.0567 pd=0.69 as=0.1134 ps=1.38 w=0.42 l=0.15
X154 VPWR a_3491_5247# a_3478_4943# VPWR sky130_fd_pr__pfet_01v8_hvt ad=0.0819 pd=0.81 as=0.0567 ps=0.69 w=0.42 l=0.15
X155 VPWR VGND VPWR VPWR sky130_fd_pr__pfet_01v8_hvt ad=0.2262 pd=2.26 as=0 ps=0 w=0.87 l=0.59
X156 VPWR VGND VPWR VPWR sky130_fd_pr__pfet_01v8_hvt ad=0.2262 pd=2.26 as=0 ps=0 w=0.87 l=0.59
X157 VPWR a_5069_2767# a_5175_2767# VPWR sky130_fd_pr__pfet_01v8_hvt ad=0.14075 pd=1.325 as=0.1092 ps=1.36 w=0.42 l=0.5
X158 VPWR a_2856_4399# a_3031_4373# VPWR sky130_fd_pr__pfet_01v8_hvt ad=0.1134 pd=1.38 as=0.0567 ps=0.69 w=0.42 l=0.15
X159 a_7167_4233# a_6817_3861# a_7072_4221# VPWR sky130_fd_pr__pfet_01v8_hvt ad=0.07245 pd=0.765 as=0.0651 ps=0.73 w=0.42 l=0.15
X160 VPWR VGND VPWR VPWR sky130_fd_pr__pfet_01v8_hvt ad=0.2262 pd=2.26 as=0 ps=0 w=0.87 l=0.59
X161 VGND a_4032_7351# a_3992_7235# VGND sky130_fd_pr__nfet_01v8 ad=0.0567 pd=0.69 as=0.1092 ps=1.36 w=0.42 l=0.15
X162 VPWR VGND VPWR VPWR sky130_fd_pr__pfet_01v8_hvt ad=0.2262 pd=2.26 as=0 ps=0 w=0.87 l=0.59
X163 VPWR _28_.A _52_.Y VPWR sky130_fd_pr__pfet_01v8_hvt ad=0.26 pd=2.52 as=0.135 ps=1.27 w=1 l=0.15
X164 xa a_8911_8207# VPWR VPWR sky130_fd_pr__pfet_01v8_hvt ad=0.495 pd=2.99 as=0.2726 ps=1.61 w=1 l=0.15
X165 a_2360_7119# a_2143_7119# VPWR VPWR sky130_fd_pr__pfet_01v8_hvt ad=0.2173 pd=2.17 as=0.19265 ps=1.415 w=0.82 l=0.25
X166 VGND a_3992_7235# _41_.C1 VGND sky130_fd_pr__nfet_01v8 ad=0.10025 pd=0.985 as=0.08775 ps=0.92 w=0.65 l=0.15
X167 VPWR VGND VPWR VPWR sky130_fd_pr__pfet_01v8_hvt ad=0.2262 pd=2.26 as=0 ps=0 w=0.87 l=0.59
X168 VPWR VGND VPWR VPWR sky130_fd_pr__pfet_01v8_hvt ad=0.2262 pd=2.26 as=0 ps=0 w=0.87 l=0.59
X169 VGND src[0] a_2143_7119# VGND sky130_fd_pr__nfet_01v8 ad=0.1228 pd=1.065 as=0.1134 ps=1.38 w=0.42 l=0.15
X170 a_2196_4399# _27_.Y VPWR VPWR sky130_fd_pr__pfet_01v8_hvt ad=0.0651 pd=0.73 as=0.1092 ps=1.36 w=0.42 l=0.15
X171 a_7275_3855# a_6651_3861# a_7167_4233# VPWR sky130_fd_pr__pfet_01v8_hvt ad=0.1155 pd=0.97 as=0.07245 ps=0.765 w=0.42 l=0.15
X172 VGND VPWR VGND VGND sky130_fd_pr__nfet_01v8 ad=0.143 pd=1.62 as=0 ps=0 w=0.55 l=0.59
X173 VPWR _48_.Y a_4351_9301# VPWR sky130_fd_pr__pfet_01v8_hvt ad=0.0864 pd=0.91 as=0.1664 ps=1.8 w=0.64 l=0.15
X174 VPWR u_loop.u_gh.C output6.A VPWR sky130_fd_pr__pfet_01v8_hvt ad=0.135 pd=1.27 as=0.135 ps=1.27 w=1 l=0.15
X175 VPWR u_loop.u_d2.X a_3361_2767# VPWR sky130_fd_pr__pfet_01v8_hvt ad=0.0567 pd=0.69 as=0.1092 ps=1.36 w=0.42 l=0.15
X176 VGND a_2125_2767# a_2231_2767# VGND sky130_fd_pr__nfet_01v8 ad=0.097 pd=0.975 as=0.1092 ps=1.36 w=0.42 l=0.5
X177 VPWR VGND VPWR VPWR sky130_fd_pr__pfet_01v8_hvt ad=0.2262 pd=2.26 as=0 ps=0 w=0.87 l=0.59
X178 VGND VPWR VGND VGND sky130_fd_pr__nfet_01v8 ad=0.143 pd=1.62 as=0 ps=0 w=0.55 l=0.59
X179 VGND VPWR VGND VGND sky130_fd_pr__nfet_01v8 ad=0.143 pd=1.62 as=0 ps=0 w=0.55 l=0.59
X180 VGND u_loop.u_gh.C a_2553_4399# VGND sky130_fd_pr__nfet_01v8 ad=0.1346 pd=1.15 as=0.0441 ps=0.63 w=0.42 l=0.15
X181 a_2509_4641# a_2291_4399# VPWR VPWR sky130_fd_pr__pfet_01v8_hvt ad=0.12915 pd=1.185 as=0.2184 ps=2.2 w=0.84 l=0.15
X182 a_4076_3561# u_loop.u_gl.A2 VPWR VPWR sky130_fd_pr__pfet_01v8_hvt ad=0.14 pd=1.28 as=0.14 ps=1.28 w=1 l=0.15
X183 _23_.A a_3399_6335# VPWR VPWR sky130_fd_pr__pfet_01v8_hvt ad=0.135 pd=1.27 as=0.3012 ps=2.66 w=1 l=0.15
X184 a_7443_5487# a_6927_5487# a_7348_5487# VGND sky130_fd_pr__special_nfet_01v8 ad=0.0594 pd=0.69 as=0.066 ps=0.745 w=0.36 l=0.15
X185 VPWR a_8183_5461# a_8170_5853# VPWR sky130_fd_pr__pfet_01v8_hvt ad=0.0819 pd=0.81 as=0.0567 ps=0.69 w=0.42 l=0.15
X186 VGND VPWR VGND VGND sky130_fd_pr__nfet_01v8 ad=0.143 pd=1.62 as=0 ps=0 w=0.55 l=0.59
X187 VPWR _40_.B _62_.D VPWR sky130_fd_pr__pfet_01v8_hvt ad=0.26 pd=2.52 as=0.135 ps=1.27 w=1 l=0.15
X188 VGND VPWR VGND VGND sky130_fd_pr__nfet_01v8 ad=0.143 pd=1.62 as=0 ps=0 w=0.55 l=0.59
X189 a_3333_6409# a_2143_6037# a_3224_6409# VGND sky130_fd_pr__special_nfet_01v8 ad=0.0669 pd=0.75 as=0.0711 ps=0.755 w=0.36 l=0.15
X190 VGND a_4910_2197# prenh VGND sky130_fd_pr__nfet_01v8 ad=0.1856 pd=1.26 as=0.2079 ps=1.83 w=0.42 l=0.15
X191 VGND VPWR VGND VGND sky130_fd_pr__nfet_01v8 ad=0.143 pd=1.62 as=0 ps=0 w=0.55 l=0.59
X192 VPWR VGND VPWR VPWR sky130_fd_pr__pfet_01v8_hvt ad=0.2262 pd=2.26 as=0 ps=0 w=0.87 l=0.59
X193 a_8630_7119# a_7553_7125# a_8468_7497# VPWR sky130_fd_pr__pfet_01v8_hvt ad=0.0567 pd=0.69 as=0.0588 ps=0.7 w=0.42 l=0.15
X194 _55_.Q a_7907_4159# VGND VGND sky130_fd_pr__nfet_01v8 ad=0.08775 pd=0.92 as=0.2087 ps=2.02 w=0.65 l=0.15
X195 VPWR u_loop.u_q.Y output6.A VPWR sky130_fd_pr__pfet_01v8_hvt ad=0.27 pd=2.54 as=0.135 ps=1.27 w=1 l=0.15
X196 VPWR a_5607_9599# _39_.B2 VPWR sky130_fd_pr__pfet_01v8_hvt ad=0.26 pd=2.52 as=0.135 ps=1.27 w=1 l=0.15
X197 VPWR VGND VPWR VPWR sky130_fd_pr__pfet_01v8_hvt ad=0.2262 pd=2.26 as=0 ps=0 w=0.87 l=0.59
X198 VGND VPWR VGND VGND sky130_fd_pr__nfet_01v8 ad=0.143 pd=1.62 as=0 ps=0 w=0.55 l=0.59
X199 VGND VPWR VGND VGND sky130_fd_pr__nfet_01v8 ad=0.143 pd=1.62 as=0 ps=0 w=0.55 l=0.59
X200 VPWR VGND VPWR VPWR sky130_fd_pr__pfet_01v8_hvt ad=0.2262 pd=2.26 as=0 ps=0 w=0.87 l=0.59
X201 a_2755_6409# a_2309_6037# a_2659_6409# VGND sky130_fd_pr__special_nfet_01v8 ad=0.1401 pd=1.1 as=0.0594 ps=0.69 w=0.36 l=0.15
X202 a_5129_9661# a_5085_9269# a_4963_9673# VGND sky130_fd_pr__nfet_01v8 ad=0.0441 pd=0.63 as=0.1401 ps=1.1 w=0.42 l=0.15
X203 VPWR a_3859_8511# a_3846_8207# VPWR sky130_fd_pr__pfet_01v8_hvt ad=0.0819 pd=0.81 as=0.0567 ps=0.69 w=0.42 l=0.15
X204 VPWR VGND VPWR VPWR sky130_fd_pr__pfet_01v8_hvt ad=0.2262 pd=2.26 as=0 ps=0 w=0.87 l=0.59
X205 VPWR VGND VPWR VPWR sky130_fd_pr__pfet_01v8_hvt ad=0.2262 pd=2.26 as=0 ps=0 w=0.87 l=0.59
X206 VPWR a_4333_2767# a_4439_2767# VPWR sky130_fd_pr__pfet_01v8_hvt ad=0.14075 pd=1.325 as=0.1092 ps=1.36 w=0.42 l=0.5
X207 VPWR u_loop.u_d0.A a_4076_3561# VPWR sky130_fd_pr__pfet_01v8_hvt ad=0.14 pd=1.28 as=0.14 ps=1.28 w=1 l=0.15
X208 VGND VPWR VGND VGND sky130_fd_pr__nfet_01v8 ad=0.143 pd=1.62 as=0 ps=0 w=0.55 l=0.59
X209 VPWR VGND VPWR VPWR sky130_fd_pr__pfet_01v8_hvt ad=0.2262 pd=2.26 as=0 ps=0 w=0.87 l=0.59
X210 _36_.A a_4167_6147# VPWR VPWR sky130_fd_pr__pfet_01v8_hvt ad=0.165 pd=1.33 as=0.1468 ps=1.34 w=1 l=0.15
X211 u_loop.u_d2.X a_2967_2767# VGND VGND sky130_fd_pr__nfet_01v8 ad=0.169 pd=1.82 as=0.097 ps=0.975 w=0.65 l=0.15
X212 a_6141_4399# a_6097_4641# a_5975_4399# VGND sky130_fd_pr__nfet_01v8 ad=0.0441 pd=0.63 as=0.1401 ps=1.1 w=0.42 l=0.15
X213 VGND VPWR VGND VGND sky130_fd_pr__nfet_01v8 ad=0.143 pd=1.62 as=0 ps=0 w=0.55 l=0.59
X214 _68_.Q a_8643_7423# VGND VGND sky130_fd_pr__nfet_01v8 ad=0.08775 pd=0.92 as=0.2087 ps=2.02 w=0.65 l=0.15
X215 VPWR a_7109_6005# a_6999_6031# VPWR sky130_fd_pr__pfet_01v8_hvt ad=0.07035 pd=0.755 as=0.1155 ps=0.97 w=0.42 l=0.15
X216 VPWR VGND VPWR VPWR sky130_fd_pr__pfet_01v8_hvt ad=0.2262 pd=2.26 as=0 ps=0 w=0.87 l=0.59
X217 VPWR VGND VPWR VPWR sky130_fd_pr__pfet_01v8_hvt ad=0.2262 pd=2.26 as=0 ps=0 w=0.87 l=0.59
X218 _35_.A_N a_2471_7119# VGND VGND sky130_fd_pr__nfet_01v8 ad=0.2079 pd=1.83 as=0.1856 ps=1.26 w=0.42 l=0.15
X219 a_7456_6409# a_6541_6037# a_7109_6005# VGND sky130_fd_pr__special_nfet_01v8 ad=0.0711 pd=0.755 as=0.0999 ps=0.985 w=0.36 l=0.15
X220 VPWR VGND VPWR VPWR sky130_fd_pr__pfet_01v8_hvt ad=0.2262 pd=2.26 as=0 ps=0 w=0.87 l=0.59
X221 VGND u_loop.u_gh.C a_2801_9661# VGND sky130_fd_pr__nfet_01v8 ad=0.12495 pd=1.015 as=0.06405 ps=0.725 w=0.42 l=0.15
X222 VGND a_3859_8511# _40_.B VGND sky130_fd_pr__nfet_01v8 ad=0.169 pd=1.82 as=0.08775 ps=0.92 w=0.65 l=0.15
X223 VGND VPWR VGND VGND sky130_fd_pr__nfet_01v8 ad=0.143 pd=1.62 as=0 ps=0 w=0.55 l=0.59
X224 VPWR VGND VPWR VPWR sky130_fd_pr__pfet_01v8_hvt ad=0.2262 pd=2.26 as=0 ps=0 w=0.87 l=0.59
X225 VPWR a_3070_6549# u_loop.u_gh.C VPWR sky130_fd_pr__pfet_01v8_hvt ad=0.2726 pd=1.61 as=0.495 ps=2.99 w=1 l=0.15
X226 a_3083_9537# _49_.Y VGND VGND sky130_fd_pr__nfet_01v8 ad=0.1092 pd=1.36 as=0.0567 ps=0.69 w=0.42 l=0.15
X227 _39_.B2 a_5607_9599# VGND VGND sky130_fd_pr__nfet_01v8 ad=0.08775 pd=0.92 as=0.2087 ps=2.02 w=0.65 l=0.15
X228 _49_.Y _40_.B VGND VGND sky130_fd_pr__nfet_01v8 ad=0.08775 pd=0.92 as=0.169 ps=1.82 w=0.65 l=0.15
X229 VGND _30_.A _30_.Y VGND sky130_fd_pr__nfet_01v8 ad=0.169 pd=1.82 as=0.08775 ps=0.92 w=0.65 l=0.15
X230 VPWR en a_2235_6575# VPWR sky130_fd_pr__pfet_01v8_hvt ad=0.19265 pd=1.415 as=0.27 ps=2.54 w=1 l=0.15
X231 a_6796_6397# _32_.Y VGND VGND sky130_fd_pr__nfet_01v8 ad=0.066 pd=0.745 as=0.2205 ps=1.89 w=0.42 l=0.15
X232 VPWR a_2479_9269# _30_.A VPWR sky130_fd_pr__pfet_01v8_hvt ad=0.3012 pd=2.66 as=0.135 ps=1.27 w=1 l=0.15
X233 VPWR a_3239_9269# a_3170_9295# VPWR sky130_fd_pr__pfet_01v8_hvt ad=0.2184 pd=2.2 as=0.12915 ps=1.185 w=0.84 l=0.15
X234 VGND a_5190_7439# _39_.X VGND sky130_fd_pr__nfet_01v8 ad=0.169 pd=1.82 as=0.08775 ps=0.92 w=0.65 l=0.15
X235 VGND u_loop.u_gh.C a_3013_5309# VGND sky130_fd_pr__nfet_01v8 ad=0.1346 pd=1.15 as=0.0441 ps=0.63 w=0.42 l=0.15
X236 a_3793_8585# a_2603_8213# a_3684_8585# VGND sky130_fd_pr__special_nfet_01v8 ad=0.0669 pd=0.75 as=0.0711 ps=0.755 w=0.36 l=0.15
X237 VGND VPWR VGND VGND sky130_fd_pr__nfet_01v8 ad=0.143 pd=1.62 as=0 ps=0 w=0.55 l=0.59
X238 output7.A u_loop.u_gl.B1 VGND VGND sky130_fd_pr__nfet_01v8 ad=0.091 pd=0.93 as=0.091 ps=0.93 w=0.65 l=0.15
X239 VGND VPWR VGND VGND sky130_fd_pr__nfet_01v8 ad=0.143 pd=1.62 as=0 ps=0 w=0.55 l=0.59
X240 VPWR a_2755_7637# a_2742_8029# VPWR sky130_fd_pr__pfet_01v8_hvt ad=0.0819 pd=0.81 as=0.0567 ps=0.69 w=0.42 l=0.15
X241 VPWR a_8121_4917# a_8011_4943# VPWR sky130_fd_pr__pfet_01v8_hvt ad=0.07035 pd=0.755 as=0.1155 ps=0.97 w=0.42 l=0.15
X242 a_5987_4765# _55_.RESET_B VPWR VPWR sky130_fd_pr__pfet_01v8_hvt ad=0.1092 pd=1.36 as=0.07035 ps=0.755 w=0.42 l=0.15
X243 _56_.CLK _32_.A VGND VGND sky130_fd_pr__nfet_01v8 ad=0.08775 pd=0.92 as=0.169 ps=1.82 w=0.65 l=0.15
X244 a_2751_5321# a_2235_4949# a_2656_5309# VGND sky130_fd_pr__special_nfet_01v8 ad=0.0594 pd=0.69 as=0.066 ps=0.745 w=0.36 l=0.15
X245 VPWR u_loop.u_d7.X a_6457_2473# VPWR sky130_fd_pr__pfet_01v8_hvt ad=0.26 pd=2.52 as=0.105 ps=1.21 w=1 l=0.15
X246 VGND u_loop.u_d5.X a_5569_2767# VGND sky130_fd_pr__nfet_01v8 ad=0.0567 pd=0.69 as=0.1092 ps=1.36 w=0.42 l=0.15
X247 a_7385_3829# a_7167_4233# VGND VGND sky130_fd_pr__nfet_01v8 ad=0.0999 pd=0.985 as=0.1346 ps=1.15 w=0.64 l=0.15
X248 _31_.Y _46_.A VPWR VPWR sky130_fd_pr__pfet_01v8_hvt ad=0.135 pd=1.27 as=0.26 ps=2.52 w=1 l=0.15
X249 VPWR _53_.Y a_2235_4949# VPWR sky130_fd_pr__pfet_01v8_hvt ad=0.0864 pd=0.91 as=0.1664 ps=1.8 w=0.64 l=0.15
X250 VPWR output7.A a_4075_2223# VPWR sky130_fd_pr__pfet_01v8_hvt ad=0.19265 pd=1.415 as=0.27 ps=2.54 w=1 l=0.15
X251 VPWR a_6444_4399# a_6619_4373# VPWR sky130_fd_pr__pfet_01v8_hvt ad=0.1134 pd=1.38 as=0.0567 ps=0.69 w=0.42 l=0.15
X252 a_5989_8751# a_5823_8751# VGND VGND sky130_fd_pr__nfet_01v8 ad=0.1092 pd=1.36 as=0.0567 ps=0.69 w=0.42 l=0.15
X253 VPWR a_5691_3829# u_loop.u_d0.A VPWR sky130_fd_pr__pfet_01v8_hvt ad=0.1625 pd=1.325 as=0.135 ps=1.27 w=1 l=0.15
X254 a_4518_6825# _35_.A_N VPWR VPWR sky130_fd_pr__pfet_01v8_hvt ad=0.135 pd=1.27 as=0.135 ps=1.27 w=1 l=0.15
X255 VPWR VGND VPWR VPWR sky130_fd_pr__pfet_01v8_hvt ad=0.2262 pd=2.26 as=0 ps=0 w=0.87 l=0.59
X256 u_loop.u_qb.A u_loop.u_s1.Y VPWR VPWR sky130_fd_pr__pfet_01v8_hvt ad=0.26 pd=2.52 as=0.26 ps=2.52 w=1 l=0.15
X257 VPWR VGND VPWR VPWR sky130_fd_pr__pfet_01v8_hvt ad=0.2262 pd=2.26 as=0 ps=0 w=0.87 l=0.59
X258 a_3070_6549# a_3196_6733# VGND VGND sky130_fd_pr__nfet_01v8 ad=0.17225 pd=1.83 as=0.1856 ps=1.26 w=0.65 l=0.25
X259 VGND VPWR VGND VGND sky130_fd_pr__nfet_01v8 ad=0.143 pd=1.62 as=0 ps=0 w=0.55 l=0.59
X260 a_3859_8511# u_loop.u_gh.C VPWR VPWR sky130_fd_pr__pfet_01v8_hvt ad=0.0567 pd=0.69 as=0.0819 ps=0.81 w=0.42 l=0.15
X261 a_8643_7423# a_8468_7497# a_8822_7485# VGND sky130_fd_pr__nfet_01v8 ad=0.1092 pd=1.36 as=0.06405 ps=0.725 w=0.42 l=0.15
X262 VPWR a_3224_6409# a_3399_6335# VPWR sky130_fd_pr__pfet_01v8_hvt ad=0.1134 pd=1.38 as=0.0567 ps=0.69 w=0.42 l=0.15
X263 input5.X a_5875_2223# VGND VGND sky130_fd_pr__nfet_01v8 ad=0.2079 pd=1.83 as=0.1856 ps=1.26 w=0.42 l=0.15
X264 output6.A u_loop.u_q.Y a_4769_4175# VGND sky130_fd_pr__nfet_01v8 ad=0.08775 pd=0.92 as=0.08775 ps=0.92 w=0.65 l=0.15
X265 a_5293_5487# _56_.Q a_5377_5487# VGND sky130_fd_pr__nfet_01v8 ad=0.169 pd=1.82 as=0.08775 ps=0.92 w=0.65 l=0.15
X266 VPWR u_loop.u_gh.C output6.A VPWR sky130_fd_pr__pfet_01v8_hvt ad=0.135 pd=1.27 as=0.135 ps=1.27 w=1 l=0.15
X267 a_5784_4399# _56_.D VPWR VPWR sky130_fd_pr__pfet_01v8_hvt ad=0.0651 pd=0.73 as=0.1092 ps=1.36 w=0.42 l=0.15
X268 VPWR VGND VPWR VPWR sky130_fd_pr__pfet_01v8_hvt ad=0.2262 pd=2.26 as=0 ps=0 w=0.87 l=0.59
X269 VGND a_8800_6031# a_8911_6031# VGND sky130_fd_pr__nfet_01v8 ad=0.1856 pd=1.26 as=0.17225 ps=1.83 w=0.65 l=0.25
X270 VPWR u_loop.u_gl.A2 a_4076_3561# VPWR sky130_fd_pr__pfet_01v8_hvt ad=0.14 pd=1.28 as=0.14 ps=1.28 w=1 l=0.15
X271 VGND a_3597_2767# a_3703_2767# VGND sky130_fd_pr__nfet_01v8 ad=0.097 pd=0.975 as=0.1092 ps=1.36 w=0.42 l=0.5
X272 VPWR a_4292_2223# a_4403_2223# VPWR sky130_fd_pr__pfet_01v8_hvt ad=0.2726 pd=1.61 as=0.2173 ps=2.17 w=0.82 l=0.25
X273 a_7275_3855# _55_.RESET_B VPWR VPWR sky130_fd_pr__pfet_01v8_hvt ad=0.1092 pd=1.36 as=0.07035 ps=0.755 w=0.42 l=0.15
X274 VPWR src[1] a_1407_7119# VPWR sky130_fd_pr__pfet_01v8_hvt ad=0.19265 pd=1.415 as=0.27 ps=2.54 w=1 l=0.15
X275 a_2564_6397# _23_.Y VPWR VPWR sky130_fd_pr__pfet_01v8_hvt ad=0.0651 pd=0.73 as=0.1092 ps=1.36 w=0.42 l=0.15
X276 a_6619_4373# a_6444_4399# a_6798_4399# VGND sky130_fd_pr__nfet_01v8 ad=0.1092 pd=1.36 as=0.06405 ps=0.725 w=0.42 l=0.15
X277 a_5607_9599# a_5432_9673# a_5786_9661# VGND sky130_fd_pr__nfet_01v8 ad=0.1092 pd=1.36 as=0.06405 ps=0.725 w=0.42 l=0.15
X278 _34_.B1 a_2563_6575# VPWR VPWR sky130_fd_pr__pfet_01v8_hvt ad=0.495 pd=2.99 as=0.2726 ps=1.61 w=1 l=0.15
X279 VPWR VGND VPWR VPWR sky130_fd_pr__pfet_01v8_hvt ad=0.2262 pd=2.26 as=0 ps=0 w=0.87 l=0.59
X280 _32_.A a_7631_6335# VPWR VPWR sky130_fd_pr__pfet_01v8_hvt ad=0.135 pd=1.27 as=0.3012 ps=2.66 w=1 l=0.15
X281 VGND VPWR VGND VGND sky130_fd_pr__nfet_01v8 ad=0.143 pd=1.62 as=0 ps=0 w=0.55 l=0.59
X282 VPWR u_loop.u_q.Y output6.A VPWR sky130_fd_pr__pfet_01v8_hvt ad=0.135 pd=1.27 as=0.135 ps=1.27 w=1 l=0.15
X283 VPWR _56_.CLK a_5363_4399# VPWR sky130_fd_pr__pfet_01v8_hvt ad=0.0864 pd=0.91 as=0.1664 ps=1.8 w=0.64 l=0.15
X284 a_5085_9269# a_4867_9673# VGND VGND sky130_fd_pr__nfet_01v8 ad=0.0999 pd=0.985 as=0.1346 ps=1.15 w=0.64 l=0.15
X285 VGND u_loop.u_gh.C a_8165_5309# VGND sky130_fd_pr__nfet_01v8 ad=0.1346 pd=1.15 as=0.0441 ps=0.63 w=0.42 l=0.15
X286 VGND a_8643_5247# _25_.A VGND sky130_fd_pr__nfet_01v8 ad=0.169 pd=1.82 as=0.08775 ps=0.92 w=0.65 l=0.15
X287 VGND VPWR VGND VGND sky130_fd_pr__nfet_01v8 ad=0.143 pd=1.62 as=0 ps=0 w=0.55 l=0.59
X288 _46_.Y _46_.A VPWR VPWR sky130_fd_pr__pfet_01v8_hvt ad=0.135 pd=1.27 as=0.26 ps=2.52 w=1 l=0.15
X289 VPWR _20_.Y a_1499_6575# VPWR sky130_fd_pr__pfet_01v8_hvt ad=0.14 pd=1.28 as=0.265 ps=2.53 w=1 l=0.15
X290 u_loop.u_d1.X a_2875_2223# VPWR VPWR sky130_fd_pr__pfet_01v8_hvt ad=0.26 pd=2.52 as=0.14075 ps=1.325 w=1 l=0.15
X291 VPWR u_loop.u_gh.B output6.A VPWR sky130_fd_pr__pfet_01v8_hvt ad=0.26 pd=2.52 as=0.135 ps=1.27 w=1 l=0.15
X292 VGND _39_.X a_7387_7125# VGND sky130_fd_pr__nfet_01v8 ad=0.0567 pd=0.69 as=0.1092 ps=1.36 w=0.42 l=0.15
X293 VGND VPWR VGND VGND sky130_fd_pr__nfet_01v8 ad=0.143 pd=1.62 as=0 ps=0 w=0.55 l=0.59
X294 VPWR VGND VPWR VPWR sky130_fd_pr__pfet_01v8_hvt ad=0.2262 pd=2.26 as=0 ps=0 w=0.87 l=0.59
X295 VPWR VGND VPWR VPWR sky130_fd_pr__pfet_01v8_hvt ad=0.2262 pd=2.26 as=0 ps=0 w=0.87 l=0.59
X296 VGND u_loop.u_d0.A a_1889_2767# VGND sky130_fd_pr__nfet_01v8 ad=0.0567 pd=0.69 as=0.1092 ps=1.36 w=0.42 l=0.15
X297 VGND _55_.CLK a_6651_3861# VGND sky130_fd_pr__nfet_01v8 ad=0.0567 pd=0.69 as=0.1092 ps=1.36 w=0.42 l=0.15
X298 VGND _55_.Q _55_.D VGND sky130_fd_pr__nfet_01v8 ad=0.169 pd=1.82 as=0.08775 ps=0.92 w=0.65 l=0.15
X299 VPWR VGND VPWR VPWR sky130_fd_pr__pfet_01v8_hvt ad=0.2262 pd=2.26 as=0 ps=0 w=0.87 l=0.59
X300 VPWR VGND VPWR VPWR sky130_fd_pr__pfet_01v8_hvt ad=0.2262 pd=2.26 as=0 ps=0 w=0.87 l=0.59
X301 _41_.B1 a_4160_6575# a_4518_6825# VPWR sky130_fd_pr__pfet_01v8_hvt ad=0.135 pd=1.27 as=0.26 ps=2.52 w=1 l=0.15
X302 VPWR pre a_1407_6031# VPWR sky130_fd_pr__pfet_01v8_hvt ad=0.19265 pd=1.415 as=0.27 ps=2.54 w=1 l=0.15
X303 a_2751_5321# a_2401_4949# a_2656_5309# VPWR sky130_fd_pr__pfet_01v8_hvt ad=0.07245 pd=0.765 as=0.0651 ps=0.73 w=0.42 l=0.15
X304 a_2509_4641# a_2291_4399# VGND VGND sky130_fd_pr__nfet_01v8 ad=0.0999 pd=0.985 as=0.1346 ps=1.15 w=0.64 l=0.15
X305 a_3597_2767# a_3361_2767# VGND VGND sky130_fd_pr__nfet_01v8 ad=0.1092 pd=1.36 as=0.0567 ps=0.69 w=0.42 l=0.5
X306 a_6704_7663# _22_.Y VGND VGND sky130_fd_pr__nfet_01v8 ad=0.066 pd=0.745 as=0.2205 ps=1.89 w=0.42 l=0.15
X307 a_4910_2197# a_5036_2381# VGND VGND sky130_fd_pr__nfet_01v8 ad=0.17225 pd=1.83 as=0.1856 ps=1.26 w=0.65 l=0.25
X308 VPWR VGND VPWR VPWR sky130_fd_pr__pfet_01v8_hvt ad=0.2262 pd=2.26 as=0 ps=0 w=0.87 l=0.59
X309 a_3024_8573# _62_.D VGND VGND sky130_fd_pr__nfet_01v8 ad=0.066 pd=0.745 as=0.2205 ps=1.89 w=0.42 l=0.15
X310 a_6449_7663# a_6283_7663# VGND VGND sky130_fd_pr__nfet_01v8 ad=0.1092 pd=1.36 as=0.0567 ps=0.69 w=0.42 l=0.15
X311 VGND a_2769_2223# a_2875_2223# VGND sky130_fd_pr__nfet_01v8 ad=0.097 pd=0.975 as=0.1092 ps=1.36 w=0.42 l=0.5
X312 a_7385_3829# a_7167_4233# VPWR VPWR sky130_fd_pr__pfet_01v8_hvt ad=0.12915 pd=1.185 as=0.2184 ps=2.2 w=0.84 l=0.15
X313 a_5691_3829# u_loop.u_q.Y VPWR VPWR sky130_fd_pr__pfet_01v8_hvt ad=0.265 pd=2.53 as=0.1625 ps=1.325 w=1 l=0.15
X314 a_2769_8213# a_2603_8213# VGND VGND sky130_fd_pr__nfet_01v8 ad=0.1092 pd=1.36 as=0.0567 ps=0.69 w=0.42 l=0.15
X315 prenl a_4403_2223# VPWR VPWR sky130_fd_pr__pfet_01v8_hvt ad=0.495 pd=2.99 as=0.2726 ps=1.61 w=1 l=0.15
X316 VPWR VGND VPWR VPWR sky130_fd_pr__pfet_01v8_hvt ad=0.2262 pd=2.26 as=0 ps=0 w=0.87 l=0.59
X317 VPWR VGND VPWR VPWR sky130_fd_pr__pfet_01v8_hvt ad=0.2262 pd=2.26 as=0 ps=0 w=0.87 l=0.59
X318 VPWR _42_.Y a_7387_4949# VPWR sky130_fd_pr__pfet_01v8_hvt ad=0.0864 pd=0.91 as=0.1664 ps=1.8 w=0.64 l=0.15
X319 VPWR a_5805_2767# a_5911_2767# VPWR sky130_fd_pr__pfet_01v8_hvt ad=0.14075 pd=1.325 as=0.1092 ps=1.36 w=0.42 l=0.5
X320 VGND VPWR VGND VGND sky130_fd_pr__nfet_01v8 ad=0.143 pd=1.62 as=0 ps=0 w=0.55 l=0.59
X321 VPWR VGND VPWR VPWR sky130_fd_pr__pfet_01v8_hvt ad=0.2262 pd=2.26 as=0 ps=0 w=0.87 l=0.59
X322 a_3316_5321# a_2401_4949# a_2969_4917# VGND sky130_fd_pr__special_nfet_01v8 ad=0.0711 pd=0.755 as=0.0999 ps=0.985 w=0.36 l=0.15
X323 u_loop.u_d4.X a_4439_2767# VGND VGND sky130_fd_pr__nfet_01v8 ad=0.169 pd=1.82 as=0.097 ps=0.975 w=0.65 l=0.15
X324 VPWR VGND VPWR VPWR sky130_fd_pr__pfet_01v8_hvt ad=0.2262 pd=2.26 as=0 ps=0 w=0.87 l=0.59
X325 _25_.A a_8643_5247# VPWR VPWR sky130_fd_pr__pfet_01v8_hvt ad=0.135 pd=1.27 as=0.3012 ps=2.66 w=1 l=0.15
X326 VPWR VGND VPWR VPWR sky130_fd_pr__pfet_01v8_hvt ad=0.2262 pd=2.26 as=0 ps=0 w=0.87 l=0.59
X327 VPWR VGND VPWR VPWR sky130_fd_pr__pfet_01v8_hvt ad=0.2262 pd=2.26 as=0 ps=0 w=0.87 l=0.59
X328 a_8121_7093# a_7903_7497# VGND VGND sky130_fd_pr__nfet_01v8 ad=0.0999 pd=0.985 as=0.1346 ps=1.15 w=0.64 l=0.15
X329 VPWR a_6633_2767# a_6739_2767# VPWR sky130_fd_pr__pfet_01v8_hvt ad=0.14075 pd=1.325 as=0.1092 ps=1.36 w=0.42 l=0.5
X330 a_7732_4233# a_6651_3861# a_7385_3829# VPWR sky130_fd_pr__pfet_01v8_hvt ad=0.0588 pd=0.7 as=0.12915 ps=1.185 w=0.42 l=0.15
X331 VGND VPWR VGND VGND sky130_fd_pr__nfet_01v8 ad=0.143 pd=1.62 as=0 ps=0 w=0.55 l=0.59
X332 VPWR a_8183_5461# _67_.Q VPWR sky130_fd_pr__pfet_01v8_hvt ad=0.26 pd=2.52 as=0.135 ps=1.27 w=1 l=0.15
X333 VGND VPWR VGND VGND sky130_fd_pr__nfet_01v8 ad=0.143 pd=1.62 as=0 ps=0 w=0.55 l=0.59
X334 VPWR VGND VPWR VPWR sky130_fd_pr__pfet_01v8_hvt ad=0.2262 pd=2.26 as=0 ps=0 w=0.87 l=0.59
X335 VPWR VGND VPWR VPWR sky130_fd_pr__pfet_01v8_hvt ad=0.2262 pd=2.26 as=0 ps=0 w=0.87 l=0.59
X336 VPWR VGND VPWR VPWR sky130_fd_pr__pfet_01v8_hvt ad=0.2262 pd=2.26 as=0 ps=0 w=0.87 l=0.59
X337 _35_.B a_1735_7119# VPWR VPWR sky130_fd_pr__pfet_01v8_hvt ad=0.495 pd=2.99 as=0.2726 ps=1.61 w=1 l=0.15
X338 VGND VPWR VGND VGND sky130_fd_pr__nfet_01v8 ad=0.143 pd=1.62 as=0 ps=0 w=0.55 l=0.59
X339 a_2769_2223# a_2533_2223# VGND VGND sky130_fd_pr__nfet_01v8 ad=0.1092 pd=1.36 as=0.0567 ps=0.69 w=0.42 l=0.5
X340 u_loop.u_s1.Y u_loop.u_cmp.Y VGND VGND sky130_fd_pr__nfet_01v8 ad=0.169 pd=1.82 as=0.169 ps=1.82 w=0.65 l=0.15
X341 VGND u_loop.u_gl.B1 output7.A VGND sky130_fd_pr__nfet_01v8 ad=0.104 pd=0.97 as=0.091 ps=0.93 w=0.65 l=0.15
X342 xb a_8911_6031# VGND VGND sky130_fd_pr__nfet_01v8 ad=0.2079 pd=1.83 as=0.1856 ps=1.26 w=0.42 l=0.15
X343 a_7443_5487# a_7093_5487# a_7348_5487# VPWR sky130_fd_pr__pfet_01v8_hvt ad=0.07245 pd=0.765 as=0.0651 ps=0.73 w=0.42 l=0.15
X344 VPWR VGND VPWR VPWR sky130_fd_pr__pfet_01v8_hvt ad=0.2262 pd=2.26 as=0 ps=0 w=0.87 l=0.59
X345 VGND VPWR VGND VGND sky130_fd_pr__nfet_01v8 ad=0.143 pd=1.62 as=0 ps=0 w=0.55 l=0.59
X346 a_4369_6351# _35_.B VGND VGND sky130_fd_pr__nfet_01v8 ad=0.169 pd=1.82 as=0.08775 ps=0.92 w=0.65 l=0.15
X347 VGND VPWR VGND VGND sky130_fd_pr__nfet_01v8 ad=0.143 pd=1.62 as=0 ps=0 w=0.55 l=0.59
X348 a_5276_2197# output6.A VGND VGND sky130_fd_pr__nfet_01v8 ad=0.1134 pd=1.38 as=0.1228 ps=1.065 w=0.42 l=0.15
X349 VGND VPWR VGND VGND sky130_fd_pr__nfet_01v8 ad=0.143 pd=1.62 as=0 ps=0 w=0.55 l=0.59
X350 VGND _53_.A _27_.Y VGND sky130_fd_pr__nfet_01v8 ad=0.169 pd=1.82 as=0.08775 ps=0.92 w=0.65 l=0.15
X351 VPWR VGND VPWR VPWR sky130_fd_pr__pfet_01v8_hvt ad=0.2262 pd=2.26 as=0 ps=0 w=0.87 l=0.59
X352 _38_.X a_3348_7235# VPWR VPWR sky130_fd_pr__pfet_01v8_hvt ad=0.135 pd=1.27 as=0.14825 ps=1.34 w=1 l=0.15
X353 output7.A u_loop.u_d0.A a_4510_3311# VGND sky130_fd_pr__nfet_01v8 ad=0.091 pd=0.93 as=0.091 ps=0.93 w=0.65 l=0.15
X354 VGND VPWR VGND VGND sky130_fd_pr__nfet_01v8 ad=0.143 pd=1.62 as=0 ps=0 w=0.55 l=0.59
X355 VPWR _23_.A _63_.CLK VPWR sky130_fd_pr__pfet_01v8_hvt ad=0.26 pd=2.52 as=0.135 ps=1.27 w=1 l=0.15
X356 a_7551_5853# a_6927_5487# a_7443_5487# VPWR sky130_fd_pr__pfet_01v8_hvt ad=0.1155 pd=0.97 as=0.07245 ps=0.765 w=0.42 l=0.15
X357 _20_.A a_1735_6031# VPWR VPWR sky130_fd_pr__pfet_01v8_hvt ad=0.495 pd=2.99 as=0.2726 ps=1.61 w=1 l=0.15
X358 a_5377_5487# _36_.A VGND VGND sky130_fd_pr__nfet_01v8 ad=0.08775 pd=0.92 as=0.169 ps=1.82 w=0.65 l=0.15
X359 VGND u_loop.u_gh.C a_4351_4175# VGND sky130_fd_pr__nfet_01v8 ad=0.08775 pd=0.92 as=0.169 ps=1.82 w=0.65 l=0.15
X360 a_2856_4399# a_1941_4399# a_2509_4641# VGND sky130_fd_pr__special_nfet_01v8 ad=0.0711 pd=0.755 as=0.0999 ps=0.985 w=0.36 l=0.15
X361 a_5389_5737# _41_.B1 VPWR VPWR sky130_fd_pr__pfet_01v8_hvt ad=0.1125 pd=1.225 as=0.165 ps=1.33 w=1 l=0.15
X362 VPWR VGND VPWR VPWR sky130_fd_pr__pfet_01v8_hvt ad=0.2262 pd=2.26 as=0 ps=0 w=0.87 l=0.59
X363 VGND VPWR VGND VGND sky130_fd_pr__nfet_01v8 ad=0.143 pd=1.62 as=0 ps=0 w=0.55 l=0.59
X364 VGND a_7539_7637# _45_.A VGND sky130_fd_pr__nfet_01v8 ad=0.169 pd=1.82 as=0.08775 ps=0.92 w=0.65 l=0.15
X365 VPWR VGND VPWR VPWR sky130_fd_pr__pfet_01v8_hvt ad=0.2262 pd=2.26 as=0 ps=0 w=0.87 l=0.59
X366 VPWR VGND VPWR VPWR sky130_fd_pr__pfet_01v8_hvt ad=0.2262 pd=2.26 as=0 ps=0 w=0.87 l=0.59
X367 _63_.CLK _23_.A VGND VGND sky130_fd_pr__nfet_01v8 ad=0.08775 pd=0.92 as=0.169 ps=1.82 w=0.65 l=0.15
X368 VPWR a_3436_6549# a_3196_6733# VPWR sky130_fd_pr__pfet_01v8_hvt ad=0.19265 pd=1.415 as=0.2173 ps=2.17 w=0.82 l=0.25
X369 u_loop.u_gh.B _36_.A VGND VGND sky130_fd_pr__nfet_01v8 ad=0.08775 pd=0.92 as=0.169 ps=1.82 w=0.65 l=0.15
X370 VGND VPWR VGND VGND sky130_fd_pr__nfet_01v8 ad=0.143 pd=1.62 as=0 ps=0 w=0.55 l=0.59
X371 VPWR VGND VPWR VPWR sky130_fd_pr__pfet_01v8_hvt ad=0.2262 pd=2.26 as=0 ps=0 w=0.87 l=0.59
X372 VPWR a_3491_5247# _28_.A VPWR sky130_fd_pr__pfet_01v8_hvt ad=0.26 pd=2.52 as=0.135 ps=1.27 w=1 l=0.15
X373 output6.A u_loop.u_q.Y a_4769_4175# VGND sky130_fd_pr__nfet_01v8 ad=0.08775 pd=0.92 as=0.169 ps=1.82 w=0.65 l=0.15
X374 _56_.Q a_6619_4373# VGND VGND sky130_fd_pr__nfet_01v8 ad=0.08775 pd=0.92 as=0.2087 ps=2.02 w=0.65 l=0.15
X375 a_6244_8751# _31_.Y VGND VGND sky130_fd_pr__nfet_01v8 ad=0.066 pd=0.745 as=0.2205 ps=1.89 w=0.42 l=0.15
X376 a_5293_5487# _41_.C1 a_5190_5487# VGND sky130_fd_pr__nfet_01v8 ad=0.08775 pd=0.92 as=0.23725 ps=2.03 w=0.65 l=0.15
X377 a_8468_5321# a_7553_4949# a_8121_4917# VGND sky130_fd_pr__special_nfet_01v8 ad=0.0711 pd=0.755 as=0.0999 ps=0.985 w=0.36 l=0.15
X378 a_7907_4159# a_7732_4233# a_8086_4221# VGND sky130_fd_pr__nfet_01v8 ad=0.1092 pd=1.36 as=0.06405 ps=0.725 w=0.42 l=0.15
X379 VGND _55_.RESET_B a_7429_4221# VGND sky130_fd_pr__nfet_01v8 ad=0.1346 pd=1.15 as=0.0441 ps=0.63 w=0.42 l=0.15
X380 a_8800_8207# a_8583_8207# VGND VGND sky130_fd_pr__nfet_01v8 ad=0.17225 pd=1.83 as=0.1228 ps=1.065 w=0.65 l=0.25
X381 _56_.D _56_.Q VGND VGND sky130_fd_pr__nfet_01v8 ad=0.08775 pd=0.92 as=0.169 ps=1.82 w=0.65 l=0.15
X382 a_2452_6575# a_2235_6575# VPWR VPWR sky130_fd_pr__pfet_01v8_hvt ad=0.2173 pd=2.17 as=0.19265 ps=1.415 w=0.82 l=0.25
X383 _34_.X a_1499_6575# VPWR VPWR sky130_fd_pr__pfet_01v8_hvt ad=0.14 pd=1.28 as=0.195 ps=1.39 w=1 l=0.15
X384 VGND VPWR VGND VGND sky130_fd_pr__nfet_01v8 ad=0.143 pd=1.62 as=0 ps=0 w=0.55 l=0.59
X385 VPWR VGND VPWR VPWR sky130_fd_pr__pfet_01v8_hvt ad=0.2262 pd=2.26 as=0 ps=0 w=0.87 l=0.59
X386 VPWR a_5764_2223# a_5875_2223# VPWR sky130_fd_pr__pfet_01v8_hvt ad=0.2726 pd=1.61 as=0.2173 ps=2.17 w=0.82 l=0.25
X387 VGND VPWR VGND VGND sky130_fd_pr__nfet_01v8 ad=0.143 pd=1.62 as=0 ps=0 w=0.55 l=0.59
X388 a_1665_7663# a_1499_7663# VPWR VPWR sky130_fd_pr__pfet_01v8_hvt ad=0.1664 pd=1.8 as=0.0864 ps=0.91 w=0.64 l=0.15
X389 VPWR VGND VPWR VPWR sky130_fd_pr__pfet_01v8_hvt ad=0.2262 pd=2.26 as=0 ps=0 w=0.87 l=0.59
X390 VGND VPWR VGND VGND sky130_fd_pr__nfet_01v8 ad=0.143 pd=1.62 as=0 ps=0 w=0.55 l=0.59
X391 VGND VPWR VGND VGND sky130_fd_pr__nfet_01v8 ad=0.143 pd=1.62 as=0 ps=0 w=0.55 l=0.59
X392 VGND _63_.CLK a_1499_7663# VGND sky130_fd_pr__nfet_01v8 ad=0.0567 pd=0.69 as=0.1092 ps=1.36 w=0.42 l=0.15
X393 _63_.Q a_2755_7637# VPWR VPWR sky130_fd_pr__pfet_01v8_hvt ad=0.135 pd=1.27 as=0.3012 ps=2.66 w=1 l=0.15
X394 a_7808_7485# _68_.D VPWR VPWR sky130_fd_pr__pfet_01v8_hvt ad=0.0651 pd=0.73 as=0.1092 ps=1.36 w=0.42 l=0.15
X395 VGND VPWR VGND VGND sky130_fd_pr__nfet_01v8 ad=0.143 pd=1.62 as=0 ps=0 w=0.55 l=0.59
X396 a_2015_7663# a_1665_7663# a_1920_7663# VPWR sky130_fd_pr__pfet_01v8_hvt ad=0.07245 pd=0.765 as=0.0651 ps=0.73 w=0.42 l=0.15
X397 a_3670_5309# u_loop.u_gh.C VGND VGND sky130_fd_pr__nfet_01v8 ad=0.06405 pd=0.725 as=0.12495 ps=1.015 w=0.42 l=0.15
X398 VGND a_7539_7637# a_7473_7663# VGND sky130_fd_pr__nfet_01v8 ad=0.12495 pd=1.015 as=0.0669 ps=0.75 w=0.42 l=0.15
X399 VGND _67__13.LO sky130_fd_pr__res_generic_po w=0.48 l=0.045
X400 a_6606_4765# a_5529_4399# a_6444_4399# VPWR sky130_fd_pr__pfet_01v8_hvt ad=0.0567 pd=0.69 as=0.0588 ps=0.7 w=0.42 l=0.15
X401 VGND a_3859_8511# a_3793_8585# VGND sky130_fd_pr__nfet_01v8 ad=0.12495 pd=1.015 as=0.0669 ps=0.75 w=0.42 l=0.15
X402 VGND VPWR VGND VGND sky130_fd_pr__nfet_01v8 ad=0.143 pd=1.62 as=0 ps=0 w=0.55 l=0.59
X403 VGND VPWR VGND VGND sky130_fd_pr__nfet_01v8 ad=0.143 pd=1.62 as=0 ps=0 w=0.55 l=0.59
X404 VGND VPWR VGND VGND sky130_fd_pr__nfet_01v8 ad=0.143 pd=1.62 as=0 ps=0 w=0.55 l=0.59
X405 VGND VPWR VGND VGND sky130_fd_pr__nfet_01v8 ad=0.143 pd=1.62 as=0 ps=0 w=0.55 l=0.59
X406 VPWR a_2360_7119# a_2471_7119# VPWR sky130_fd_pr__pfet_01v8_hvt ad=0.2726 pd=1.61 as=0.2173 ps=2.17 w=0.82 l=0.25
X407 a_3386_6031# a_2309_6037# a_3224_6409# VPWR sky130_fd_pr__pfet_01v8_hvt ad=0.0567 pd=0.69 as=0.0588 ps=0.7 w=0.42 l=0.15
X408 a_7093_5487# a_6927_5487# VPWR VPWR sky130_fd_pr__pfet_01v8_hvt ad=0.1664 pd=1.8 as=0.0864 ps=0.91 w=0.64 l=0.15
X409 a_5069_2767# a_4833_2767# VGND VGND sky130_fd_pr__nfet_01v8 ad=0.1092 pd=1.36 as=0.0567 ps=0.69 w=0.42 l=0.5
X410 _22_.Y _45_.A VGND VGND sky130_fd_pr__nfet_01v8 ad=0.08775 pd=0.92 as=0.169 ps=1.82 w=0.65 l=0.15
X411 VPWR _35_.A_N a_4167_6147# VPWR sky130_fd_pr__pfet_01v8_hvt ad=0.1468 pd=1.34 as=0.1092 ps=1.36 w=0.42 l=0.15
X412 a_2309_6037# a_2143_6037# VPWR VPWR sky130_fd_pr__pfet_01v8_hvt ad=0.1664 pd=1.8 as=0.0864 ps=0.91 w=0.64 l=0.15
X413 _52_.Y _28_.A VGND VGND sky130_fd_pr__nfet_01v8 ad=0.08775 pd=0.92 as=0.169 ps=1.82 w=0.65 l=0.15
X414 VPWR VGND VPWR VPWR sky130_fd_pr__pfet_01v8_hvt ad=0.2262 pd=2.26 as=0 ps=0 w=0.87 l=0.59
X415 a_7705_5487# a_7661_5729# a_7539_5487# VGND sky130_fd_pr__nfet_01v8 ad=0.0441 pd=0.63 as=0.1401 ps=1.1 w=0.42 l=0.15
X416 VGND VPWR VGND VGND sky130_fd_pr__nfet_01v8 ad=0.143 pd=1.62 as=0 ps=0 w=0.55 l=0.59
X417 VPWR _35_.A_N a_1845_6825# VPWR sky130_fd_pr__pfet_01v8_hvt ad=0.195 pd=1.39 as=0.105 ps=1.21 w=1 l=0.15
X418 _20_.Y _20_.A VPWR VPWR sky130_fd_pr__pfet_01v8_hvt ad=0.135 pd=1.27 as=0.26 ps=2.52 w=1 l=0.15
X419 VPWR u_loop.u_gh.B u_loop.u_gl.A2 VPWR sky130_fd_pr__pfet_01v8_hvt ad=0.26 pd=2.52 as=0.26 ps=2.52 w=1 l=0.15
X420 VGND VPWR VGND VGND sky130_fd_pr__nfet_01v8 ad=0.143 pd=1.62 as=0 ps=0 w=0.55 l=0.59
X421 VGND VPWR VGND VGND sky130_fd_pr__nfet_01v8 ad=0.143 pd=1.62 as=0 ps=0 w=0.55 l=0.59
X422 VPWR VGND VPWR VPWR sky130_fd_pr__pfet_01v8_hvt ad=0.2262 pd=2.26 as=0 ps=0 w=0.87 l=0.59
X423 VGND VPWR VGND VGND sky130_fd_pr__nfet_01v8 ad=0.143 pd=1.62 as=0 ps=0 w=0.55 l=0.59
X424 _40_.B a_3859_8511# VGND VGND sky130_fd_pr__nfet_01v8 ad=0.08775 pd=0.92 as=0.2087 ps=2.02 w=0.65 l=0.15
X425 VGND VPWR VGND VGND sky130_fd_pr__nfet_01v8 ad=0.143 pd=1.62 as=0 ps=0 w=0.55 l=0.59
X426 u_loop.u_d7.X a_6739_2767# VGND VGND sky130_fd_pr__nfet_01v8 ad=0.169 pd=1.82 as=0.097 ps=0.975 w=0.65 l=0.15
X427 a_7894_3855# a_6817_3861# a_7732_4233# VPWR sky130_fd_pr__pfet_01v8_hvt ad=0.0567 pd=0.69 as=0.0588 ps=0.7 w=0.42 l=0.15
X428 VGND a_3399_6335# _23_.A VGND sky130_fd_pr__nfet_01v8 ad=0.169 pd=1.82 as=0.08775 ps=0.92 w=0.65 l=0.15
X429 VPWR a_2877_6005# a_2767_6031# VPWR sky130_fd_pr__pfet_01v8_hvt ad=0.07035 pd=0.755 as=0.1155 ps=0.97 w=0.42 l=0.15
X430 _53_.A a_3031_4373# VPWR VPWR sky130_fd_pr__pfet_01v8_hvt ad=0.135 pd=1.27 as=0.3012 ps=2.66 w=1 l=0.15
X431 VGND VPWR VGND VGND sky130_fd_pr__nfet_01v8 ad=0.143 pd=1.62 as=0 ps=0 w=0.55 l=0.59
X432 VPWR _55_.Q _42_.Y VPWR sky130_fd_pr__pfet_01v8_hvt ad=0.26 pd=2.52 as=0.135 ps=1.27 w=1 l=0.15
X433 a_2387_4399# a_1941_4399# a_2291_4399# VGND sky130_fd_pr__special_nfet_01v8 ad=0.1401 pd=1.1 as=0.0594 ps=0.69 w=0.36 l=0.15
X434 VGND VPWR VGND VGND sky130_fd_pr__nfet_01v8 ad=0.143 pd=1.62 as=0 ps=0 w=0.55 l=0.59
X435 VPWR u_loop.u_d3.X a_4097_2767# VPWR sky130_fd_pr__pfet_01v8_hvt ad=0.0567 pd=0.69 as=0.1092 ps=1.36 w=0.42 l=0.15
X436 _48_.Y _30_.A VPWR VPWR sky130_fd_pr__pfet_01v8_hvt ad=0.135 pd=1.27 as=0.26 ps=2.52 w=1 l=0.15
X437 VPWR VGND VPWR VPWR sky130_fd_pr__pfet_01v8_hvt ad=0.2262 pd=2.26 as=0 ps=0 w=0.87 l=0.59
X438 VPWR VGND VPWR VPWR sky130_fd_pr__pfet_01v8_hvt ad=0.2262 pd=2.26 as=0 ps=0 w=0.87 l=0.59
X439 VGND VPWR VGND VGND sky130_fd_pr__nfet_01v8 ad=0.143 pd=1.62 as=0 ps=0 w=0.55 l=0.59
X440 VPWR VGND VPWR VPWR sky130_fd_pr__pfet_01v8_hvt ad=0.2262 pd=2.26 as=0 ps=0 w=0.87 l=0.59
X441 VPWR a_6619_4373# _56_.Q VPWR sky130_fd_pr__pfet_01v8_hvt ad=0.26 pd=2.52 as=0.135 ps=1.27 w=1 l=0.15
X442 VGND VPWR VGND VGND sky130_fd_pr__nfet_01v8 ad=0.143 pd=1.62 as=0 ps=0 w=0.55 l=0.59
X443 VPWR _28_.A _28_.Y VPWR sky130_fd_pr__pfet_01v8_hvt ad=0.26 pd=2.52 as=0.135 ps=1.27 w=1 l=0.15
X444 a_2766_9427# a_3044_9411# a_3000_9295# VPWR sky130_fd_pr__pfet_01v8_hvt ad=0.0588 pd=0.7 as=0.0567 ps=0.69 w=0.42 l=0.15
X445 _45_.A a_7539_7637# VGND VGND sky130_fd_pr__nfet_01v8 ad=0.08775 pd=0.92 as=0.2087 ps=2.02 w=0.65 l=0.15
X446 _32_.Y _32_.A VGND VGND sky130_fd_pr__nfet_01v8 ad=0.08775 pd=0.92 as=0.169 ps=1.82 w=0.65 l=0.15
X447 a_5389_7119# _41_.B1 VPWR VPWR sky130_fd_pr__pfet_01v8_hvt ad=0.1125 pd=1.225 as=0.165 ps=1.33 w=1 l=0.15
X448 a_4510_3311# u_loop.u_d0.A output7.A VGND sky130_fd_pr__nfet_01v8 ad=0.091 pd=0.93 as=0.091 ps=0.93 w=0.65 l=0.15
X449 VPWR VGND VPWR VPWR sky130_fd_pr__pfet_01v8_hvt ad=0.2262 pd=2.26 as=0 ps=0 w=0.87 l=0.59
X450 a_5293_7439# _39_.B2 a_5377_7439# VGND sky130_fd_pr__nfet_01v8 ad=0.169 pd=1.82 as=0.08775 ps=0.92 w=0.65 l=0.15
X451 _28_.A a_3491_5247# VPWR VPWR sky130_fd_pr__pfet_01v8_hvt ad=0.135 pd=1.27 as=0.3012 ps=2.66 w=1 l=0.15
X452 VPWR VGND VPWR VPWR sky130_fd_pr__pfet_01v8_hvt ad=0.2262 pd=2.26 as=0 ps=0 w=0.87 l=0.59
X453 a_6904_8751# a_5823_8751# a_6557_8993# VPWR sky130_fd_pr__pfet_01v8_hvt ad=0.0588 pd=0.7 as=0.12915 ps=1.185 w=0.42 l=0.15
X454 VPWR a_7364_7663# a_7539_7637# VPWR sky130_fd_pr__pfet_01v8_hvt ad=0.1134 pd=1.38 as=0.0567 ps=0.69 w=0.42 l=0.15
X455 VGND _52_.Y a_2143_6037# VGND sky130_fd_pr__nfet_01v8 ad=0.0567 pd=0.69 as=0.1092 ps=1.36 w=0.42 l=0.15
X456 VPWR VGND VPWR VPWR sky130_fd_pr__pfet_01v8_hvt ad=0.2262 pd=2.26 as=0 ps=0 w=0.87 l=0.59
X457 VGND VPWR VGND VGND sky130_fd_pr__nfet_01v8 ad=0.143 pd=1.62 as=0 ps=0 w=0.55 l=0.59
X458 VGND VPWR VGND VGND sky130_fd_pr__nfet_01v8 ad=0.143 pd=1.62 as=0 ps=0 w=0.55 l=0.59
X459 VGND _39_.B2 _21_.Y VGND sky130_fd_pr__nfet_01v8 ad=0.169 pd=1.82 as=0.08775 ps=0.92 w=0.65 l=0.15
X460 a_6704_7663# _22_.Y VPWR VPWR sky130_fd_pr__pfet_01v8_hvt ad=0.0651 pd=0.73 as=0.1092 ps=1.36 w=0.42 l=0.15
X461 VPWR VGND VPWR VPWR sky130_fd_pr__pfet_01v8_hvt ad=0.2262 pd=2.26 as=0 ps=0 w=0.87 l=0.59
X462 u_loop.u_cmp.Y input5.X VGND VGND sky130_fd_pr__nfet_01v8 ad=0.169 pd=1.82 as=0.169 ps=1.82 w=0.65 l=0.15
X463 VPWR VGND VPWR VPWR sky130_fd_pr__pfet_01v8_hvt ad=0.2262 pd=2.26 as=0 ps=0 w=0.87 l=0.59
X464 _53_.Y _53_.A VPWR VPWR sky130_fd_pr__pfet_01v8_hvt ad=0.135 pd=1.27 as=0.26 ps=2.52 w=1 l=0.15
X465 VPWR _68_.D sky130_fd_pr__res_generic_po w=0.48 l=0.045
X466 VPWR _45_.A _57_.CLK VPWR sky130_fd_pr__pfet_01v8_hvt ad=0.26 pd=2.52 as=0.135 ps=1.27 w=1 l=0.15
X467 VGND VPWR VGND VGND sky130_fd_pr__nfet_01v8 ad=0.143 pd=1.62 as=0 ps=0 w=0.55 l=0.59
X468 a_4075_6825# _35_.A_N VPWR VPWR sky130_fd_pr__pfet_01v8_hvt ad=0.135 pd=1.27 as=0.135 ps=1.27 w=1 l=0.15
X469 VPWR a_2769_2223# a_2875_2223# VPWR sky130_fd_pr__pfet_01v8_hvt ad=0.14075 pd=1.325 as=0.1092 ps=1.36 w=0.42 l=0.5
X470 output7.A u_loop.u_d0.A a_4510_3311# VGND sky130_fd_pr__nfet_01v8 ad=0.091 pd=0.93 as=0.091 ps=0.93 w=0.65 l=0.15
X471 a_2801_9661# a_2766_9427# a_2479_9269# VGND sky130_fd_pr__nfet_01v8 ad=0.06405 pd=0.725 as=0.1092 ps=1.36 w=0.42 l=0.15
X472 a_3477_9661# u_loop.u_gh.C VGND VGND sky130_fd_pr__nfet_01v8 ad=0.0441 pd=0.63 as=0.1346 ps=1.15 w=0.42 l=0.15
X473 VGND VPWR VGND VGND sky130_fd_pr__nfet_01v8 ad=0.143 pd=1.62 as=0 ps=0 w=0.55 l=0.59
X474 VGND _35_.B a_3348_7235# VGND sky130_fd_pr__nfet_01v8 ad=0.10187 pd=0.99 as=0.0567 ps=0.69 w=0.42 l=0.15
X475 a_2659_6409# a_2143_6037# a_2564_6397# VGND sky130_fd_pr__special_nfet_01v8 ad=0.0594 pd=0.69 as=0.066 ps=0.745 w=0.36 l=0.15
X476 a_6891_6409# a_6375_6037# a_6796_6397# VGND sky130_fd_pr__special_nfet_01v8 ad=0.0594 pd=0.69 as=0.066 ps=0.745 w=0.36 l=0.15
X477 VGND VPWR VGND VGND sky130_fd_pr__nfet_01v8 ad=0.143 pd=1.62 as=0 ps=0 w=0.55 l=0.59
X478 VPWR VGND VPWR VPWR sky130_fd_pr__pfet_01v8_hvt ad=0.2262 pd=2.26 as=0 ps=0 w=0.87 l=0.59
X479 a_2877_6005# a_2659_6409# VGND VGND sky130_fd_pr__nfet_01v8 ad=0.0999 pd=0.985 as=0.1346 ps=1.15 w=0.64 l=0.15
X480 VGND _53_.Y a_2235_4949# VGND sky130_fd_pr__nfet_01v8 ad=0.0567 pd=0.69 as=0.1092 ps=1.36 w=0.42 l=0.15
X481 VGND _56_.Q _55_.CLK VGND sky130_fd_pr__nfet_01v8 ad=0.169 pd=1.82 as=0.08775 ps=0.92 w=0.65 l=0.15
X482 a_8643_5247# u_loop.u_gh.C VPWR VPWR sky130_fd_pr__pfet_01v8_hvt ad=0.0567 pd=0.69 as=0.0819 ps=0.81 w=0.42 l=0.15
X483 VGND VPWR VGND VGND sky130_fd_pr__nfet_01v8 ad=0.143 pd=1.62 as=0 ps=0 w=0.55 l=0.59
X484 VGND VPWR VGND VGND sky130_fd_pr__nfet_01v8 ad=0.143 pd=1.62 as=0 ps=0 w=0.55 l=0.59
X485 a_3802_9295# a_3083_9537# a_3239_9269# VGND sky130_fd_pr__special_nfet_01v8 ad=0.066 pd=0.745 as=0.0594 ps=0.69 w=0.36 l=0.15
X486 VPWR _41_.X a_6927_5487# VPWR sky130_fd_pr__pfet_01v8_hvt ad=0.0864 pd=0.91 as=0.1664 ps=1.8 w=0.64 l=0.15
X487 VGND VPWR VGND VGND sky130_fd_pr__nfet_01v8 ad=0.143 pd=1.62 as=0 ps=0 w=0.55 l=0.59
X488 a_2125_2767# a_1889_2767# VPWR VPWR sky130_fd_pr__pfet_01v8_hvt ad=0.1092 pd=1.36 as=0.0567 ps=0.69 w=0.42 l=0.5
X489 VPWR VGND VPWR VPWR sky130_fd_pr__pfet_01v8_hvt ad=0.2262 pd=2.26 as=0 ps=0 w=0.87 l=0.59
X490 u_loop.u_d0.A a_5691_3829# VGND VGND sky130_fd_pr__nfet_01v8 ad=0.0567 pd=0.69 as=0.1092 ps=1.36 w=0.42 l=0.15
X491 u_loop.u_gl.B1 u_loop.u_gh.C VGND VGND sky130_fd_pr__nfet_01v8 ad=0.169 pd=1.82 as=0.169 ps=1.82 w=0.65 l=0.15
X492 VPWR _63_.Q _50_.Y VPWR sky130_fd_pr__pfet_01v8_hvt ad=0.26 pd=2.52 as=0.135 ps=1.27 w=1 l=0.15
X493 VGND _46_.A _31_.Y VGND sky130_fd_pr__nfet_01v8 ad=0.169 pd=1.82 as=0.08775 ps=0.92 w=0.65 l=0.15
X494 VPWR VGND VPWR VPWR sky130_fd_pr__pfet_01v8_hvt ad=0.2262 pd=2.26 as=0 ps=0 w=0.87 l=0.59
X495 VGND VPWR VGND VGND sky130_fd_pr__nfet_01v8 ad=0.143 pd=1.62 as=0 ps=0 w=0.55 l=0.59
X496 u_loop.u_d3.X a_3703_2767# VPWR VPWR sky130_fd_pr__pfet_01v8_hvt ad=0.26 pd=2.52 as=0.14075 ps=1.325 w=1 l=0.15
X497 output6.A u_loop.u_gh.B VPWR VPWR sky130_fd_pr__pfet_01v8_hvt ad=0.135 pd=1.27 as=0.135 ps=1.27 w=1 l=0.15
X498 VGND VPWR VGND VGND sky130_fd_pr__nfet_01v8 ad=0.143 pd=1.62 as=0 ps=0 w=0.55 l=0.59
X499 a_3514_7235# _23_.A a_3430_7235# VPWR sky130_fd_pr__pfet_01v8_hvt ad=0.0567 pd=0.69 as=0.0567 ps=0.69 w=0.42 l=0.15
X500 VPWR VGND VPWR VPWR sky130_fd_pr__pfet_01v8_hvt ad=0.2262 pd=2.26 as=0 ps=0 w=0.87 l=0.59
X501 a_7364_7663# a_6283_7663# a_7017_7905# VPWR sky130_fd_pr__pfet_01v8_hvt ad=0.0588 pd=0.7 as=0.12915 ps=1.185 w=0.42 l=0.15
X502 VPWR _35_.B a_4158_7235# VPWR sky130_fd_pr__pfet_01v8_hvt ad=0.14825 pd=1.34 as=0.0567 ps=0.69 w=0.42 l=0.15
X503 a_2769_2223# a_2533_2223# VPWR VPWR sky130_fd_pr__pfet_01v8_hvt ad=0.1092 pd=1.36 as=0.0567 ps=0.69 w=0.42 l=0.5
X504 VPWR VGND VPWR VPWR sky130_fd_pr__pfet_01v8_hvt ad=0.2262 pd=2.26 as=0 ps=0 w=0.87 l=0.59
X505 VGND a_3436_6549# a_3196_6733# VGND sky130_fd_pr__nfet_01v8 ad=0.1228 pd=1.065 as=0.17225 ps=1.83 w=0.65 l=0.25
X506 VPWR VGND VPWR VPWR sky130_fd_pr__pfet_01v8_hvt ad=0.2262 pd=2.26 as=0 ps=0 w=0.87 l=0.59
X507 VGND u_loop.u_q.Y u_loop.u_q.B VGND sky130_fd_pr__nfet_01v8 ad=0.169 pd=1.82 as=0.08775 ps=0.92 w=0.65 l=0.15
X508 VPWR _25_.A a_5649_5737# VPWR sky130_fd_pr__pfet_01v8_hvt ad=0.165 pd=1.33 as=0.105 ps=1.21 w=1 l=0.15
X509 _55_.CLK _56_.Q VPWR VPWR sky130_fd_pr__pfet_01v8_hvt ad=0.135 pd=1.27 as=0.26 ps=2.52 w=1 l=0.15
X510 a_1941_4399# a_1775_4399# VPWR VPWR sky130_fd_pr__pfet_01v8_hvt ad=0.1664 pd=1.8 as=0.0864 ps=0.91 w=0.64 l=0.15
X511 a_3031_4373# a_2856_4399# a_3210_4399# VGND sky130_fd_pr__nfet_01v8 ad=0.1092 pd=1.36 as=0.06405 ps=0.725 w=0.42 l=0.15
X512 VPWR VGND VPWR VPWR sky130_fd_pr__pfet_01v8_hvt ad=0.2262 pd=2.26 as=0 ps=0 w=0.87 l=0.59
X513 _46_.A a_7079_8725# VGND VGND sky130_fd_pr__nfet_01v8 ad=0.08775 pd=0.92 as=0.2087 ps=2.02 w=0.65 l=0.15
X514 VGND _35_.A_N a_4518_6575# VGND sky130_fd_pr__nfet_01v8 ad=0.08775 pd=0.92 as=0.169 ps=1.82 w=0.65 l=0.15
X515 a_8643_5247# a_8468_5321# a_8822_5309# VGND sky130_fd_pr__nfet_01v8 ad=0.1092 pd=1.36 as=0.06405 ps=0.725 w=0.42 l=0.15
X516 VPWR VGND VPWR VPWR sky130_fd_pr__pfet_01v8_hvt ad=0.2262 pd=2.26 as=0 ps=0 w=0.87 l=0.59
X517 VGND VPWR VGND VGND sky130_fd_pr__nfet_01v8 ad=0.143 pd=1.62 as=0 ps=0 w=0.55 l=0.59
X518 VPWR VGND VPWR VPWR sky130_fd_pr__pfet_01v8_hvt ad=0.2262 pd=2.26 as=0 ps=0 w=0.87 l=0.59
X519 VGND VPWR VGND VGND sky130_fd_pr__nfet_01v8 ad=0.143 pd=1.62 as=0 ps=0 w=0.55 l=0.59
X520 VPWR a_6904_8751# a_7079_8725# VPWR sky130_fd_pr__pfet_01v8_hvt ad=0.1134 pd=1.38 as=0.0567 ps=0.69 w=0.42 l=0.15
X521 VGND VPWR VGND VGND sky130_fd_pr__nfet_01v8 ad=0.143 pd=1.62 as=0 ps=0 w=0.55 l=0.59
X522 a_8822_7485# _55_.RESET_B VGND VGND sky130_fd_pr__nfet_01v8 ad=0.06405 pd=0.725 as=0.12495 ps=1.015 w=0.42 l=0.15
X523 a_2452_6575# a_2235_6575# VGND VGND sky130_fd_pr__nfet_01v8 ad=0.17225 pd=1.83 as=0.1228 ps=1.065 w=0.65 l=0.25
X524 VGND VPWR VGND VGND sky130_fd_pr__nfet_01v8 ad=0.143 pd=1.62 as=0 ps=0 w=0.55 l=0.59
X525 _27_.Y _53_.A VPWR VPWR sky130_fd_pr__pfet_01v8_hvt ad=0.135 pd=1.27 as=0.26 ps=2.52 w=1 l=0.15
X526 a_6553_4399# a_5363_4399# a_6444_4399# VGND sky130_fd_pr__special_nfet_01v8 ad=0.0669 pd=0.75 as=0.0711 ps=0.755 w=0.36 l=0.15
X527 a_2859_4943# u_loop.u_gh.C VPWR VPWR sky130_fd_pr__pfet_01v8_hvt ad=0.1092 pd=1.36 as=0.07035 ps=0.755 w=0.42 l=0.15
X528 VPWR a_8643_5247# a_8630_4943# VPWR sky130_fd_pr__pfet_01v8_hvt ad=0.0819 pd=0.81 as=0.0567 ps=0.69 w=0.42 l=0.15
X529 VGND VPWR VGND VGND sky130_fd_pr__nfet_01v8 ad=0.143 pd=1.62 as=0 ps=0 w=0.55 l=0.59
X530 a_3170_9295# a_3044_9411# a_2766_9427# VGND sky130_fd_pr__special_nfet_01v8 ad=0.0999 pd=0.985 as=0.0711 ps=0.755 w=0.36 l=0.15
X531 VGND _30_.A _48_.Y VGND sky130_fd_pr__nfet_01v8 ad=0.169 pd=1.82 as=0.08775 ps=0.92 w=0.65 l=0.15
X532 VGND a_2755_7637# _63_.Q VGND sky130_fd_pr__nfet_01v8 ad=0.169 pd=1.82 as=0.08775 ps=0.92 w=0.65 l=0.15
X533 VGND a_7631_6335# _32_.A VGND sky130_fd_pr__nfet_01v8 ad=0.169 pd=1.82 as=0.08775 ps=0.92 w=0.65 l=0.15
X534 _28_.Y _28_.A VGND VGND sky130_fd_pr__nfet_01v8 ad=0.08775 pd=0.92 as=0.169 ps=1.82 w=0.65 l=0.15
X535 VPWR VGND VPWR VPWR sky130_fd_pr__pfet_01v8_hvt ad=0.2262 pd=2.26 as=0 ps=0 w=0.87 l=0.59
X536 VGND VPWR VGND VGND sky130_fd_pr__nfet_01v8 ad=0.143 pd=1.62 as=0 ps=0 w=0.55 l=0.59
X537 a_6244_8751# _31_.Y VPWR VPWR sky130_fd_pr__pfet_01v8_hvt ad=0.0651 pd=0.73 as=0.1092 ps=1.36 w=0.42 l=0.15
X538 a_5377_7439# _36_.A VGND VGND sky130_fd_pr__nfet_01v8 ad=0.08775 pd=0.92 as=0.169 ps=1.82 w=0.65 l=0.15
X539 VPWR a_3316_5321# a_3491_5247# VPWR sky130_fd_pr__pfet_01v8_hvt ad=0.1134 pd=1.38 as=0.0567 ps=0.69 w=0.42 l=0.15
X540 a_6798_4399# _55_.RESET_B VGND VGND sky130_fd_pr__nfet_01v8 ad=0.06405 pd=0.725 as=0.12495 ps=1.015 w=0.42 l=0.15
X541 a_5975_4399# a_5529_4399# a_5879_4399# VGND sky130_fd_pr__special_nfet_01v8 ad=0.1401 pd=1.1 as=0.0594 ps=0.69 w=0.36 l=0.15
X542 a_5786_9661# u_loop.u_gh.C VGND VGND sky130_fd_pr__nfet_01v8 ad=0.06405 pd=0.725 as=0.12495 ps=1.015 w=0.42 l=0.15
X543 a_7661_5729# a_7443_5487# VPWR VPWR sky130_fd_pr__pfet_01v8_hvt ad=0.12915 pd=1.185 as=0.2184 ps=2.2 w=0.84 l=0.15
X544 VGND VPWR VGND VGND sky130_fd_pr__nfet_01v8 ad=0.143 pd=1.62 as=0 ps=0 w=0.55 l=0.59
X545 VPWR VGND VPWR VPWR sky130_fd_pr__pfet_01v8_hvt ad=0.2262 pd=2.26 as=0 ps=0 w=0.87 l=0.59
X546 VGND VPWR VGND VGND sky130_fd_pr__nfet_01v8 ad=0.143 pd=1.62 as=0 ps=0 w=0.55 l=0.59
X547 VGND VPWR VGND VGND sky130_fd_pr__nfet_01v8 ad=0.143 pd=1.62 as=0 ps=0 w=0.55 l=0.59
X548 a_8800_6031# a_8583_6031# VPWR VPWR sky130_fd_pr__pfet_01v8_hvt ad=0.2173 pd=2.17 as=0.19265 ps=1.415 w=0.82 l=0.25
X549 VPWR VGND VPWR VPWR sky130_fd_pr__pfet_01v8_hvt ad=0.2262 pd=2.26 as=0 ps=0 w=0.87 l=0.59
X550 VGND _42_.Y a_7387_4949# VGND sky130_fd_pr__nfet_01v8 ad=0.0567 pd=0.69 as=0.1092 ps=1.36 w=0.42 l=0.15
X551 VPWR src[0] a_2143_7119# VPWR sky130_fd_pr__pfet_01v8_hvt ad=0.19265 pd=1.415 as=0.27 ps=2.54 w=1 l=0.15
X552 _23_.Y _23_.A VGND VGND sky130_fd_pr__nfet_01v8 ad=0.08775 pd=0.92 as=0.169 ps=1.82 w=0.65 l=0.15
X553 a_3170_9295# a_3083_9537# a_2766_9427# VPWR sky130_fd_pr__pfet_01v8_hvt ad=0.12915 pd=1.185 as=0.0588 ps=0.7 w=0.42 l=0.15
X554 VGND a_5276_2197# a_5036_2381# VGND sky130_fd_pr__nfet_01v8 ad=0.1228 pd=1.065 as=0.17225 ps=1.83 w=0.65 l=0.25
X555 VGND VPWR VGND VGND sky130_fd_pr__nfet_01v8 ad=0.143 pd=1.62 as=0 ps=0 w=0.55 l=0.59
X556 _25_.Y _25_.A VGND VGND sky130_fd_pr__nfet_01v8 ad=0.08775 pd=0.92 as=0.169 ps=1.82 w=0.65 l=0.15
X557 a_5293_7439# _38_.X a_5190_7439# VGND sky130_fd_pr__nfet_01v8 ad=0.08775 pd=0.92 as=0.23725 ps=2.03 w=0.65 l=0.15
X558 a_2656_5309# _28_.Y VPWR VPWR sky130_fd_pr__pfet_01v8_hvt ad=0.0651 pd=0.73 as=0.1092 ps=1.36 w=0.42 l=0.15
X559 VPWR u_loop.u_d6.X a_6397_2767# VPWR sky130_fd_pr__pfet_01v8_hvt ad=0.0567 pd=0.69 as=0.1092 ps=1.36 w=0.42 l=0.15
X560 VGND u_loop.u_gl.A2 a_4510_3311# VGND sky130_fd_pr__nfet_01v8 ad=0.091 pd=0.93 as=0.091 ps=0.93 w=0.65 l=0.15
X561 VGND VPWR VGND VGND sky130_fd_pr__nfet_01v8 ad=0.143 pd=1.62 as=0 ps=0 w=0.55 l=0.59
X562 a_2015_7663# a_1499_7663# a_1920_7663# VGND sky130_fd_pr__special_nfet_01v8 ad=0.0594 pd=0.69 as=0.066 ps=0.745 w=0.36 l=0.15
X563 VPWR VGND VPWR VPWR sky130_fd_pr__pfet_01v8_hvt ad=0.2262 pd=2.26 as=0 ps=0 w=0.87 l=0.59
X564 VGND VPWR VGND VGND sky130_fd_pr__nfet_01v8 ad=0.143 pd=1.62 as=0 ps=0 w=0.55 l=0.59
X565 VGND VPWR VGND VGND sky130_fd_pr__nfet_01v8 ad=0.143 pd=1.62 as=0 ps=0 w=0.55 l=0.59
X566 VGND u_loop.u_d1.X a_2625_2767# VGND sky130_fd_pr__nfet_01v8 ad=0.0567 pd=0.69 as=0.1092 ps=1.36 w=0.42 l=0.15
X567 a_2564_6397# _23_.Y VGND VGND sky130_fd_pr__nfet_01v8 ad=0.066 pd=0.745 as=0.2205 ps=1.89 w=0.42 l=0.15
X568 a_4292_2223# a_4075_2223# VGND VGND sky130_fd_pr__nfet_01v8 ad=0.17225 pd=1.83 as=0.1228 ps=1.065 w=0.65 l=0.25
X569 VGND VPWR VGND VGND sky130_fd_pr__nfet_01v8 ad=0.143 pd=1.62 as=0 ps=0 w=0.55 l=0.59
X570 VPWR VGND VPWR VPWR sky130_fd_pr__pfet_01v8_hvt ad=0.2262 pd=2.26 as=0 ps=0 w=0.87 l=0.59
X571 _68__14.LO VGND sky130_fd_pr__res_generic_po w=0.48 l=0.045
X572 a_6541_6037# a_6375_6037# VGND VGND sky130_fd_pr__nfet_01v8 ad=0.1092 pd=1.36 as=0.0567 ps=0.69 w=0.42 l=0.15
X573 VGND VPWR VGND VGND sky130_fd_pr__nfet_01v8 ad=0.143 pd=1.62 as=0 ps=0 w=0.55 l=0.59
X574 VGND _20_.A _20_.Y VGND sky130_fd_pr__nfet_01v8 ad=0.169 pd=1.82 as=0.08775 ps=0.92 w=0.65 l=0.15
X575 VPWR a_8008_5487# a_8183_5461# VPWR sky130_fd_pr__pfet_01v8_hvt ad=0.1134 pd=1.38 as=0.0567 ps=0.69 w=0.42 l=0.15
X576 VPWR VGND VPWR VPWR sky130_fd_pr__pfet_01v8_hvt ad=0.2262 pd=2.26 as=0 ps=0 w=0.87 l=0.59
X577 VPWR VGND VPWR VPWR sky130_fd_pr__pfet_01v8_hvt ad=0.2262 pd=2.26 as=0 ps=0 w=0.87 l=0.59
X578 VGND _68_.Q a_8583_8207# VGND sky130_fd_pr__nfet_01v8 ad=0.1228 pd=1.065 as=0.1134 ps=1.38 w=0.42 l=0.15
X579 VPWR VGND VPWR VPWR sky130_fd_pr__pfet_01v8_hvt ad=0.2262 pd=2.26 as=0 ps=0 w=0.87 l=0.59
X580 VPWR VGND VPWR VPWR sky130_fd_pr__pfet_01v8_hvt ad=0.2262 pd=2.26 as=0 ps=0 w=0.87 l=0.59
X581 a_4333_2767# a_4097_2767# VGND VGND sky130_fd_pr__nfet_01v8 ad=0.1092 pd=1.36 as=0.0567 ps=0.69 w=0.42 l=0.5
X582 VGND VPWR VGND VGND sky130_fd_pr__nfet_01v8 ad=0.143 pd=1.62 as=0 ps=0 w=0.55 l=0.59
X583 a_3227_8207# u_loop.u_gh.C VPWR VPWR sky130_fd_pr__pfet_01v8_hvt ad=0.1092 pd=1.36 as=0.07035 ps=0.755 w=0.42 l=0.15
X584 a_2233_7905# a_2015_7663# VGND VGND sky130_fd_pr__nfet_01v8 ad=0.0999 pd=0.985 as=0.1346 ps=1.15 w=0.64 l=0.15
X585 VGND VPWR VGND VGND sky130_fd_pr__nfet_01v8 ad=0.143 pd=1.62 as=0 ps=0 w=0.55 l=0.59
X586 a_7553_7125# a_7387_7125# VPWR VPWR sky130_fd_pr__pfet_01v8_hvt ad=0.1664 pd=1.8 as=0.0864 ps=0.91 w=0.64 l=0.15
X587 _41_.X a_5190_5487# VGND VGND sky130_fd_pr__nfet_01v8 ad=0.08775 pd=0.92 as=0.08775 ps=0.92 w=0.65 l=0.15
X588 _67_.Q a_8183_5461# VGND VGND sky130_fd_pr__nfet_01v8 ad=0.08775 pd=0.92 as=0.2087 ps=2.02 w=0.65 l=0.15
X589 VGND VPWR VGND VGND sky130_fd_pr__nfet_01v8 ad=0.143 pd=1.62 as=0 ps=0 w=0.55 l=0.59
X590 a_4510_3311# u_loop.u_d0.A output7.A VGND sky130_fd_pr__nfet_01v8 ad=0.091 pd=0.93 as=0.091 ps=0.93 w=0.65 l=0.15
X591 VGND u_loop.u_gh.C a_4351_4175# VGND sky130_fd_pr__nfet_01v8 ad=0.08775 pd=0.92 as=0.08775 ps=0.92 w=0.65 l=0.15
X592 a_3992_7235# _40_.B VGND VGND sky130_fd_pr__nfet_01v8 ad=0.0567 pd=0.69 as=0.0567 ps=0.69 w=0.42 l=0.15
X593 a_8011_4943# u_loop.u_gh.C VPWR VPWR sky130_fd_pr__pfet_01v8_hvt ad=0.1092 pd=1.36 as=0.07035 ps=0.755 w=0.42 l=0.15
X594 VPWR VGND VPWR VPWR sky130_fd_pr__pfet_01v8_hvt ad=0.2262 pd=2.26 as=0 ps=0 w=0.87 l=0.59
X595 VGND a_3031_4373# _53_.A VGND sky130_fd_pr__nfet_01v8 ad=0.169 pd=1.82 as=0.08775 ps=0.92 w=0.65 l=0.15
X596 a_2656_5309# _28_.Y VGND VGND sky130_fd_pr__nfet_01v8 ad=0.066 pd=0.745 as=0.2205 ps=1.89 w=0.42 l=0.15
X597 VGND VPWR VGND VGND sky130_fd_pr__nfet_01v8 ad=0.143 pd=1.62 as=0 ps=0 w=0.55 l=0.59
X598 VGND a_3388_7351# a_3348_7235# VGND sky130_fd_pr__nfet_01v8 ad=0.0567 pd=0.69 as=0.1092 ps=1.36 w=0.42 l=0.15
X599 VPWR u_loop.u_gh.C a_3384_9295# VPWR sky130_fd_pr__pfet_01v8_hvt ad=0.07035 pd=0.755 as=0.1092 ps=1.36 w=0.42 l=0.15
X600 a_7526_8029# a_6449_7663# a_7364_7663# VPWR sky130_fd_pr__pfet_01v8_hvt ad=0.0567 pd=0.69 as=0.0588 ps=0.7 w=0.42 l=0.15
X601 VGND a_3348_7235# _38_.X VGND sky130_fd_pr__nfet_01v8 ad=0.10025 pd=0.985 as=0.08775 ps=0.92 w=0.65 l=0.15
X602 VGND VPWR VGND VGND sky130_fd_pr__nfet_01v8 ad=0.143 pd=1.62 as=0 ps=0 w=0.55 l=0.59
X603 _35_.A_N a_2471_7119# VPWR VPWR sky130_fd_pr__pfet_01v8_hvt ad=0.495 pd=2.99 as=0.2726 ps=1.61 w=1 l=0.15
X604 VGND VPWR VGND VGND sky130_fd_pr__nfet_01v8 ad=0.143 pd=1.62 as=0 ps=0 w=0.55 l=0.59
X605 VGND VPWR VGND VGND sky130_fd_pr__nfet_01v8 ad=0.143 pd=1.62 as=0 ps=0 w=0.55 l=0.59
X606 VGND _55_.RESET_B a_7705_5487# VGND sky130_fd_pr__nfet_01v8 ad=0.1346 pd=1.15 as=0.0441 ps=0.63 w=0.42 l=0.15
X607 VPWR VGND VPWR VPWR sky130_fd_pr__pfet_01v8_hvt ad=0.2262 pd=2.26 as=0 ps=0 w=0.87 l=0.59
X608 output6.A u_loop.u_gh.B VPWR VPWR sky130_fd_pr__pfet_01v8_hvt ad=0.135 pd=1.27 as=0.135 ps=1.27 w=1 l=0.15
X609 VPWR u_loop.u_d4.X a_4833_2767# VPWR sky130_fd_pr__pfet_01v8_hvt ad=0.0567 pd=0.69 as=0.1092 ps=1.36 w=0.42 l=0.15
X610 a_4074_7235# a_4032_7351# a_3992_7235# VPWR sky130_fd_pr__pfet_01v8_hvt ad=0.0567 pd=0.69 as=0.1092 ps=1.36 w=0.42 l=0.15
X611 VPWR VGND VPWR VPWR sky130_fd_pr__pfet_01v8_hvt ad=0.2262 pd=2.26 as=0 ps=0 w=0.87 l=0.59
X612 VGND VPWR VGND VGND sky130_fd_pr__nfet_01v8 ad=0.143 pd=1.62 as=0 ps=0 w=0.55 l=0.59
X613 _47_.Y _39_.B2 VGND VGND sky130_fd_pr__nfet_01v8 ad=0.08775 pd=0.92 as=0.169 ps=1.82 w=0.65 l=0.15
X614 VGND VPWR VGND VGND sky130_fd_pr__nfet_01v8 ad=0.143 pd=1.62 as=0 ps=0 w=0.55 l=0.59
X615 VPWR _45_.A a_5649_7119# VPWR sky130_fd_pr__pfet_01v8_hvt ad=0.165 pd=1.33 as=0.105 ps=1.21 w=1 l=0.15
X616 VGND VPWR VGND VGND sky130_fd_pr__nfet_01v8 ad=0.143 pd=1.62 as=0 ps=0 w=0.55 l=0.59
X617 VPWR _67_.Q a_8583_6031# VPWR sky130_fd_pr__pfet_01v8_hvt ad=0.19265 pd=1.415 as=0.27 ps=2.54 w=1 l=0.15
X618 VGND VPWR VGND VGND sky130_fd_pr__nfet_01v8 ad=0.143 pd=1.62 as=0 ps=0 w=0.55 l=0.59
X619 VPWR VGND VPWR VPWR sky130_fd_pr__pfet_01v8_hvt ad=0.2262 pd=2.26 as=0 ps=0 w=0.87 l=0.59
X620 VPWR a_3083_9537# a_3044_9411# VPWR sky130_fd_pr__pfet_01v8_hvt ad=0.0864 pd=0.91 as=0.1664 ps=1.8 w=0.64 l=0.15
X621 a_3684_8585# a_2769_8213# a_3337_8181# VGND sky130_fd_pr__special_nfet_01v8 ad=0.0711 pd=0.755 as=0.0999 ps=0.985 w=0.36 l=0.15
X622 VPWR _35_.B _36_.A VPWR sky130_fd_pr__pfet_01v8_hvt ad=0.275 pd=2.55 as=0.135 ps=1.27 w=1 l=0.15
X623 VPWR VGND VPWR VPWR sky130_fd_pr__pfet_01v8_hvt ad=0.2262 pd=2.26 as=0 ps=0 w=0.87 l=0.59
X624 VPWR _57_.CLK a_6375_6037# VPWR sky130_fd_pr__pfet_01v8_hvt ad=0.0864 pd=0.91 as=0.1664 ps=1.8 w=0.64 l=0.15
X625 VGND VPWR VGND VGND sky130_fd_pr__nfet_01v8 ad=0.143 pd=1.62 as=0 ps=0 w=0.55 l=0.59
X626 VGND a_7907_4159# _55_.Q VGND sky130_fd_pr__nfet_01v8 ad=0.169 pd=1.82 as=0.08775 ps=0.92 w=0.65 l=0.15
X627 VPWR _25_.A _25_.Y VPWR sky130_fd_pr__pfet_01v8_hvt ad=0.26 pd=2.52 as=0.135 ps=1.27 w=1 l=0.15
X628 VGND a_8800_8207# a_8911_8207# VGND sky130_fd_pr__nfet_01v8 ad=0.1856 pd=1.26 as=0.17225 ps=1.83 w=0.65 l=0.25
X629 VPWR _34_.X a_7387_6575# VPWR sky130_fd_pr__pfet_01v8_hvt ad=0.19265 pd=1.415 as=0.27 ps=2.54 w=1 l=0.15
X630 a_2877_6005# a_2659_6409# VPWR VPWR sky130_fd_pr__pfet_01v8_hvt ad=0.12915 pd=1.185 as=0.2184 ps=2.2 w=0.84 l=0.15
X631 VPWR a_2452_6575# a_2563_6575# VPWR sky130_fd_pr__pfet_01v8_hvt ad=0.2726 pd=1.61 as=0.2173 ps=2.17 w=0.82 l=0.25
X632 a_1654_6575# _35_.B VGND VGND sky130_fd_pr__nfet_01v8 ad=0.091 pd=0.93 as=0.16535 ps=1.82 w=0.65 l=0.15
X633 a_4160_6575# _35_.B VGND VGND sky130_fd_pr__nfet_01v8 ad=0.08775 pd=0.92 as=0.08775 ps=0.92 w=0.65 l=0.15
X634 VPWR VGND VPWR VPWR sky130_fd_pr__pfet_01v8_hvt ad=0.2262 pd=2.26 as=0 ps=0 w=0.87 l=0.59
X635 VPWR VGND VPWR VPWR sky130_fd_pr__pfet_01v8_hvt ad=0.2262 pd=2.26 as=0 ps=0 w=0.87 l=0.59
X636 a_6444_4399# a_5363_4399# a_6097_4641# VPWR sky130_fd_pr__pfet_01v8_hvt ad=0.0588 pd=0.7 as=0.12915 ps=1.185 w=0.42 l=0.15
X637 VPWR VGND VPWR VPWR sky130_fd_pr__pfet_01v8_hvt ad=0.2262 pd=2.26 as=0 ps=0 w=0.87 l=0.59
X638 a_3436_6549# _34_.X VGND VGND sky130_fd_pr__nfet_01v8 ad=0.1134 pd=1.38 as=0.1228 ps=1.065 w=0.42 l=0.15
X639 VGND VPWR VGND VGND sky130_fd_pr__nfet_01v8 ad=0.143 pd=1.62 as=0 ps=0 w=0.55 l=0.59
X640 VPWR _23_.A _23_.Y VPWR sky130_fd_pr__pfet_01v8_hvt ad=0.26 pd=2.52 as=0.135 ps=1.27 w=1 l=0.15
X641 a_7903_5321# a_7387_4949# a_7808_5309# VGND sky130_fd_pr__special_nfet_01v8 ad=0.0594 pd=0.69 as=0.066 ps=0.745 w=0.36 l=0.15
X642 a_8086_4221# _55_.RESET_B VGND VGND sky130_fd_pr__nfet_01v8 ad=0.06405 pd=0.725 as=0.12495 ps=1.015 w=0.42 l=0.15
X643 a_2123_8029# u_loop.u_gh.C VPWR VPWR sky130_fd_pr__pfet_01v8_hvt ad=0.1092 pd=1.36 as=0.07035 ps=0.755 w=0.42 l=0.15
X644 VPWR a_2580_7663# a_2755_7637# VPWR sky130_fd_pr__pfet_01v8_hvt ad=0.1134 pd=1.38 as=0.0567 ps=0.69 w=0.42 l=0.15
X645 VGND output7.A a_4075_2223# VGND sky130_fd_pr__nfet_01v8 ad=0.1228 pd=1.065 as=0.1134 ps=1.38 w=0.42 l=0.15
X646 a_2580_7663# a_1665_7663# a_2233_7905# VGND sky130_fd_pr__special_nfet_01v8 ad=0.0711 pd=0.755 as=0.0999 ps=0.985 w=0.36 l=0.15
X647 VPWR VGND VPWR VPWR sky130_fd_pr__pfet_01v8_hvt ad=0.2262 pd=2.26 as=0 ps=0 w=0.87 l=0.59
X648 u_loop.u_qb.A u_loop.u_s1.Y VGND VGND sky130_fd_pr__nfet_01v8 ad=0.169 pd=1.82 as=0.169 ps=1.82 w=0.65 l=0.15
X649 a_3224_6409# a_2143_6037# a_2877_6005# VPWR sky130_fd_pr__pfet_01v8_hvt ad=0.0588 pd=0.7 as=0.12915 ps=1.185 w=0.42 l=0.15
X650 _67_.D VPWR sky130_fd_pr__res_generic_po w=0.48 l=0.045
X651 VPWR _63_.Q _63_.D VPWR sky130_fd_pr__pfet_01v8_hvt ad=0.26 pd=2.52 as=0.135 ps=1.27 w=1 l=0.15
X652 VGND _35_.A_N a_4167_6147# VGND sky130_fd_pr__nfet_01v8 ad=0.194 pd=1.95 as=0.1092 ps=1.36 w=0.42 l=0.15
X653 VGND VPWR VGND VGND sky130_fd_pr__nfet_01v8 ad=0.143 pd=1.62 as=0 ps=0 w=0.55 l=0.59
X654 VGND a_8643_7423# _68_.Q VGND sky130_fd_pr__nfet_01v8 ad=0.169 pd=1.82 as=0.08775 ps=0.92 w=0.65 l=0.15
X655 VPWR VGND VPWR VPWR sky130_fd_pr__pfet_01v8_hvt ad=0.2262 pd=2.26 as=0 ps=0 w=0.87 l=0.59
X656 _55_.Q a_7907_4159# VPWR VPWR sky130_fd_pr__pfet_01v8_hvt ad=0.135 pd=1.27 as=0.3012 ps=2.66 w=1 l=0.15
X657 VGND VPWR VGND VGND sky130_fd_pr__nfet_01v8 ad=0.143 pd=1.62 as=0 ps=0 w=0.55 l=0.59
X658 a_4510_3311# u_loop.u_gl.A2 VGND VGND sky130_fd_pr__nfet_01v8 ad=0.091 pd=0.93 as=0.091 ps=0.93 w=0.65 l=0.15
X659 VGND _56_.CLK a_5363_4399# VGND sky130_fd_pr__nfet_01v8 ad=0.0567 pd=0.69 as=0.1092 ps=1.36 w=0.42 l=0.15
X660 VGND _48_.Y a_4351_9301# VGND sky130_fd_pr__nfet_01v8 ad=0.0567 pd=0.69 as=0.1092 ps=1.36 w=0.42 l=0.15
X661 VPWR a_8121_7093# a_8011_7119# VPWR sky130_fd_pr__pfet_01v8_hvt ad=0.07035 pd=0.755 as=0.1155 ps=0.97 w=0.42 l=0.15
X662 VGND a_7631_6335# a_7565_6409# VGND sky130_fd_pr__nfet_01v8 ad=0.12495 pd=1.015 as=0.0669 ps=0.75 w=0.42 l=0.15
X663 VGND VPWR VGND VGND sky130_fd_pr__nfet_01v8 ad=0.143 pd=1.62 as=0 ps=0 w=0.55 l=0.59
X664 VPWR VGND VPWR VPWR sky130_fd_pr__pfet_01v8_hvt ad=0.2262 pd=2.26 as=0 ps=0 w=0.87 l=0.59
X665 a_1920_7663# _63_.D VPWR VPWR sky130_fd_pr__pfet_01v8_hvt ad=0.0651 pd=0.73 as=0.1092 ps=1.36 w=0.42 l=0.15
X666 a_1624_7119# a_1407_7119# VGND VGND sky130_fd_pr__nfet_01v8 ad=0.17225 pd=1.83 as=0.1228 ps=1.065 w=0.65 l=0.25
X667 a_8577_7497# a_7387_7125# a_8468_7497# VGND sky130_fd_pr__special_nfet_01v8 ad=0.0669 pd=0.75 as=0.0711 ps=0.755 w=0.36 l=0.15
X668 VGND a_5607_9599# _39_.B2 VGND sky130_fd_pr__nfet_01v8 ad=0.169 pd=1.82 as=0.08775 ps=0.92 w=0.65 l=0.15
X669 VGND _40_.B _49_.Y VGND sky130_fd_pr__nfet_01v8 ad=0.169 pd=1.82 as=0.08775 ps=0.92 w=0.65 l=0.15
X670 VPWR a_7079_8725# _46_.A VPWR sky130_fd_pr__pfet_01v8_hvt ad=0.26 pd=2.52 as=0.135 ps=1.27 w=1 l=0.15
X671 _63_.D _63_.Q VGND VGND sky130_fd_pr__nfet_01v8 ad=0.08775 pd=0.92 as=0.169 ps=1.82 w=0.65 l=0.15
X672 a_7153_6397# a_7109_6005# a_6987_6409# VGND sky130_fd_pr__nfet_01v8 ad=0.0441 pd=0.63 as=0.1401 ps=1.1 w=0.42 l=0.15
X673 VPWR a_5190_5487# _41_.X VPWR sky130_fd_pr__pfet_01v8_hvt ad=0.26 pd=2.52 as=0.135 ps=1.27 w=1 l=0.15
X674 a_7841_4233# a_6651_3861# a_7732_4233# VGND sky130_fd_pr__special_nfet_01v8 ad=0.0669 pd=0.75 as=0.0711 ps=0.755 w=0.36 l=0.15
X675 VGND VPWR VGND VGND sky130_fd_pr__nfet_01v8 ad=0.143 pd=1.62 as=0 ps=0 w=0.55 l=0.59
X676 a_7066_9117# a_5989_8751# a_6904_8751# VPWR sky130_fd_pr__pfet_01v8_hvt ad=0.0567 pd=0.69 as=0.0588 ps=0.7 w=0.42 l=0.15
X677 u_loop.u_d2.X a_2967_2767# VPWR VPWR sky130_fd_pr__pfet_01v8_hvt ad=0.26 pd=2.52 as=0.14075 ps=1.325 w=1 l=0.15
X678 a_2861_2767# a_2625_2767# VPWR VPWR sky130_fd_pr__pfet_01v8_hvt ad=0.1092 pd=1.36 as=0.0567 ps=0.69 w=0.42 l=0.5
X679 VPWR u_loop.u_gl.A2 a_4076_3561# VPWR sky130_fd_pr__pfet_01v8_hvt ad=0.145 pd=1.29 as=0.155 ps=1.31 w=1 l=0.15
X680 VGND VPWR VGND VGND sky130_fd_pr__nfet_01v8 ad=0.143 pd=1.62 as=0 ps=0 w=0.55 l=0.59
X681 a_3549_9661# a_3170_9295# a_3477_9661# VGND sky130_fd_pr__nfet_01v8 ad=0.1401 pd=1.1 as=0.0441 ps=0.63 w=0.42 l=0.15
X682 a_6999_6031# a_6375_6037# a_6891_6409# VPWR sky130_fd_pr__pfet_01v8_hvt ad=0.1155 pd=0.97 as=0.07245 ps=0.765 w=0.42 l=0.15
X683 VPWR VGND VPWR VPWR sky130_fd_pr__pfet_01v8_hvt ad=0.2262 pd=2.26 as=0 ps=0 w=0.87 l=0.59
X684 a_7999_7497# a_7553_7125# a_7903_7497# VGND sky130_fd_pr__special_nfet_01v8 ad=0.1401 pd=1.1 as=0.0594 ps=0.69 w=0.36 l=0.15
X685 VPWR VGND VPWR VPWR sky130_fd_pr__pfet_01v8_hvt ad=0.2262 pd=2.26 as=0 ps=0 w=0.87 l=0.59
X686 u_loop.u_d1.X a_2875_2223# VGND VGND sky130_fd_pr__nfet_01v8 ad=0.169 pd=1.82 as=0.097 ps=0.975 w=0.65 l=0.15
X687 a_5764_2223# a_5547_2223# VGND VGND sky130_fd_pr__nfet_01v8 ad=0.17225 pd=1.83 as=0.1228 ps=1.065 w=0.65 l=0.25
X688 a_2399_4765# u_loop.u_gh.C VPWR VPWR sky130_fd_pr__pfet_01v8_hvt ad=0.1092 pd=1.36 as=0.07035 ps=0.755 w=0.42 l=0.15
X689 VGND VPWR VGND VGND sky130_fd_pr__nfet_01v8 ad=0.143 pd=1.62 as=0 ps=0 w=0.55 l=0.59
X690 VGND VPWR VGND VGND sky130_fd_pr__nfet_01v8 ad=0.143 pd=1.62 as=0 ps=0 w=0.55 l=0.59
X691 _55_.RESET_B a_7715_6575# VPWR VPWR sky130_fd_pr__pfet_01v8_hvt ad=0.495 pd=2.99 as=0.2726 ps=1.61 w=1 l=0.15
X692 a_1624_6031# a_1407_6031# VGND VGND sky130_fd_pr__nfet_01v8 ad=0.17225 pd=1.83 as=0.1228 ps=1.065 w=0.65 l=0.25
X693 a_2580_7663# a_1499_7663# a_2233_7905# VPWR sky130_fd_pr__pfet_01v8_hvt ad=0.0588 pd=0.7 as=0.12915 ps=1.185 w=0.42 l=0.15
X694 VPWR a_3992_7235# _41_.C1 VPWR sky130_fd_pr__pfet_01v8_hvt ad=0.14575 pd=1.335 as=0.135 ps=1.27 w=1 l=0.15
X695 VGND VPWR VGND VGND sky130_fd_pr__nfet_01v8 ad=0.143 pd=1.62 as=0 ps=0 w=0.55 l=0.59
X696 VGND _32_.A _56_.CLK VGND sky130_fd_pr__nfet_01v8 ad=0.169 pd=1.82 as=0.08775 ps=0.92 w=0.65 l=0.15
X697 a_3478_4943# a_2401_4949# a_3316_5321# VPWR sky130_fd_pr__pfet_01v8_hvt ad=0.0567 pd=0.69 as=0.0588 ps=0.7 w=0.42 l=0.15
X698 a_7903_5321# a_7553_4949# a_7808_5309# VPWR sky130_fd_pr__pfet_01v8_hvt ad=0.07245 pd=0.765 as=0.0651 ps=0.73 w=0.42 l=0.15
X699 a_5805_2767# a_5569_2767# VGND VGND sky130_fd_pr__nfet_01v8 ad=0.1092 pd=1.36 as=0.0567 ps=0.69 w=0.42 l=0.5
X700 a_6601_8751# a_6557_8993# a_6435_8751# VGND sky130_fd_pr__nfet_01v8 ad=0.0441 pd=0.63 as=0.1401 ps=1.1 w=0.42 l=0.15
X701 VPWR VGND VPWR VPWR sky130_fd_pr__pfet_01v8_hvt ad=0.2262 pd=2.26 as=0 ps=0 w=0.87 l=0.59
X702 VPWR VGND VPWR VPWR sky130_fd_pr__pfet_01v8_hvt ad=0.2262 pd=2.26 as=0 ps=0 w=0.87 l=0.59
X703 prenl a_4403_2223# VGND VGND sky130_fd_pr__nfet_01v8 ad=0.2079 pd=1.83 as=0.1856 ps=1.26 w=0.42 l=0.15
X704 VGND VPWR VGND VGND sky130_fd_pr__nfet_01v8 ad=0.143 pd=1.62 as=0 ps=0 w=0.55 l=0.59
X705 VGND VPWR VGND VGND sky130_fd_pr__nfet_01v8 ad=0.143 pd=1.62 as=0 ps=0 w=0.55 l=0.59
X706 VPWR a_6557_8993# a_6447_9117# VPWR sky130_fd_pr__pfet_01v8_hvt ad=0.07035 pd=0.755 as=0.1155 ps=0.97 w=0.42 l=0.15
X707 a_3215_8585# a_2769_8213# a_3119_8585# VGND sky130_fd_pr__special_nfet_01v8 ad=0.1401 pd=1.1 as=0.0594 ps=0.69 w=0.36 l=0.15
X708 VPWR _35_.B a_4518_6825# VPWR sky130_fd_pr__pfet_01v8_hvt ad=0.1625 pd=1.325 as=0.135 ps=1.27 w=1 l=0.15
X709 _42_.Y _55_.Q VGND VGND sky130_fd_pr__nfet_01v8 ad=0.08775 pd=0.92 as=0.169 ps=1.82 w=0.65 l=0.15
X710 a_4975_9295# u_loop.u_gh.C VPWR VPWR sky130_fd_pr__pfet_01v8_hvt ad=0.1092 pd=1.36 as=0.07035 ps=0.755 w=0.42 l=0.15
X711 VPWR _50_.Y a_2603_8213# VPWR sky130_fd_pr__pfet_01v8_hvt ad=0.0864 pd=0.91 as=0.1664 ps=1.8 w=0.64 l=0.15
X712 a_6633_2767# a_6397_2767# VGND VGND sky130_fd_pr__nfet_01v8 ad=0.1092 pd=1.36 as=0.0567 ps=0.69 w=0.42 l=0.5
X713 VPWR VGND VPWR VPWR sky130_fd_pr__pfet_01v8_hvt ad=0.2262 pd=2.26 as=0 ps=0 w=0.87 l=0.59
X714 VPWR x a_5547_2223# VPWR sky130_fd_pr__pfet_01v8_hvt ad=0.19265 pd=1.415 as=0.27 ps=2.54 w=1 l=0.15
X715 VGND VPWR VGND VGND sky130_fd_pr__nfet_01v8 ad=0.143 pd=1.62 as=0 ps=0 w=0.55 l=0.59
X716 VGND a_2479_9269# _30_.A VGND sky130_fd_pr__nfet_01v8 ad=0.2087 pd=2.02 as=0.08775 ps=0.92 w=0.65 l=0.15
X717 _41_.C1 a_3992_7235# VGND VGND sky130_fd_pr__nfet_01v8 ad=0.08775 pd=0.92 as=0.10187 ps=0.99 w=0.65 l=0.15
X718 a_8011_4943# a_7387_4949# a_7903_5321# VPWR sky130_fd_pr__pfet_01v8_hvt ad=0.1155 pd=0.97 as=0.07245 ps=0.765 w=0.42 l=0.15
X719 VPWR a_5432_9673# a_5607_9599# VPWR sky130_fd_pr__pfet_01v8_hvt ad=0.1134 pd=1.38 as=0.0567 ps=0.69 w=0.42 l=0.15
X720 VPWR VGND VPWR VPWR sky130_fd_pr__pfet_01v8_hvt ad=0.2262 pd=2.26 as=0 ps=0 w=0.87 l=0.59
X721 VGND VPWR VGND VGND sky130_fd_pr__nfet_01v8 ad=0.143 pd=1.62 as=0 ps=0 w=0.55 l=0.59
X722 a_4075_6825# _35_.B a_4160_6575# VPWR sky130_fd_pr__pfet_01v8_hvt ad=0.26 pd=2.52 as=0.135 ps=1.27 w=1 l=0.15
X723 VPWR a_2969_4917# a_2859_4943# VPWR sky130_fd_pr__pfet_01v8_hvt ad=0.07035 pd=0.755 as=0.1155 ps=0.97 w=0.42 l=0.15
X724 a_3239_9269# a_3083_9537# a_3384_9295# VPWR sky130_fd_pr__pfet_01v8_hvt ad=0.07245 pd=0.765 as=0.1155 ps=0.97 w=0.42 l=0.15
X725 VPWR VGND VPWR VPWR sky130_fd_pr__pfet_01v8_hvt ad=0.2262 pd=2.26 as=0 ps=0 w=0.87 l=0.59
X726 a_4510_3311# u_loop.u_gl.A2 VGND VGND sky130_fd_pr__nfet_01v8 ad=0.091 pd=0.93 as=0.104 ps=0.97 w=0.65 l=0.15
X727 VPWR VGND VPWR VPWR sky130_fd_pr__pfet_01v8_hvt ad=0.2262 pd=2.26 as=0 ps=0 w=0.87 l=0.59
X728 _62_.D _40_.B VPWR VPWR sky130_fd_pr__pfet_01v8_hvt ad=0.135 pd=1.27 as=0.26 ps=2.52 w=1 l=0.15
X729 _21_.Y _39_.B2 VPWR VPWR sky130_fd_pr__pfet_01v8_hvt ad=0.135 pd=1.27 as=0.26 ps=2.52 w=1 l=0.15
X730 a_2111_7663# a_1665_7663# a_2015_7663# VGND sky130_fd_pr__special_nfet_01v8 ad=0.1401 pd=1.1 as=0.0594 ps=0.69 w=0.36 l=0.15
X731 VGND _35_.A_N a_1654_6575# VGND sky130_fd_pr__nfet_01v8 ad=0.104 pd=0.97 as=0.091 ps=0.93 w=0.65 l=0.15
X732 VGND VPWR VGND VGND sky130_fd_pr__nfet_01v8 ad=0.143 pd=1.62 as=0 ps=0 w=0.55 l=0.59
X733 a_4772_9661# _21_.Y VPWR VPWR sky130_fd_pr__pfet_01v8_hvt ad=0.0651 pd=0.73 as=0.1092 ps=1.36 w=0.42 l=0.15
X734 VGND _55_.RESET_B a_6141_4399# VGND sky130_fd_pr__nfet_01v8 ad=0.1346 pd=1.15 as=0.0441 ps=0.63 w=0.42 l=0.15
X735 VGND u_loop.u_gh.C a_5129_9661# VGND sky130_fd_pr__nfet_01v8 ad=0.1346 pd=1.15 as=0.0441 ps=0.63 w=0.42 l=0.15
X736 output6.A u_loop.u_q.Y VPWR VPWR sky130_fd_pr__pfet_01v8_hvt ad=0.135 pd=1.27 as=0.135 ps=1.27 w=1 l=0.15
X737 a_3802_9295# a_3044_9411# a_3239_9269# VPWR sky130_fd_pr__pfet_01v8_hvt ad=0.0651 pd=0.73 as=0.07245 ps=0.765 w=0.42 l=0.15
X738 a_5085_9269# a_4867_9673# VPWR VPWR sky130_fd_pr__pfet_01v8_hvt ad=0.12915 pd=1.185 as=0.2184 ps=2.2 w=0.84 l=0.15
X739 VPWR _46_.A _46_.Y VPWR sky130_fd_pr__pfet_01v8_hvt ad=0.26 pd=2.52 as=0.135 ps=1.27 w=1 l=0.15
X740 a_7808_7485# _68_.D VGND VGND sky130_fd_pr__nfet_01v8 ad=0.066 pd=0.745 as=0.2205 ps=1.89 w=0.42 l=0.15
X741 VPWR VGND VPWR VPWR sky130_fd_pr__pfet_01v8_hvt ad=0.2262 pd=2.26 as=0 ps=0 w=0.87 l=0.59
X742 VPWR VGND VPWR VPWR sky130_fd_pr__pfet_01v8_hvt ad=0.2262 pd=2.26 as=0 ps=0 w=0.87 l=0.59
X743 VPWR a_7732_4233# a_7907_4159# VPWR sky130_fd_pr__pfet_01v8_hvt ad=0.1134 pd=1.38 as=0.0567 ps=0.69 w=0.42 l=0.15
X744 a_3846_8207# a_2769_8213# a_3684_8585# VPWR sky130_fd_pr__pfet_01v8_hvt ad=0.0567 pd=0.69 as=0.0588 ps=0.7 w=0.42 l=0.15
X745 _68_.Q a_8643_7423# VPWR VPWR sky130_fd_pr__pfet_01v8_hvt ad=0.135 pd=1.27 as=0.3012 ps=2.66 w=1 l=0.15
X746 a_4518_6825# a_4160_6575# _41_.B1 VPWR sky130_fd_pr__pfet_01v8_hvt ad=0.28 pd=2.56 as=0.135 ps=1.27 w=1 l=0.15
X747 _57_.CLK _45_.A VGND VGND sky130_fd_pr__nfet_01v8 ad=0.08775 pd=0.92 as=0.169 ps=1.82 w=0.65 l=0.15
X748 a_7061_7663# a_7017_7905# a_6895_7663# VGND sky130_fd_pr__nfet_01v8 ad=0.0441 pd=0.63 as=0.1401 ps=1.1 w=0.42 l=0.15
X749 a_3381_8573# a_3337_8181# a_3215_8585# VGND sky130_fd_pr__nfet_01v8 ad=0.0441 pd=0.63 as=0.1401 ps=1.1 w=0.42 l=0.15
X750 a_4160_6575# _35_.A_N VGND VGND sky130_fd_pr__nfet_01v8 ad=0.08775 pd=0.92 as=0.17875 ps=1.85 w=0.65 l=0.15
X751 a_5432_9673# a_4351_9301# a_5085_9269# VPWR sky130_fd_pr__pfet_01v8_hvt ad=0.0588 pd=0.7 as=0.12915 ps=1.185 w=0.42 l=0.15
X752 VPWR _46_.Y a_6283_7663# VPWR sky130_fd_pr__pfet_01v8_hvt ad=0.0864 pd=0.91 as=0.1664 ps=1.8 w=0.64 l=0.15
X753 VPWR a_7017_7905# a_6907_8029# VPWR sky130_fd_pr__pfet_01v8_hvt ad=0.07035 pd=0.755 as=0.1155 ps=0.97 w=0.42 l=0.15
X754 a_4518_6825# _35_.B VPWR VPWR sky130_fd_pr__pfet_01v8_hvt ad=0.26 pd=2.52 as=0.1625 ps=1.325 w=1 l=0.15
X755 VGND VPWR VGND VGND sky130_fd_pr__nfet_01v8 ad=0.143 pd=1.62 as=0 ps=0 w=0.55 l=0.59
X756 VPWR a_2861_2767# a_2967_2767# VPWR sky130_fd_pr__pfet_01v8_hvt ad=0.14075 pd=1.325 as=0.1092 ps=1.36 w=0.42 l=0.5
X757 a_7072_4221# _55_.D VPWR VPWR sky130_fd_pr__pfet_01v8_hvt ad=0.0651 pd=0.73 as=0.1092 ps=1.36 w=0.42 l=0.15
X758 VPWR _39_.B2 _47_.Y VPWR sky130_fd_pr__pfet_01v8_hvt ad=0.26 pd=2.52 as=0.135 ps=1.27 w=1 l=0.15
X759 VPWR a_3859_8511# _40_.B VPWR sky130_fd_pr__pfet_01v8_hvt ad=0.26 pd=2.52 as=0.135 ps=1.27 w=1 l=0.15
X760 VPWR a_8643_5247# _25_.A VPWR sky130_fd_pr__pfet_01v8_hvt ad=0.26 pd=2.52 as=0.135 ps=1.27 w=1 l=0.15
X761 VGND VPWR VGND VGND sky130_fd_pr__nfet_01v8 ad=0.143 pd=1.62 as=0 ps=0 w=0.55 l=0.59
X762 VPWR a_5190_7439# _39_.X VPWR sky130_fd_pr__pfet_01v8_hvt ad=0.26 pd=2.52 as=0.135 ps=1.27 w=1 l=0.15
X763 VPWR VGND VPWR VPWR sky130_fd_pr__pfet_01v8_hvt ad=0.2262 pd=2.26 as=0 ps=0 w=0.87 l=0.59
X764 VPWR _47_.Y a_5823_8751# VPWR sky130_fd_pr__pfet_01v8_hvt ad=0.0864 pd=0.91 as=0.1664 ps=1.8 w=0.64 l=0.15
X765 VPWR VGND VPWR VPWR sky130_fd_pr__pfet_01v8_hvt ad=0.2262 pd=2.26 as=0 ps=0 w=0.87 l=0.59
X766 VGND VPWR VGND VGND sky130_fd_pr__nfet_01v8 ad=0.143 pd=1.62 as=0 ps=0 w=0.55 l=0.59
X767 a_7604_6575# a_7387_6575# VPWR VPWR sky130_fd_pr__pfet_01v8_hvt ad=0.2173 pd=2.17 as=0.19265 ps=1.415 w=0.82 l=0.25
X768 _30_.A a_2479_9269# VPWR VPWR sky130_fd_pr__pfet_01v8_hvt ad=0.135 pd=1.27 as=0.26 ps=2.52 w=1 l=0.15
X769 _30_.Y _30_.A VGND VGND sky130_fd_pr__nfet_01v8 ad=0.08775 pd=0.92 as=0.169 ps=1.82 w=0.65 l=0.15
X770 _39_.X a_5190_7439# VGND VGND sky130_fd_pr__nfet_01v8 ad=0.08775 pd=0.92 as=0.08775 ps=0.92 w=0.65 l=0.15
X771 a_7093_5487# a_6927_5487# VGND VGND sky130_fd_pr__nfet_01v8 ad=0.1092 pd=1.36 as=0.0567 ps=0.69 w=0.42 l=0.15
X772 u_loop.u_d4.X a_4439_2767# VPWR VPWR sky130_fd_pr__pfet_01v8_hvt ad=0.26 pd=2.52 as=0.14075 ps=1.325 w=1 l=0.15
X773 VPWR VGND VPWR VPWR sky130_fd_pr__pfet_01v8_hvt ad=0.2262 pd=2.26 as=0 ps=0 w=0.87 l=0.59
X774 VGND VPWR VGND VGND sky130_fd_pr__nfet_01v8 ad=0.143 pd=1.62 as=0 ps=0 w=0.55 l=0.59
X775 VGND VPWR VGND VGND sky130_fd_pr__nfet_01v8 ad=0.143 pd=1.62 as=0 ps=0 w=0.55 l=0.59
X776 VGND VPWR VGND VGND sky130_fd_pr__nfet_01v8 ad=0.143 pd=1.62 as=0 ps=0 w=0.55 l=0.59
X777 a_3210_4399# u_loop.u_gh.C VGND VGND sky130_fd_pr__nfet_01v8 ad=0.06405 pd=0.725 as=0.12495 ps=1.015 w=0.42 l=0.15
X778 VGND a_3239_9269# a_3170_9295# VGND sky130_fd_pr__nfet_01v8 ad=0.1346 pd=1.15 as=0.0999 ps=0.985 w=0.64 l=0.15
X779 VGND a_2452_6575# a_2563_6575# VGND sky130_fd_pr__nfet_01v8 ad=0.1856 pd=1.26 as=0.17225 ps=1.83 w=0.65 l=0.25
X780 VPWR VGND VPWR VPWR sky130_fd_pr__pfet_01v8_hvt ad=0.2262 pd=2.26 as=0 ps=0 w=0.87 l=0.59
X781 a_8822_5309# u_loop.u_gh.C VGND VGND sky130_fd_pr__nfet_01v8 ad=0.06405 pd=0.725 as=0.12495 ps=1.015 w=0.42 l=0.15
X782 a_3239_9269# a_3044_9411# a_3549_9661# VGND sky130_fd_pr__special_nfet_01v8 ad=0.0594 pd=0.69 as=0.1401 ps=1.1 w=0.36 l=0.15
X783 VPWR VGND VPWR VPWR sky130_fd_pr__pfet_01v8_hvt ad=0.2262 pd=2.26 as=0 ps=0 w=0.87 l=0.59
X784 a_3119_8585# a_2769_8213# a_3024_8573# VPWR sky130_fd_pr__pfet_01v8_hvt ad=0.07245 pd=0.765 as=0.0651 ps=0.73 w=0.42 l=0.15
X785 a_2742_8029# a_1665_7663# a_2580_7663# VPWR sky130_fd_pr__pfet_01v8_hvt ad=0.0567 pd=0.69 as=0.0588 ps=0.7 w=0.42 l=0.15
X786 VPWR VGND VPWR VPWR sky130_fd_pr__pfet_01v8_hvt ad=0.2262 pd=2.26 as=0 ps=0 w=0.87 l=0.59
X787 VGND a_7079_8725# a_7013_8751# VGND sky130_fd_pr__nfet_01v8 ad=0.12495 pd=1.015 as=0.0669 ps=0.75 w=0.42 l=0.15
X788 VGND VPWR VGND VGND sky130_fd_pr__nfet_01v8 ad=0.143 pd=1.62 as=0 ps=0 w=0.55 l=0.59
X789 VGND _53_.A _53_.Y VGND sky130_fd_pr__nfet_01v8 ad=0.169 pd=1.82 as=0.08775 ps=0.92 w=0.65 l=0.15
X790 a_6619_4373# _55_.RESET_B VPWR VPWR sky130_fd_pr__pfet_01v8_hvt ad=0.0567 pd=0.69 as=0.0819 ps=0.81 w=0.42 l=0.15
X791 VGND VPWR VGND VGND sky130_fd_pr__nfet_01v8 ad=0.143 pd=1.62 as=0 ps=0 w=0.55 l=0.59
X792 VPWR VGND VPWR VPWR sky130_fd_pr__pfet_01v8_hvt ad=0.2262 pd=2.26 as=0 ps=0 w=0.87 l=0.59
X793 VPWR VGND VPWR VPWR sky130_fd_pr__pfet_01v8_hvt ad=0.2262 pd=2.26 as=0 ps=0 w=0.87 l=0.59
X794 VGND VPWR VGND VGND sky130_fd_pr__nfet_01v8 ad=0.143 pd=1.62 as=0 ps=0 w=0.55 l=0.59
X795 VGND _36_.A u_loop.u_gh.B VGND sky130_fd_pr__nfet_01v8 ad=0.169 pd=1.82 as=0.08775 ps=0.92 w=0.65 l=0.15
X796 VPWR a_8800_6031# a_8911_6031# VPWR sky130_fd_pr__pfet_01v8_hvt ad=0.2726 pd=1.61 as=0.2173 ps=2.17 w=0.82 l=0.25
X797 VPWR VGND VPWR VPWR sky130_fd_pr__pfet_01v8_hvt ad=0.2262 pd=2.26 as=0 ps=0 w=0.87 l=0.59
X798 VPWR VGND VPWR VPWR sky130_fd_pr__pfet_01v8_hvt ad=0.2262 pd=2.26 as=0 ps=0 w=0.87 l=0.59
X799 a_3227_8207# a_2603_8213# a_3119_8585# VPWR sky130_fd_pr__pfet_01v8_hvt ad=0.1155 pd=0.97 as=0.07245 ps=0.765 w=0.42 l=0.15
X800 a_3399_6335# u_loop.u_gh.C VPWR VPWR sky130_fd_pr__pfet_01v8_hvt ad=0.0567 pd=0.69 as=0.0819 ps=0.81 w=0.42 l=0.15
X801 a_7631_6335# _55_.RESET_B VPWR VPWR sky130_fd_pr__pfet_01v8_hvt ad=0.0567 pd=0.69 as=0.0819 ps=0.81 w=0.42 l=0.15
X802 VPWR a_2125_2767# a_2231_2767# VPWR sky130_fd_pr__pfet_01v8_hvt ad=0.14075 pd=1.325 as=0.1092 ps=1.36 w=0.42 l=0.5
X803 a_5377_5487# _41_.B1 a_5293_5487# VGND sky130_fd_pr__nfet_01v8 ad=0.08775 pd=0.92 as=0.08775 ps=0.92 w=0.65 l=0.15
X804 VGND VPWR VGND VGND sky130_fd_pr__nfet_01v8 ad=0.143 pd=1.62 as=0 ps=0 w=0.55 l=0.59
X805 a_7539_7637# a_7364_7663# a_7718_7663# VGND sky130_fd_pr__nfet_01v8 ad=0.1092 pd=1.36 as=0.06405 ps=0.725 w=0.42 l=0.15
X806 VGND VPWR VGND VGND sky130_fd_pr__nfet_01v8 ad=0.143 pd=1.62 as=0 ps=0 w=0.55 l=0.59
X807 VGND _56_.Q _56_.D VGND sky130_fd_pr__nfet_01v8 ad=0.169 pd=1.82 as=0.08775 ps=0.92 w=0.65 l=0.15
X808 VPWR VGND VPWR VPWR sky130_fd_pr__pfet_01v8_hvt ad=0.2262 pd=2.26 as=0 ps=0 w=0.87 l=0.59
X809 VGND VPWR VGND VGND sky130_fd_pr__nfet_01v8 ad=0.143 pd=1.62 as=0 ps=0 w=0.55 l=0.59
X810 VGND _40_.B _62_.D VGND sky130_fd_pr__nfet_01v8 ad=0.169 pd=1.82 as=0.08775 ps=0.92 w=0.65 l=0.15
X811 output6.A u_loop.u_gh.C VPWR VPWR sky130_fd_pr__pfet_01v8_hvt ad=0.135 pd=1.27 as=0.26 ps=2.52 w=1 l=0.15
X812 VGND VPWR VGND VGND sky130_fd_pr__nfet_01v8 ad=0.143 pd=1.62 as=0 ps=0 w=0.55 l=0.59
X813 VGND VPWR VGND VGND sky130_fd_pr__nfet_01v8 ad=0.143 pd=1.62 as=0 ps=0 w=0.55 l=0.59
X814 a_1920_7663# _63_.D VGND VGND sky130_fd_pr__nfet_01v8 ad=0.066 pd=0.745 as=0.2205 ps=1.89 w=0.42 l=0.15
X815 VGND a_4292_2223# a_4403_2223# VGND sky130_fd_pr__nfet_01v8 ad=0.1856 pd=1.26 as=0.17225 ps=1.83 w=0.65 l=0.25
X816 a_4076_3561# u_loop.u_gl.A2 VPWR VPWR sky130_fd_pr__pfet_01v8_hvt ad=0.265 pd=2.53 as=0.14 ps=1.28 w=1 l=0.15
X817 a_3337_8181# a_3119_8585# VGND VGND sky130_fd_pr__nfet_01v8 ad=0.0999 pd=0.985 as=0.1346 ps=1.15 w=0.64 l=0.15
X818 a_1665_7663# a_1499_7663# VGND VGND sky130_fd_pr__nfet_01v8 ad=0.1092 pd=1.36 as=0.0567 ps=0.69 w=0.42 l=0.15
X819 u_loop.u_gh.B _36_.A VPWR VPWR sky130_fd_pr__pfet_01v8_hvt ad=0.135 pd=1.27 as=0.26 ps=2.52 w=1 l=0.15
X820 VGND a_5069_2767# a_5175_2767# VGND sky130_fd_pr__nfet_01v8 ad=0.097 pd=0.975 as=0.1092 ps=1.36 w=0.42 l=0.5
X821 VGND a_7907_4159# a_7841_4233# VGND sky130_fd_pr__nfet_01v8 ad=0.12495 pd=1.015 as=0.0669 ps=0.75 w=0.42 l=0.15
X822 VGND VPWR VGND VGND sky130_fd_pr__nfet_01v8 ad=0.143 pd=1.62 as=0 ps=0 w=0.55 l=0.59
X823 a_6817_3861# a_6651_3861# VPWR VPWR sky130_fd_pr__pfet_01v8_hvt ad=0.1664 pd=1.8 as=0.0864 ps=0.91 w=0.64 l=0.15
X824 output6.A u_loop.u_q.Y VPWR VPWR sky130_fd_pr__pfet_01v8_hvt ad=0.135 pd=1.27 as=0.26 ps=2.52 w=1 l=0.15
X825 VPWR VGND VPWR VPWR sky130_fd_pr__pfet_01v8_hvt ad=0.2262 pd=2.26 as=0 ps=0 w=0.87 l=0.59
X826 VPWR VGND VPWR VPWR sky130_fd_pr__pfet_01v8_hvt ad=0.2262 pd=2.26 as=0 ps=0 w=0.87 l=0.59
X827 a_5879_4399# a_5363_4399# a_5784_4399# VGND sky130_fd_pr__special_nfet_01v8 ad=0.0594 pd=0.69 as=0.066 ps=0.745 w=0.36 l=0.15
X828 VPWR VGND VPWR VPWR sky130_fd_pr__pfet_01v8_hvt ad=0.2262 pd=2.26 as=0 ps=0 w=0.87 l=0.59
X829 _56_.D _56_.Q VPWR VPWR sky130_fd_pr__pfet_01v8_hvt ad=0.135 pd=1.27 as=0.26 ps=2.52 w=1 l=0.15
X830 VGND pre a_1407_6031# VGND sky130_fd_pr__nfet_01v8 ad=0.1228 pd=1.065 as=0.1134 ps=1.38 w=0.42 l=0.15
X831 a_2969_4917# a_2751_5321# VGND VGND sky130_fd_pr__nfet_01v8 ad=0.0999 pd=0.985 as=0.1346 ps=1.15 w=0.64 l=0.15
X832 VPWR VGND VPWR VPWR sky130_fd_pr__pfet_01v8_hvt ad=0.2262 pd=2.26 as=0 ps=0 w=0.87 l=0.59
X833 _55_.D _55_.Q VGND VGND sky130_fd_pr__nfet_01v8 ad=0.08775 pd=0.92 as=0.169 ps=1.82 w=0.65 l=0.15
X834 VPWR VGND VPWR VPWR sky130_fd_pr__pfet_01v8_hvt ad=0.2262 pd=2.26 as=0 ps=0 w=0.87 l=0.59
X835 VPWR a_7631_6335# a_7618_6031# VPWR sky130_fd_pr__pfet_01v8_hvt ad=0.0819 pd=0.81 as=0.0567 ps=0.69 w=0.42 l=0.15
X836 VPWR VGND VPWR VPWR sky130_fd_pr__pfet_01v8_hvt ad=0.2262 pd=2.26 as=0 ps=0 w=0.87 l=0.59
X837 VGND _45_.A _22_.Y VGND sky130_fd_pr__nfet_01v8 ad=0.169 pd=1.82 as=0.08775 ps=0.92 w=0.65 l=0.15
X838 a_5594_9295# a_4517_9301# a_5432_9673# VPWR sky130_fd_pr__pfet_01v8_hvt ad=0.0567 pd=0.69 as=0.0588 ps=0.7 w=0.42 l=0.15
X839 VGND _28_.A _52_.Y VGND sky130_fd_pr__nfet_01v8 ad=0.169 pd=1.82 as=0.08775 ps=0.92 w=0.65 l=0.15
X840 VGND u_loop.u_d2.X a_3361_2767# VGND sky130_fd_pr__nfet_01v8 ad=0.0567 pd=0.69 as=0.1092 ps=1.36 w=0.42 l=0.15
X841 a_6097_4641# a_5879_4399# VGND VGND sky130_fd_pr__nfet_01v8 ad=0.0999 pd=0.985 as=0.1346 ps=1.15 w=0.64 l=0.15
X842 _50_.Y _63_.Q VGND VGND sky130_fd_pr__nfet_01v8 ad=0.08775 pd=0.92 as=0.169 ps=1.82 w=0.65 l=0.15
X843 VPWR VGND VPWR VPWR sky130_fd_pr__pfet_01v8_hvt ad=0.2262 pd=2.26 as=0 ps=0 w=0.87 l=0.59
X844 VPWR VGND VPWR VPWR sky130_fd_pr__pfet_01v8_hvt ad=0.2262 pd=2.26 as=0 ps=0 w=0.87 l=0.59
X845 VPWR VGND VPWR VPWR sky130_fd_pr__pfet_01v8_hvt ad=0.2262 pd=2.26 as=0 ps=0 w=0.87 l=0.59
X846 VGND VPWR VGND VGND sky130_fd_pr__nfet_01v8 ad=0.143 pd=1.62 as=0 ps=0 w=0.55 l=0.59
X847 VGND VPWR VGND VGND sky130_fd_pr__nfet_01v8 ad=0.143 pd=1.62 as=0 ps=0 w=0.55 l=0.59
X848 a_2123_8029# a_1499_7663# a_2015_7663# VPWR sky130_fd_pr__pfet_01v8_hvt ad=0.1155 pd=0.97 as=0.07245 ps=0.765 w=0.42 l=0.15
X849 VGND a_8183_5461# a_8117_5487# VGND sky130_fd_pr__nfet_01v8 ad=0.12495 pd=1.015 as=0.0669 ps=0.75 w=0.42 l=0.15
X850 VGND _41_.X a_6927_5487# VGND sky130_fd_pr__nfet_01v8 ad=0.0567 pd=0.69 as=0.1092 ps=1.36 w=0.42 l=0.15
X851 u_loop.u_d6.X a_5911_2767# VGND VGND sky130_fd_pr__nfet_01v8 ad=0.169 pd=1.82 as=0.097 ps=0.975 w=0.65 l=0.15
X852 _56_.CLK _32_.A VPWR VPWR sky130_fd_pr__pfet_01v8_hvt ad=0.135 pd=1.27 as=0.26 ps=2.52 w=1 l=0.15
X853 a_7539_5487# a_7093_5487# a_7443_5487# VGND sky130_fd_pr__special_nfet_01v8 ad=0.1401 pd=1.1 as=0.0594 ps=0.69 w=0.36 l=0.15
X854 VPWR a_7907_4159# a_7894_3855# VPWR sky130_fd_pr__pfet_01v8_hvt ad=0.0819 pd=0.81 as=0.0567 ps=0.69 w=0.42 l=0.15
X855 a_7017_7905# a_6799_7663# VPWR VPWR sky130_fd_pr__pfet_01v8_hvt ad=0.12915 pd=1.185 as=0.2184 ps=2.2 w=0.84 l=0.15
X856 VPWR VGND VPWR VPWR sky130_fd_pr__pfet_01v8_hvt ad=0.2262 pd=2.26 as=0 ps=0 w=0.87 l=0.59
X857 VGND VPWR VGND VGND sky130_fd_pr__nfet_01v8 ad=0.143 pd=1.62 as=0 ps=0 w=0.55 l=0.59
X858 VPWR a_6097_4641# a_5987_4765# VPWR sky130_fd_pr__pfet_01v8_hvt ad=0.07035 pd=0.755 as=0.1155 ps=0.97 w=0.42 l=0.15
X859 VPWR VGND VPWR VPWR sky130_fd_pr__pfet_01v8_hvt ad=0.2262 pd=2.26 as=0 ps=0 w=0.87 l=0.59
X860 VGND VPWR VGND VGND sky130_fd_pr__nfet_01v8 ad=0.143 pd=1.62 as=0 ps=0 w=0.55 l=0.59
X861 VGND _35_.B a_4369_6351# VGND sky130_fd_pr__nfet_01v8 ad=0.08775 pd=0.92 as=0.08775 ps=0.92 w=0.65 l=0.15
X862 VGND VPWR VGND VGND sky130_fd_pr__nfet_01v8 ad=0.143 pd=1.62 as=0 ps=0 w=0.55 l=0.59
X863 VGND _55_.RESET_B a_6601_8751# VGND sky130_fd_pr__nfet_01v8 ad=0.1346 pd=1.15 as=0.0441 ps=0.63 w=0.42 l=0.15
X864 a_7079_8725# a_6904_8751# a_7258_8751# VGND sky130_fd_pr__nfet_01v8 ad=0.1092 pd=1.36 as=0.06405 ps=0.725 w=0.42 l=0.15
X865 a_1941_4399# a_1775_4399# VGND VGND sky130_fd_pr__nfet_01v8 ad=0.1092 pd=1.36 as=0.0567 ps=0.69 w=0.42 l=0.15
X866 VPWR VGND VPWR VPWR sky130_fd_pr__pfet_01v8_hvt ad=0.2262 pd=2.26 as=0 ps=0 w=0.87 l=0.59
X867 VGND VPWR VGND VGND sky130_fd_pr__nfet_01v8 ad=0.143 pd=1.62 as=0 ps=0 w=0.55 l=0.59
X868 a_3000_9295# a_2479_9269# VPWR VPWR sky130_fd_pr__pfet_01v8_hvt ad=0.0567 pd=0.69 as=0.0819 ps=0.81 w=0.42 l=0.15
X869 a_6557_8993# a_6339_8751# VPWR VPWR sky130_fd_pr__pfet_01v8_hvt ad=0.12915 pd=1.185 as=0.2184 ps=2.2 w=0.84 l=0.15
X870 VPWR VGND VPWR VPWR sky130_fd_pr__pfet_01v8_hvt ad=0.2262 pd=2.26 as=0 ps=0 w=0.87 l=0.59
X871 VPWR VGND VPWR VPWR sky130_fd_pr__pfet_01v8_hvt ad=0.2262 pd=2.26 as=0 ps=0 w=0.87 l=0.59
X872 VPWR u_loop.u_d5.X a_5569_2767# VPWR sky130_fd_pr__pfet_01v8_hvt ad=0.0567 pd=0.69 as=0.1092 ps=1.36 w=0.42 l=0.15
X873 VGND a_4333_2767# a_4439_2767# VGND sky130_fd_pr__nfet_01v8 ad=0.097 pd=0.975 as=0.1092 ps=1.36 w=0.42 l=0.5
X874 VGND VPWR VGND VGND sky130_fd_pr__nfet_01v8 ad=0.143 pd=1.62 as=0 ps=0 w=0.55 l=0.59
X875 _63_.CLK _23_.A VPWR VPWR sky130_fd_pr__pfet_01v8_hvt ad=0.135 pd=1.27 as=0.26 ps=2.52 w=1 l=0.15
X876 a_2921_6397# a_2877_6005# a_2755_6409# VGND sky130_fd_pr__nfet_01v8 ad=0.0441 pd=0.63 as=0.1401 ps=1.1 w=0.42 l=0.15
X877 VGND _32_.A _32_.Y VGND sky130_fd_pr__nfet_01v8 ad=0.169 pd=1.82 as=0.08775 ps=0.92 w=0.65 l=0.15
X878 VGND u_loop.u_d7.X u_loop.u_q.Y VGND sky130_fd_pr__nfet_01v8 ad=0.169 pd=1.82 as=0.08775 ps=0.92 w=0.65 l=0.15
X879 _20_.A a_1735_6031# VGND VGND sky130_fd_pr__nfet_01v8 ad=0.2079 pd=1.83 as=0.1856 ps=1.26 w=0.42 l=0.15
X880 a_3224_6409# a_2309_6037# a_2877_6005# VGND sky130_fd_pr__special_nfet_01v8 ad=0.0711 pd=0.755 as=0.0999 ps=0.985 w=0.36 l=0.15
X881 u_loop.u_d7.X a_6739_2767# VPWR VPWR sky130_fd_pr__pfet_01v8_hvt ad=0.26 pd=2.52 as=0.14075 ps=1.325 w=1 l=0.15
X882 a_8121_4917# a_7903_5321# VGND VGND sky130_fd_pr__nfet_01v8 ad=0.0999 pd=0.985 as=0.1346 ps=1.15 w=0.64 l=0.15
X883 VPWR VGND VPWR VPWR sky130_fd_pr__pfet_01v8_hvt ad=0.2262 pd=2.26 as=0 ps=0 w=0.87 l=0.59
X884 VGND VPWR VGND VGND sky130_fd_pr__nfet_01v8 ad=0.143 pd=1.62 as=0 ps=0 w=0.55 l=0.59
X885 a_2399_4765# a_1775_4399# a_2291_4399# VPWR sky130_fd_pr__pfet_01v8_hvt ad=0.1155 pd=0.97 as=0.07245 ps=0.765 w=0.42 l=0.15
X886 a_6999_6031# _55_.RESET_B VPWR VPWR sky130_fd_pr__pfet_01v8_hvt ad=0.1092 pd=1.36 as=0.07035 ps=0.755 w=0.42 l=0.15
X887 a_2309_6037# a_2143_6037# VGND VGND sky130_fd_pr__nfet_01v8 ad=0.1092 pd=1.36 as=0.0567 ps=0.69 w=0.42 l=0.15
X888 VPWR a_7385_3829# a_7275_3855# VPWR sky130_fd_pr__pfet_01v8_hvt ad=0.07035 pd=0.755 as=0.1155 ps=0.97 w=0.42 l=0.15
X889 a_8800_8207# a_8583_8207# VPWR VPWR sky130_fd_pr__pfet_01v8_hvt ad=0.2173 pd=2.17 as=0.19265 ps=1.415 w=0.82 l=0.25
X890 a_2969_4917# a_2751_5321# VPWR VPWR sky130_fd_pr__pfet_01v8_hvt ad=0.12915 pd=1.185 as=0.2184 ps=2.2 w=0.84 l=0.15
X891 VPWR VGND VPWR VPWR sky130_fd_pr__pfet_01v8_hvt ad=0.2262 pd=2.26 as=0 ps=0 w=0.87 l=0.59
X892 VGND VPWR VGND VGND sky130_fd_pr__nfet_01v8 ad=0.143 pd=1.62 as=0 ps=0 w=0.55 l=0.59
X893 a_6444_4399# a_5529_4399# a_6097_4641# VGND sky130_fd_pr__special_nfet_01v8 ad=0.0711 pd=0.755 as=0.0999 ps=0.985 w=0.36 l=0.15
X894 VGND VPWR VGND VGND sky130_fd_pr__nfet_01v8 ad=0.143 pd=1.62 as=0 ps=0 w=0.55 l=0.59
X895 VPWR a_3597_2767# a_3703_2767# VPWR sky130_fd_pr__pfet_01v8_hvt ad=0.14075 pd=1.325 as=0.1092 ps=1.36 w=0.42 l=0.5
X896 _49_.Y _40_.B VPWR VPWR sky130_fd_pr__pfet_01v8_hvt ad=0.135 pd=1.27 as=0.26 ps=2.52 w=1 l=0.15
X897 VGND a_2755_7637# a_2689_7663# VGND sky130_fd_pr__nfet_01v8 ad=0.12495 pd=1.015 as=0.0669 ps=0.75 w=0.42 l=0.15
X898 u_loop.u_d0.X a_2231_2767# VGND VGND sky130_fd_pr__nfet_01v8 ad=0.169 pd=1.82 as=0.097 ps=0.975 w=0.65 l=0.15
X899 VPWR VGND VPWR VPWR sky130_fd_pr__pfet_01v8_hvt ad=0.2262 pd=2.26 as=0 ps=0 w=0.87 l=0.59
X900 a_2766_9427# a_3083_9537# a_3041_9661# VGND sky130_fd_pr__special_nfet_01v8 ad=0.0711 pd=0.755 as=0.0669 ps=0.75 w=0.36 l=0.15
X901 VPWR _30_.A _30_.Y VPWR sky130_fd_pr__pfet_01v8_hvt ad=0.26 pd=2.52 as=0.135 ps=1.27 w=1 l=0.15
X902 VGND a_1624_7119# a_1735_7119# VGND sky130_fd_pr__nfet_01v8 ad=0.1856 pd=1.26 as=0.17225 ps=1.83 w=0.65 l=0.25
X903 a_8643_7423# _55_.RESET_B VPWR VPWR sky130_fd_pr__pfet_01v8_hvt ad=0.0567 pd=0.69 as=0.0819 ps=0.81 w=0.42 l=0.15
X904 a_2277_7663# a_2233_7905# a_2111_7663# VGND sky130_fd_pr__nfet_01v8 ad=0.0441 pd=0.63 as=0.1401 ps=1.1 w=0.42 l=0.15
X905 a_7604_6575# a_7387_6575# VGND VGND sky130_fd_pr__nfet_01v8 ad=0.17225 pd=1.83 as=0.1228 ps=1.065 w=0.65 l=0.25
X906 a_3013_5309# a_2969_4917# a_2847_5321# VGND sky130_fd_pr__nfet_01v8 ad=0.0441 pd=0.63 as=0.1401 ps=1.1 w=0.42 l=0.15
X907 VPWR _55_.Q _55_.D VPWR sky130_fd_pr__pfet_01v8_hvt ad=0.26 pd=2.52 as=0.135 ps=1.27 w=1 l=0.15
X908 VPWR VGND VPWR VPWR sky130_fd_pr__pfet_01v8_hvt ad=0.2262 pd=2.26 as=0 ps=0 w=0.87 l=0.59
X909 VGND VPWR VGND VGND sky130_fd_pr__nfet_01v8 ad=0.143 pd=1.62 as=0 ps=0 w=0.55 l=0.59
X910 VGND VPWR VGND VGND sky130_fd_pr__nfet_01v8 ad=0.143 pd=1.62 as=0 ps=0 w=0.55 l=0.59
X911 VGND VPWR VGND VGND sky130_fd_pr__nfet_01v8 ad=0.143 pd=1.62 as=0 ps=0 w=0.55 l=0.59
X912 a_3316_5321# a_2235_4949# a_2969_4917# VPWR sky130_fd_pr__pfet_01v8_hvt ad=0.0588 pd=0.7 as=0.12915 ps=1.185 w=0.42 l=0.15
X913 a_4351_4175# u_loop.u_gh.B a_4769_4175# VGND sky130_fd_pr__nfet_01v8 ad=0.08775 pd=0.92 as=0.08775 ps=0.92 w=0.65 l=0.15
X914 VGND a_3070_6549# u_loop.u_gh.C VGND sky130_fd_pr__nfet_01v8 ad=0.1856 pd=1.26 as=0.2079 ps=1.83 w=0.42 l=0.15
X915 VPWR VGND VPWR VPWR sky130_fd_pr__pfet_01v8_hvt ad=0.2262 pd=2.26 as=0 ps=0 w=0.87 l=0.59
X916 u_loop.u_d5.X a_5175_2767# VGND VGND sky130_fd_pr__nfet_01v8 ad=0.169 pd=1.82 as=0.097 ps=0.975 w=0.65 l=0.15
X917 VPWR VGND VPWR VPWR sky130_fd_pr__pfet_01v8_hvt ad=0.2262 pd=2.26 as=0 ps=0 w=0.87 l=0.59
X918 VPWR u_loop.u_gh.C a_2479_9269# VPWR sky130_fd_pr__pfet_01v8_hvt ad=0.0819 pd=0.81 as=0.0567 ps=0.69 w=0.42 l=0.15
X919 VGND _55_.RESET_B a_7061_7663# VGND sky130_fd_pr__nfet_01v8 ad=0.1346 pd=1.15 as=0.0441 ps=0.63 w=0.42 l=0.15
X920 VGND en a_2235_6575# VGND sky130_fd_pr__nfet_01v8 ad=0.1228 pd=1.065 as=0.1134 ps=1.38 w=0.42 l=0.15
X921 VGND VPWR VGND VGND sky130_fd_pr__nfet_01v8 ad=0.143 pd=1.62 as=0 ps=0 w=0.55 l=0.59
X922 VGND a_5764_2223# a_5875_2223# VGND sky130_fd_pr__nfet_01v8 ad=0.1856 pd=1.26 as=0.17225 ps=1.83 w=0.65 l=0.25
X923 VGND u_loop.u_gh.C a_3381_8573# VGND sky130_fd_pr__nfet_01v8 ad=0.1346 pd=1.15 as=0.0441 ps=0.63 w=0.42 l=0.15
X924 VGND VPWR VGND VGND sky130_fd_pr__nfet_01v8 ad=0.143 pd=1.62 as=0 ps=0 w=0.55 l=0.59
X925 VPWR a_1499_6575# _34_.X VPWR sky130_fd_pr__pfet_01v8_hvt ad=0.265 pd=2.53 as=0.14 ps=1.28 w=1 l=0.15
X926 VPWR a_8468_5321# a_8643_5247# VPWR sky130_fd_pr__pfet_01v8_hvt ad=0.1134 pd=1.38 as=0.0567 ps=0.69 w=0.42 l=0.15
X927 VPWR VGND VPWR VPWR sky130_fd_pr__pfet_01v8_hvt ad=0.2262 pd=2.26 as=0 ps=0 w=0.87 l=0.59
X928 a_4517_9301# a_4351_9301# VPWR VPWR sky130_fd_pr__pfet_01v8_hvt ad=0.1664 pd=1.8 as=0.0864 ps=0.91 w=0.64 l=0.15
X929 VPWR VGND VPWR VPWR sky130_fd_pr__pfet_01v8_hvt ad=0.2262 pd=2.26 as=0 ps=0 w=0.87 l=0.59
X930 VGND a_1624_6031# a_1735_6031# VGND sky130_fd_pr__nfet_01v8 ad=0.1856 pd=1.26 as=0.17225 ps=1.83 w=0.65 l=0.25
X931 a_2847_5321# a_2401_4949# a_2751_5321# VGND sky130_fd_pr__special_nfet_01v8 ad=0.1401 pd=1.1 as=0.0594 ps=0.69 w=0.36 l=0.15
X932 a_7348_5487# _67_.D VPWR VPWR sky130_fd_pr__pfet_01v8_hvt ad=0.0651 pd=0.73 as=0.1092 ps=1.36 w=0.42 l=0.15
X933 VPWR u_loop.u_d0.A a_1889_2767# VPWR sky130_fd_pr__pfet_01v8_hvt ad=0.0567 pd=0.69 as=0.1092 ps=1.36 w=0.42 l=0.15
X934 VGND a_5691_3829# u_loop.u_d0.A VGND sky130_fd_pr__nfet_01v8 ad=0.06825 pd=0.745 as=0.0567 ps=0.69 w=0.42 l=0.15
X935 VPWR VGND VPWR VPWR sky130_fd_pr__pfet_01v8_hvt ad=0.2262 pd=2.26 as=0 ps=0 w=0.87 l=0.59
X936 VPWR VGND VPWR VPWR sky130_fd_pr__pfet_01v8_hvt ad=0.2262 pd=2.26 as=0 ps=0 w=0.87 l=0.59
X937 VPWR VGND VPWR VPWR sky130_fd_pr__pfet_01v8_hvt ad=0.2262 pd=2.26 as=0 ps=0 w=0.87 l=0.59
X938 _22_.Y _45_.A VPWR VPWR sky130_fd_pr__pfet_01v8_hvt ad=0.135 pd=1.27 as=0.26 ps=2.52 w=1 l=0.15
X939 a_3597_2767# a_3361_2767# VPWR VPWR sky130_fd_pr__pfet_01v8_hvt ad=0.1092 pd=1.36 as=0.0567 ps=0.69 w=0.42 l=0.5
X940 VGND VPWR VGND VGND sky130_fd_pr__nfet_01v8 ad=0.143 pd=1.62 as=0 ps=0 w=0.55 l=0.59
X941 VPWR VGND VPWR VPWR sky130_fd_pr__pfet_01v8_hvt ad=0.2262 pd=2.26 as=0 ps=0 w=0.87 l=0.59
X942 a_2360_7119# a_2143_7119# VGND VGND sky130_fd_pr__nfet_01v8 ad=0.17225 pd=1.83 as=0.1228 ps=1.065 w=0.65 l=0.25
X943 VPWR _35_.B a_3514_7235# VPWR sky130_fd_pr__pfet_01v8_hvt ad=0.14825 pd=1.34 as=0.0567 ps=0.69 w=0.42 l=0.15
X944 VGND VPWR VGND VGND sky130_fd_pr__nfet_01v8 ad=0.143 pd=1.62 as=0 ps=0 w=0.55 l=0.59
X945 a_8183_5461# a_8008_5487# a_8362_5487# VGND sky130_fd_pr__nfet_01v8 ad=0.1092 pd=1.36 as=0.06405 ps=0.725 w=0.42 l=0.15
X946 VGND VPWR VGND VGND sky130_fd_pr__nfet_01v8 ad=0.143 pd=1.62 as=0 ps=0 w=0.55 l=0.59
X947 VGND VPWR VGND VGND sky130_fd_pr__nfet_01v8 ad=0.143 pd=1.62 as=0 ps=0 w=0.55 l=0.59
X948 VPWR VGND VPWR VPWR sky130_fd_pr__pfet_01v8_hvt ad=0.2262 pd=2.26 as=0 ps=0 w=0.87 l=0.59
X949 VPWR a_8643_7423# a_8630_7119# VPWR sky130_fd_pr__pfet_01v8_hvt ad=0.0819 pd=0.81 as=0.0567 ps=0.69 w=0.42 l=0.15
X950 VGND VPWR VGND VGND sky130_fd_pr__nfet_01v8 ad=0.143 pd=1.62 as=0 ps=0 w=0.55 l=0.59
X951 VPWR _56_.Q _55_.CLK VPWR sky130_fd_pr__pfet_01v8_hvt ad=0.26 pd=2.52 as=0.135 ps=1.27 w=1 l=0.15
X952 VPWR VGND VPWR VPWR sky130_fd_pr__pfet_01v8_hvt ad=0.2262 pd=2.26 as=0 ps=0 w=0.87 l=0.59
X953 VPWR VGND VPWR VPWR sky130_fd_pr__pfet_01v8_hvt ad=0.2262 pd=2.26 as=0 ps=0 w=0.87 l=0.59
X954 a_3337_8181# a_3119_8585# VPWR VPWR sky130_fd_pr__pfet_01v8_hvt ad=0.12915 pd=1.185 as=0.2184 ps=2.2 w=0.84 l=0.15
X955 VGND VPWR VGND VGND sky130_fd_pr__nfet_01v8 ad=0.143 pd=1.62 as=0 ps=0 w=0.55 l=0.59
X956 a_4518_6575# _35_.A_N VGND VGND sky130_fd_pr__nfet_01v8 ad=0.08775 pd=0.92 as=0.08775 ps=0.92 w=0.65 l=0.15
X957 a_8008_5487# a_6927_5487# a_7661_5729# VPWR sky130_fd_pr__pfet_01v8_hvt ad=0.0588 pd=0.7 as=0.12915 ps=1.185 w=0.42 l=0.15
X958 _40_.B a_3859_8511# VPWR VPWR sky130_fd_pr__pfet_01v8_hvt ad=0.135 pd=1.27 as=0.3012 ps=2.66 w=1 l=0.15
X959 VPWR a_3399_6335# _23_.A VPWR sky130_fd_pr__pfet_01v8_hvt ad=0.26 pd=2.52 as=0.135 ps=1.27 w=1 l=0.15
X960 a_8121_4917# a_7903_5321# VPWR VPWR sky130_fd_pr__pfet_01v8_hvt ad=0.12915 pd=1.185 as=0.2184 ps=2.2 w=0.84 l=0.15
X961 u_loop.u_gl.B1 u_loop.u_gh.C VPWR VPWR sky130_fd_pr__pfet_01v8_hvt ad=0.26 pd=2.52 as=0.26 ps=2.52 w=1 l=0.15
X962 VPWR VGND VPWR VPWR sky130_fd_pr__pfet_01v8_hvt ad=0.2262 pd=2.26 as=0 ps=0 w=0.87 l=0.59
X963 VGND VPWR VGND VGND sky130_fd_pr__nfet_01v8 ad=0.143 pd=1.62 as=0 ps=0 w=0.55 l=0.59
X964 output7.A u_loop.u_gl.B1 a_4076_3561# VPWR sky130_fd_pr__pfet_01v8_hvt ad=0.14 pd=1.28 as=0.26 ps=2.52 w=1 l=0.15
X965 VGND VPWR VGND VGND sky130_fd_pr__nfet_01v8 ad=0.143 pd=1.62 as=0 ps=0 w=0.55 l=0.59
X966 VPWR _53_.A _27_.Y VPWR sky130_fd_pr__pfet_01v8_hvt ad=0.26 pd=2.52 as=0.135 ps=1.27 w=1 l=0.15
X967 VPWR VGND VPWR VPWR sky130_fd_pr__pfet_01v8_hvt ad=0.2262 pd=2.26 as=0 ps=0 w=0.87 l=0.59
X968 VGND VPWR VGND VGND sky130_fd_pr__nfet_01v8 ad=0.143 pd=1.62 as=0 ps=0 w=0.55 l=0.59
X969 VPWR _68_.Q a_8583_8207# VPWR sky130_fd_pr__pfet_01v8_hvt ad=0.19265 pd=1.415 as=0.27 ps=2.54 w=1 l=0.15
X970 _23_.A a_3399_6335# VGND VGND sky130_fd_pr__nfet_01v8 ad=0.08775 pd=0.92 as=0.2087 ps=2.02 w=0.65 l=0.15
X971 VGND VPWR VGND VGND sky130_fd_pr__nfet_01v8 ad=0.143 pd=1.62 as=0 ps=0 w=0.55 l=0.59
X972 VGND VPWR VGND VGND sky130_fd_pr__nfet_01v8 ad=0.143 pd=1.62 as=0 ps=0 w=0.55 l=0.59
X973 VGND VPWR VGND VGND sky130_fd_pr__nfet_01v8 ad=0.143 pd=1.62 as=0 ps=0 w=0.55 l=0.59
X974 a_2553_4399# a_2509_4641# a_2387_4399# VGND sky130_fd_pr__nfet_01v8 ad=0.0441 pd=0.63 as=0.1401 ps=1.1 w=0.42 l=0.15
X975 a_3684_8585# a_2603_8213# a_3337_8181# VPWR sky130_fd_pr__pfet_01v8_hvt ad=0.0588 pd=0.7 as=0.12915 ps=1.185 w=0.42 l=0.15
X976 VPWR VGND VPWR VPWR sky130_fd_pr__pfet_01v8_hvt ad=0.2262 pd=2.26 as=0 ps=0 w=0.87 l=0.59
X977 a_5649_5737# _36_.A a_5190_5487# VPWR sky130_fd_pr__pfet_01v8_hvt ad=0.105 pd=1.21 as=0.3875 ps=1.775 w=1 l=0.15
X978 a_8468_5321# a_7387_4949# a_8121_4917# VPWR sky130_fd_pr__pfet_01v8_hvt ad=0.0588 pd=0.7 as=0.12915 ps=1.185 w=0.42 l=0.15
X979 VGND VPWR VGND VGND sky130_fd_pr__nfet_01v8 ad=0.143 pd=1.62 as=0 ps=0 w=0.55 l=0.59
X980 VPWR a_7539_7637# _45_.A VPWR sky130_fd_pr__pfet_01v8_hvt ad=0.26 pd=2.52 as=0.135 ps=1.27 w=1 l=0.15
X981 _32_.Y _32_.A VPWR VPWR sky130_fd_pr__pfet_01v8_hvt ad=0.135 pd=1.27 as=0.26 ps=2.52 w=1 l=0.15
X982 VPWR VGND VPWR VPWR sky130_fd_pr__pfet_01v8_hvt ad=0.2262 pd=2.26 as=0 ps=0 w=0.87 l=0.59
X983 VGND VPWR VGND VGND sky130_fd_pr__nfet_01v8 ad=0.143 pd=1.62 as=0 ps=0 w=0.55 l=0.59
X984 _34_.B1 a_2563_6575# VGND VGND sky130_fd_pr__nfet_01v8 ad=0.2079 pd=1.83 as=0.1856 ps=1.26 w=0.42 l=0.15
X985 a_2196_4399# _27_.Y VGND VGND sky130_fd_pr__nfet_01v8 ad=0.066 pd=0.745 as=0.2205 ps=1.89 w=0.42 l=0.15
X986 a_3119_8585# a_2603_8213# a_3024_8573# VGND sky130_fd_pr__special_nfet_01v8 ad=0.0594 pd=0.69 as=0.066 ps=0.745 w=0.36 l=0.15
X987 a_7808_5309# _25_.Y VGND VGND sky130_fd_pr__nfet_01v8 ad=0.066 pd=0.745 as=0.2205 ps=1.89 w=0.42 l=0.15
X988 a_5691_3829# u_loop.u_q.Y VGND VGND sky130_fd_pr__nfet_01v8 ad=0.1113 pd=1.37 as=0.06825 ps=0.745 w=0.42 l=0.15
X989 _56_.Q a_6619_4373# VPWR VPWR sky130_fd_pr__pfet_01v8_hvt ad=0.135 pd=1.27 as=0.3012 ps=2.66 w=1 l=0.15
X990 VGND VPWR VGND VGND sky130_fd_pr__nfet_01v8 ad=0.143 pd=1.62 as=0 ps=0 w=0.55 l=0.59
X991 VPWR VGND VPWR VPWR sky130_fd_pr__pfet_01v8_hvt ad=0.2262 pd=2.26 as=0 ps=0 w=0.87 l=0.59
X992 VPWR VGND VPWR VPWR sky130_fd_pr__pfet_01v8_hvt ad=0.2262 pd=2.26 as=0 ps=0 w=0.87 l=0.59
X993 VPWR VGND VPWR VPWR sky130_fd_pr__pfet_01v8_hvt ad=0.2262 pd=2.26 as=0 ps=0 w=0.87 l=0.59
X994 a_4032_7351# _35_.A_N VGND VGND sky130_fd_pr__nfet_01v8 ad=0.1092 pd=1.36 as=0.10025 ps=0.985 w=0.42 l=0.15
X995 _36_.A a_4167_6147# a_4369_6351# VGND sky130_fd_pr__nfet_01v8 ad=0.08775 pd=0.92 as=0.169 ps=1.82 w=0.65 l=0.15
X996 a_5879_4399# a_5529_4399# a_5784_4399# VPWR sky130_fd_pr__pfet_01v8_hvt ad=0.07245 pd=0.765 as=0.0651 ps=0.73 w=0.42 l=0.15
X997 VPWR _41_.C1 a_5190_5487# VPWR sky130_fd_pr__pfet_01v8_hvt ad=0.165 pd=1.33 as=0.325 ps=2.65 w=1 l=0.15
X998 a_1582_6575# _20_.Y a_1499_6575# VGND sky130_fd_pr__nfet_01v8 ad=0.06825 pd=0.86 as=0.17225 ps=1.83 w=0.65 l=0.15
X999 VGND a_3399_6335# a_3333_6409# VGND sky130_fd_pr__nfet_01v8 ad=0.12495 pd=1.015 as=0.0669 ps=0.75 w=0.42 l=0.15
X1000 VPWR VGND VPWR VPWR sky130_fd_pr__pfet_01v8_hvt ad=0.2262 pd=2.26 as=0 ps=0 w=0.87 l=0.59
X1001 VGND a_5805_2767# a_5911_2767# VGND sky130_fd_pr__nfet_01v8 ad=0.097 pd=0.975 as=0.1092 ps=1.36 w=0.42 l=0.5
X1002 VGND _30_.Y a_3802_9295# VGND sky130_fd_pr__nfet_01v8 ad=0.2205 pd=1.89 as=0.066 ps=0.745 w=0.42 l=0.15
X1003 _46_.Y _46_.A VGND VGND sky130_fd_pr__nfet_01v8 ad=0.08775 pd=0.92 as=0.169 ps=1.82 w=0.65 l=0.15
X1004 a_5377_7439# _41_.B1 a_5293_7439# VGND sky130_fd_pr__nfet_01v8 ad=0.08775 pd=0.92 as=0.08775 ps=0.92 w=0.65 l=0.15
X1005 VPWR VGND VPWR VPWR sky130_fd_pr__pfet_01v8_hvt ad=0.2262 pd=2.26 as=0 ps=0 w=0.87 l=0.59
X1006 a_7539_7637# _55_.RESET_B VPWR VPWR sky130_fd_pr__pfet_01v8_hvt ad=0.0567 pd=0.69 as=0.0819 ps=0.81 w=0.42 l=0.15
X1007 a_2659_6409# a_2309_6037# a_2564_6397# VPWR sky130_fd_pr__pfet_01v8_hvt ad=0.07245 pd=0.765 as=0.0651 ps=0.73 w=0.42 l=0.15
X1008 a_6891_6409# a_6541_6037# a_6796_6397# VPWR sky130_fd_pr__pfet_01v8_hvt ad=0.07245 pd=0.765 as=0.0651 ps=0.73 w=0.42 l=0.15
X1009 VPWR VGND VPWR VPWR sky130_fd_pr__pfet_01v8_hvt ad=0.2262 pd=2.26 as=0 ps=0 w=0.87 l=0.59
X1010 VGND VPWR VGND VGND sky130_fd_pr__nfet_01v8 ad=0.143 pd=1.62 as=0 ps=0 w=0.55 l=0.59
X1011 _41_.B1 a_4160_6575# VGND VGND sky130_fd_pr__nfet_01v8 ad=0.08775 pd=0.92 as=0.169 ps=1.82 w=0.65 l=0.15
X1012 _28_.Y _28_.A VPWR VPWR sky130_fd_pr__pfet_01v8_hvt ad=0.135 pd=1.27 as=0.26 ps=2.52 w=1 l=0.15
X1013 VPWR VGND VPWR VPWR sky130_fd_pr__pfet_01v8_hvt ad=0.2262 pd=2.26 as=0 ps=0 w=0.87 l=0.59
X1014 VGND a_6633_2767# a_6739_2767# VGND sky130_fd_pr__nfet_01v8 ad=0.097 pd=0.975 as=0.1092 ps=1.36 w=0.42 l=0.5
X1015 a_5987_4765# a_5363_4399# a_5879_4399# VPWR sky130_fd_pr__pfet_01v8_hvt ad=0.1155 pd=0.97 as=0.07245 ps=0.765 w=0.42 l=0.15
X1016 VPWR VGND VPWR VPWR sky130_fd_pr__pfet_01v8_hvt ad=0.2262 pd=2.26 as=0 ps=0 w=0.87 l=0.59
X1017 VPWR VGND VPWR VPWR sky130_fd_pr__pfet_01v8_hvt ad=0.2262 pd=2.26 as=0 ps=0 w=0.87 l=0.59
X1018 VPWR VGND VPWR VPWR sky130_fd_pr__pfet_01v8_hvt ad=0.2262 pd=2.26 as=0 ps=0 w=0.87 l=0.59
X1019 VGND VPWR VGND VGND sky130_fd_pr__nfet_01v8 ad=0.143 pd=1.62 as=0 ps=0 w=0.55 l=0.59
X1020 VPWR VGND VPWR VPWR sky130_fd_pr__pfet_01v8_hvt ad=0.2262 pd=2.26 as=0 ps=0 w=0.87 l=0.59
X1021 a_8011_7119# _55_.RESET_B VPWR VPWR sky130_fd_pr__pfet_01v8_hvt ad=0.1092 pd=1.36 as=0.07035 ps=0.755 w=0.42 l=0.15
X1022 VGND VPWR VGND VGND sky130_fd_pr__nfet_01v8 ad=0.143 pd=1.62 as=0 ps=0 w=0.55 l=0.59
X1023 a_7013_8751# a_5823_8751# a_6904_8751# VGND sky130_fd_pr__special_nfet_01v8 ad=0.0669 pd=0.75 as=0.0711 ps=0.755 w=0.36 l=0.15
X1024 a_2767_6031# a_2143_6037# a_2659_6409# VPWR sky130_fd_pr__pfet_01v8_hvt ad=0.1155 pd=0.97 as=0.07245 ps=0.765 w=0.42 l=0.15
X1025 a_3041_9661# a_2479_9269# VGND VGND sky130_fd_pr__nfet_01v8 ad=0.0669 pd=0.75 as=0.12495 ps=1.015 w=0.42 l=0.15
X1026 VPWR VGND VPWR VPWR sky130_fd_pr__pfet_01v8_hvt ad=0.2262 pd=2.26 as=0 ps=0 w=0.87 l=0.59
X1027 VGND VPWR VGND VGND sky130_fd_pr__nfet_01v8 ad=0.143 pd=1.62 as=0 ps=0 w=0.55 l=0.59
X1028 VPWR a_7604_6575# a_7715_6575# VPWR sky130_fd_pr__pfet_01v8_hvt ad=0.2726 pd=1.61 as=0.2173 ps=2.17 w=0.82 l=0.25
X1029 VPWR VGND VPWR VPWR sky130_fd_pr__pfet_01v8_hvt ad=0.2262 pd=2.26 as=0 ps=0 w=0.87 l=0.59
X1030 a_5541_9673# a_4351_9301# a_5432_9673# VGND sky130_fd_pr__special_nfet_01v8 ad=0.0669 pd=0.75 as=0.0711 ps=0.755 w=0.36 l=0.15
X1031 VGND a_8183_5461# _67_.Q VGND sky130_fd_pr__nfet_01v8 ad=0.169 pd=1.82 as=0.08775 ps=0.92 w=0.65 l=0.15
X1032 a_4351_4175# u_loop.u_gh.C VGND VGND sky130_fd_pr__nfet_01v8 ad=0.08775 pd=0.92 as=0.08775 ps=0.92 w=0.65 l=0.15
X1033 VGND VPWR VGND VGND sky130_fd_pr__nfet_01v8 ad=0.143 pd=1.62 as=0 ps=0 w=0.55 l=0.59
X1034 VPWR VGND VPWR VPWR sky130_fd_pr__pfet_01v8_hvt ad=0.2262 pd=2.26 as=0 ps=0 w=0.87 l=0.59
X1035 a_3031_4373# u_loop.u_gh.C VPWR VPWR sky130_fd_pr__pfet_01v8_hvt ad=0.0567 pd=0.69 as=0.0819 ps=0.81 w=0.42 l=0.15
X1036 VGND VPWR VGND VGND sky130_fd_pr__nfet_01v8 ad=0.143 pd=1.62 as=0 ps=0 w=0.55 l=0.59
X1037 VPWR _46_.A _31_.Y VPWR sky130_fd_pr__pfet_01v8_hvt ad=0.26 pd=2.52 as=0.135 ps=1.27 w=1 l=0.15
X1038 _52_.Y _28_.A VPWR VPWR sky130_fd_pr__pfet_01v8_hvt ad=0.135 pd=1.27 as=0.26 ps=2.52 w=1 l=0.15
X1039 a_4963_9673# a_4517_9301# a_4867_9673# VGND sky130_fd_pr__special_nfet_01v8 ad=0.1401 pd=1.1 as=0.0594 ps=0.69 w=0.36 l=0.15
X1040 VPWR VGND VPWR VPWR sky130_fd_pr__pfet_01v8_hvt ad=0.2262 pd=2.26 as=0 ps=0 w=0.87 l=0.59
X1041 a_2401_4949# a_2235_4949# VPWR VPWR sky130_fd_pr__pfet_01v8_hvt ad=0.1664 pd=1.8 as=0.0864 ps=0.91 w=0.64 l=0.15
X1042 VGND VPWR VGND VGND sky130_fd_pr__nfet_01v8 ad=0.143 pd=1.62 as=0 ps=0 w=0.55 l=0.59
X1043 VPWR VGND VPWR VPWR sky130_fd_pr__pfet_01v8_hvt ad=0.2262 pd=2.26 as=0 ps=0 w=0.87 l=0.59
X1044 VPWR VGND VPWR VPWR sky130_fd_pr__pfet_01v8_hvt ad=0.2262 pd=2.26 as=0 ps=0 w=0.87 l=0.59
X1045 _31_.Y _46_.A VGND VGND sky130_fd_pr__nfet_01v8 ad=0.08775 pd=0.92 as=0.169 ps=1.82 w=0.65 l=0.15
X1046 VGND VPWR VGND VGND sky130_fd_pr__nfet_01v8 ad=0.143 pd=1.62 as=0 ps=0 w=0.55 l=0.59
X1047 a_8468_7497# a_7553_7125# a_8121_7093# VGND sky130_fd_pr__special_nfet_01v8 ad=0.0711 pd=0.755 as=0.0999 ps=0.985 w=0.36 l=0.15
X1048 a_7732_4233# a_6817_3861# a_7385_3829# VGND sky130_fd_pr__special_nfet_01v8 ad=0.0711 pd=0.755 as=0.0999 ps=0.985 w=0.36 l=0.15
X1049 VGND VPWR VGND VGND sky130_fd_pr__nfet_01v8 ad=0.143 pd=1.62 as=0 ps=0 w=0.55 l=0.59
X1050 VGND VPWR VGND VGND sky130_fd_pr__nfet_01v8 ad=0.143 pd=1.62 as=0 ps=0 w=0.55 l=0.59
X1051 a_5069_2767# a_4833_2767# VPWR VPWR sky130_fd_pr__pfet_01v8_hvt ad=0.1092 pd=1.36 as=0.0567 ps=0.69 w=0.42 l=0.5
X1052 a_4769_4175# u_loop.u_q.Y output6.A VGND sky130_fd_pr__nfet_01v8 ad=0.1755 pd=1.84 as=0.08775 ps=0.92 w=0.65 l=0.15
X1053 a_2233_7905# a_2015_7663# VPWR VPWR sky130_fd_pr__pfet_01v8_hvt ad=0.12915 pd=1.185 as=0.2184 ps=2.2 w=0.84 l=0.15
X1054 a_4158_7235# _40_.B a_4074_7235# VPWR sky130_fd_pr__pfet_01v8_hvt ad=0.0567 pd=0.69 as=0.0567 ps=0.69 w=0.42 l=0.15
X1055 a_6457_2473# u_loop.u_q.B u_loop.u_q.Y VPWR sky130_fd_pr__pfet_01v8_hvt ad=0.105 pd=1.21 as=0.26 ps=2.52 w=1 l=0.15
X1056 output6.A u_loop.u_gh.C VPWR VPWR sky130_fd_pr__pfet_01v8_hvt ad=0.135 pd=1.27 as=0.135 ps=1.27 w=1 l=0.15
X1057 VPWR VGND VPWR VPWR sky130_fd_pr__pfet_01v8_hvt ad=0.2262 pd=2.26 as=0 ps=0 w=0.87 l=0.59
X1058 a_3083_9537# _49_.Y VPWR VPWR sky130_fd_pr__pfet_01v8_hvt ad=0.1664 pd=1.8 as=0.0864 ps=0.91 w=0.64 l=0.15
X1059 VPWR u_loop.u_d0.A a_1775_4399# VPWR sky130_fd_pr__pfet_01v8_hvt ad=0.0864 pd=0.91 as=0.1664 ps=1.8 w=0.64 l=0.15
X1060 u_loop.u_q.B u_loop.u_qb.A VGND VGND sky130_fd_pr__nfet_01v8 ad=0.08775 pd=0.92 as=0.169 ps=1.82 w=0.65 l=0.15
X1061 VGND VPWR VGND VGND sky130_fd_pr__nfet_01v8 ad=0.143 pd=1.62 as=0 ps=0 w=0.55 l=0.59
X1062 a_3024_8573# _62_.D VPWR VPWR sky130_fd_pr__pfet_01v8_hvt ad=0.0651 pd=0.73 as=0.1092 ps=1.36 w=0.42 l=0.15
X1063 a_3430_7235# a_3388_7351# a_3348_7235# VPWR sky130_fd_pr__pfet_01v8_hvt ad=0.0567 pd=0.69 as=0.1092 ps=1.36 w=0.42 l=0.15
X1064 a_5529_4399# a_5363_4399# VPWR VPWR sky130_fd_pr__pfet_01v8_hvt ad=0.1664 pd=1.8 as=0.0864 ps=0.91 w=0.64 l=0.15
X1065 VPWR VGND VPWR VPWR sky130_fd_pr__pfet_01v8_hvt ad=0.2262 pd=2.26 as=0 ps=0 w=0.87 l=0.59
X1066 a_6097_4641# a_5879_4399# VPWR VPWR sky130_fd_pr__pfet_01v8_hvt ad=0.12915 pd=1.185 as=0.2184 ps=2.2 w=0.84 l=0.15
X1067 a_7473_7663# a_6283_7663# a_7364_7663# VGND sky130_fd_pr__special_nfet_01v8 ad=0.0669 pd=0.75 as=0.0711 ps=0.755 w=0.36 l=0.15
X1068 a_8170_5853# a_7093_5487# a_8008_5487# VPWR sky130_fd_pr__pfet_01v8_hvt ad=0.0567 pd=0.69 as=0.0588 ps=0.7 w=0.42 l=0.15
X1069 a_7661_5729# a_7443_5487# VGND VGND sky130_fd_pr__nfet_01v8 ad=0.0999 pd=0.985 as=0.1346 ps=1.15 w=0.64 l=0.15
X1070 a_7079_8725# _55_.RESET_B VPWR VPWR sky130_fd_pr__pfet_01v8_hvt ad=0.0567 pd=0.69 as=0.0819 ps=0.81 w=0.42 l=0.15
X1071 VPWR VGND VPWR VPWR sky130_fd_pr__pfet_01v8_hvt ad=0.2262 pd=2.26 as=0 ps=0 w=0.87 l=0.59
X1072 VPWR a_7631_6335# _32_.A VPWR sky130_fd_pr__pfet_01v8_hvt ad=0.26 pd=2.52 as=0.135 ps=1.27 w=1 l=0.15
X1073 a_2856_4399# a_1775_4399# a_2509_4641# VPWR sky130_fd_pr__pfet_01v8_hvt ad=0.0588 pd=0.7 as=0.12915 ps=1.185 w=0.42 l=0.15
X1074 a_2291_4399# a_1775_4399# a_2196_4399# VGND sky130_fd_pr__special_nfet_01v8 ad=0.0594 pd=0.69 as=0.066 ps=0.745 w=0.36 l=0.15
X1075 a_6817_3861# a_6651_3861# VGND VGND sky130_fd_pr__nfet_01v8 ad=0.1092 pd=1.36 as=0.0567 ps=0.69 w=0.42 l=0.15
X1076 VGND VPWR VGND VGND sky130_fd_pr__nfet_01v8 ad=0.143 pd=1.62 as=0 ps=0 w=0.55 l=0.59
X1077 a_5649_7119# _36_.A a_5190_7439# VPWR sky130_fd_pr__pfet_01v8_hvt ad=0.105 pd=1.21 as=0.3875 ps=1.775 w=1 l=0.15
X1078 VPWR a_3031_4373# a_3018_4765# VPWR sky130_fd_pr__pfet_01v8_hvt ad=0.0819 pd=0.81 as=0.0567 ps=0.69 w=0.42 l=0.15
X1079 a_4076_3561# u_loop.u_gl.B1 output7.A VPWR sky130_fd_pr__pfet_01v8_hvt ad=0.14 pd=1.28 as=0.14 ps=1.28 w=1 l=0.15
X1080 _39_.B2 a_5607_9599# VPWR VPWR sky130_fd_pr__pfet_01v8_hvt ad=0.135 pd=1.27 as=0.3012 ps=2.66 w=1 l=0.15
X1081 _45_.A a_7539_7637# VPWR VPWR sky130_fd_pr__pfet_01v8_hvt ad=0.135 pd=1.27 as=0.3012 ps=2.66 w=1 l=0.15
X1082 _48_.Y _30_.A VGND VGND sky130_fd_pr__nfet_01v8 ad=0.08775 pd=0.92 as=0.169 ps=1.82 w=0.65 l=0.15
X1083 a_6895_7663# a_6449_7663# a_6799_7663# VGND sky130_fd_pr__special_nfet_01v8 ad=0.1401 pd=1.1 as=0.0594 ps=0.69 w=0.36 l=0.15
X1084 a_7718_7663# _55_.RESET_B VGND VGND sky130_fd_pr__nfet_01v8 ad=0.06405 pd=0.725 as=0.12495 ps=1.015 w=0.42 l=0.15
X1085 a_7553_7125# a_7387_7125# VGND VGND sky130_fd_pr__nfet_01v8 ad=0.1092 pd=1.36 as=0.0567 ps=0.69 w=0.42 l=0.15
X1086 _32_.A a_7631_6335# VGND VGND sky130_fd_pr__nfet_01v8 ad=0.08775 pd=0.92 as=0.2087 ps=2.02 w=0.65 l=0.15
X1087 VGND VPWR VGND VGND sky130_fd_pr__nfet_01v8 ad=0.143 pd=1.62 as=0 ps=0 w=0.55 l=0.59
X1088 VGND VPWR VGND VGND sky130_fd_pr__nfet_01v8 ad=0.143 pd=1.62 as=0 ps=0 w=0.55 l=0.59
X1089 a_4910_2197# a_5036_2381# VPWR VPWR sky130_fd_pr__pfet_01v8_hvt ad=0.2173 pd=2.17 as=0.2726 ps=1.61 w=0.82 l=0.25
X1090 VGND VPWR VGND VGND sky130_fd_pr__nfet_01v8 ad=0.143 pd=1.62 as=0 ps=0 w=0.55 l=0.59
X1091 VPWR VGND VPWR VPWR sky130_fd_pr__pfet_01v8_hvt ad=0.2262 pd=2.26 as=0 ps=0 w=0.87 l=0.59
X1092 VGND u_loop.u_gh.C a_2921_6397# VGND sky130_fd_pr__nfet_01v8 ad=0.1346 pd=1.15 as=0.0441 ps=0.63 w=0.42 l=0.15
X1093 a_3399_6335# a_3224_6409# a_3578_6397# VGND sky130_fd_pr__nfet_01v8 ad=0.1092 pd=1.36 as=0.06405 ps=0.725 w=0.42 l=0.15
X1094 a_7631_6335# a_7456_6409# a_7810_6397# VGND sky130_fd_pr__nfet_01v8 ad=0.1092 pd=1.36 as=0.06405 ps=0.725 w=0.42 l=0.15
X1095 a_8630_4943# a_7553_4949# a_8468_5321# VPWR sky130_fd_pr__pfet_01v8_hvt ad=0.0567 pd=0.69 as=0.0588 ps=0.7 w=0.42 l=0.15
X1096 VGND x a_5547_2223# VGND sky130_fd_pr__nfet_01v8 ad=0.1228 pd=1.065 as=0.1134 ps=1.38 w=0.42 l=0.15
X1097 VPWR VGND VPWR VPWR sky130_fd_pr__pfet_01v8_hvt ad=0.2262 pd=2.26 as=0 ps=0 w=0.87 l=0.59
X1098 xa a_8911_8207# VGND VGND sky130_fd_pr__nfet_01v8 ad=0.2079 pd=1.83 as=0.1856 ps=1.26 w=0.42 l=0.15
X1099 VPWR _38_.X a_5190_7439# VPWR sky130_fd_pr__pfet_01v8_hvt ad=0.165 pd=1.33 as=0.325 ps=2.65 w=1 l=0.15
X1100 VGND VPWR VGND VGND sky130_fd_pr__nfet_01v8 ad=0.143 pd=1.62 as=0 ps=0 w=0.55 l=0.59
X1101 VPWR a_7907_4159# _55_.Q VPWR sky130_fd_pr__pfet_01v8_hvt ad=0.26 pd=2.52 as=0.135 ps=1.27 w=1 l=0.15
X1102 _63_.Q a_2755_7637# VGND VGND sky130_fd_pr__nfet_01v8 ad=0.08775 pd=0.92 as=0.2087 ps=2.02 w=0.65 l=0.15
X1103 a_4032_7351# _35_.A_N VPWR VPWR sky130_fd_pr__pfet_01v8_hvt ad=0.1092 pd=1.36 as=0.14575 ps=1.335 w=0.42 l=0.15
X1104 VPWR VGND VPWR VPWR sky130_fd_pr__pfet_01v8_hvt ad=0.2262 pd=2.26 as=0 ps=0 w=0.87 l=0.59
X1105 a_5784_4399# _56_.D VGND VGND sky130_fd_pr__nfet_01v8 ad=0.066 pd=0.745 as=0.2205 ps=1.89 w=0.42 l=0.15
X1106 a_4772_9661# _21_.Y VGND VGND sky130_fd_pr__nfet_01v8 ad=0.066 pd=0.745 as=0.2205 ps=1.89 w=0.42 l=0.15
X1107 VPWR a_7661_5729# a_7551_5853# VPWR sky130_fd_pr__pfet_01v8_hvt ad=0.07035 pd=0.755 as=0.1155 ps=0.97 w=0.42 l=0.15
X1108 a_7553_4949# a_7387_4949# VPWR VPWR sky130_fd_pr__pfet_01v8_hvt ad=0.1664 pd=1.8 as=0.0864 ps=0.91 w=0.64 l=0.15
X1109 a_3388_7351# _35_.A_N VGND VGND sky130_fd_pr__nfet_01v8 ad=0.1092 pd=1.36 as=0.10025 ps=0.985 w=0.42 l=0.15
X1110 VPWR VGND VPWR VPWR sky130_fd_pr__pfet_01v8_hvt ad=0.2262 pd=2.26 as=0 ps=0 w=0.87 l=0.59
X1111 VGND VPWR VGND VGND sky130_fd_pr__nfet_01v8 ad=0.143 pd=1.62 as=0 ps=0 w=0.55 l=0.59
X1112 VGND VPWR VGND VGND sky130_fd_pr__nfet_01v8 ad=0.143 pd=1.62 as=0 ps=0 w=0.55 l=0.59
X1113 VGND VPWR VGND VGND sky130_fd_pr__nfet_01v8 ad=0.143 pd=1.62 as=0 ps=0 w=0.55 l=0.59
X1114 VGND VPWR VGND VGND sky130_fd_pr__nfet_01v8 ad=0.143 pd=1.62 as=0 ps=0 w=0.55 l=0.59
X1115 VGND u_loop.u_gh.C a_2277_7663# VGND sky130_fd_pr__nfet_01v8 ad=0.1346 pd=1.15 as=0.0441 ps=0.63 w=0.42 l=0.15
X1116 VPWR VGND VPWR VPWR sky130_fd_pr__pfet_01v8_hvt ad=0.2262 pd=2.26 as=0 ps=0 w=0.87 l=0.59
X1117 VGND a_3083_9537# a_3044_9411# VGND sky130_fd_pr__nfet_01v8 ad=0.0567 pd=0.69 as=0.1092 ps=1.36 w=0.42 l=0.15
X1118 VPWR VGND VPWR VPWR sky130_fd_pr__pfet_01v8_hvt ad=0.2262 pd=2.26 as=0 ps=0 w=0.87 l=0.59
X1119 a_7903_7497# a_7553_7125# a_7808_7485# VPWR sky130_fd_pr__pfet_01v8_hvt ad=0.07245 pd=0.765 as=0.0651 ps=0.73 w=0.42 l=0.15
X1120 _34_.X a_1499_6575# VGND VGND sky130_fd_pr__nfet_01v8 ad=0.091 pd=0.93 as=0.104 ps=0.97 w=0.65 l=0.15
X1121 VGND _57_.CLK a_6375_6037# VGND sky130_fd_pr__nfet_01v8 ad=0.0567 pd=0.69 as=0.1092 ps=1.36 w=0.42 l=0.15
X1122 VPWR VGND VPWR VPWR sky130_fd_pr__pfet_01v8_hvt ad=0.2262 pd=2.26 as=0 ps=0 w=0.87 l=0.59
X1123 VPWR VGND VPWR VPWR sky130_fd_pr__pfet_01v8_hvt ad=0.2262 pd=2.26 as=0 ps=0 w=0.87 l=0.59
X1124 xb a_8911_6031# VPWR VPWR sky130_fd_pr__pfet_01v8_hvt ad=0.495 pd=2.99 as=0.2726 ps=1.61 w=1 l=0.15
X1125 a_8008_5487# a_7093_5487# a_7661_5729# VGND sky130_fd_pr__special_nfet_01v8 ad=0.0711 pd=0.755 as=0.0999 ps=0.985 w=0.36 l=0.15
X1126 VGND u_loop.u_gh.B u_loop.u_gl.A2 VGND sky130_fd_pr__nfet_01v8 ad=0.169 pd=1.82 as=0.169 ps=1.82 w=0.65 l=0.15
X1127 VGND VPWR VGND VGND sky130_fd_pr__nfet_01v8 ad=0.143 pd=1.62 as=0 ps=0 w=0.55 l=0.59
X1128 _20_.Y _20_.A VGND VGND sky130_fd_pr__nfet_01v8 ad=0.08775 pd=0.92 as=0.169 ps=1.82 w=0.65 l=0.15
X1129 VPWR VGND VPWR VPWR sky130_fd_pr__pfet_01v8_hvt ad=0.2262 pd=2.26 as=0 ps=0 w=0.87 l=0.59
X1130 VPWR a_4910_2197# prenh VPWR sky130_fd_pr__pfet_01v8_hvt ad=0.2726 pd=1.61 as=0.495 ps=2.99 w=1 l=0.15
X1131 VGND u_loop.u_d3.X a_4097_2767# VGND sky130_fd_pr__nfet_01v8 ad=0.0567 pd=0.69 as=0.1092 ps=1.36 w=0.42 l=0.15
X1132 VPWR _39_.X a_7387_7125# VPWR sky130_fd_pr__pfet_01v8_hvt ad=0.0864 pd=0.91 as=0.1664 ps=1.8 w=0.64 l=0.15
X1133 a_7263_4233# a_6817_3861# a_7167_4233# VGND sky130_fd_pr__special_nfet_01v8 ad=0.1401 pd=1.1 as=0.0594 ps=0.69 w=0.36 l=0.15
X1134 VGND VPWR VGND VGND sky130_fd_pr__nfet_01v8 ad=0.143 pd=1.62 as=0 ps=0 w=0.55 l=0.59
X1135 a_4351_4175# u_loop.u_gh.C VGND VGND sky130_fd_pr__nfet_01v8 ad=0.08775 pd=0.92 as=0.08775 ps=0.92 w=0.65 l=0.15
X1136 a_8011_7119# a_7387_7125# a_7903_7497# VPWR sky130_fd_pr__pfet_01v8_hvt ad=0.1155 pd=0.97 as=0.07245 ps=0.765 w=0.42 l=0.15
X1137 a_2767_6031# u_loop.u_gh.C VPWR VPWR sky130_fd_pr__pfet_01v8_hvt ad=0.1092 pd=1.36 as=0.07035 ps=0.755 w=0.42 l=0.15
X1138 VGND VPWR VGND VGND sky130_fd_pr__nfet_01v8 ad=0.143 pd=1.62 as=0 ps=0 w=0.55 l=0.59
X1139 VPWR a_3348_7235# _38_.X VPWR sky130_fd_pr__pfet_01v8_hvt ad=0.14575 pd=1.335 as=0.135 ps=1.27 w=1 l=0.15
X1140 _53_.A a_3031_4373# VGND VGND sky130_fd_pr__nfet_01v8 ad=0.08775 pd=0.92 as=0.2087 ps=2.02 w=0.65 l=0.15
X1141 VPWR VGND VPWR VPWR sky130_fd_pr__pfet_01v8_hvt ad=0.2262 pd=2.26 as=0 ps=0 w=0.87 l=0.59
X1142 VGND _25_.A a_5377_5487# VGND sky130_fd_pr__nfet_01v8 ad=0.08775 pd=0.92 as=0.08775 ps=0.92 w=0.65 l=0.15
X1143 VGND VPWR VGND VGND sky130_fd_pr__nfet_01v8 ad=0.143 pd=1.62 as=0 ps=0 w=0.55 l=0.59
X1144 VGND VPWR VGND VGND sky130_fd_pr__nfet_01v8 ad=0.143 pd=1.62 as=0 ps=0 w=0.55 l=0.59
X1145 VGND _55_.Q _42_.Y VGND sky130_fd_pr__nfet_01v8 ad=0.169 pd=1.82 as=0.08775 ps=0.92 w=0.65 l=0.15
X1146 VGND _47_.Y a_5823_8751# VGND sky130_fd_pr__nfet_01v8 ad=0.0567 pd=0.69 as=0.1092 ps=1.36 w=0.42 l=0.15
X1147 a_2769_8213# a_2603_8213# VPWR VPWR sky130_fd_pr__pfet_01v8_hvt ad=0.1664 pd=1.8 as=0.0864 ps=0.91 w=0.64 l=0.15
X1148 u_loop.u_d0.A a_5691_3829# VPWR VPWR sky130_fd_pr__pfet_01v8_hvt ad=0.135 pd=1.27 as=0.26 ps=2.52 w=1 l=0.15
X1149 VPWR VGND VPWR VPWR sky130_fd_pr__pfet_01v8_hvt ad=0.2262 pd=2.26 as=0 ps=0 w=0.87 l=0.59
X1150 VGND VPWR VGND VGND sky130_fd_pr__nfet_01v8 ad=0.143 pd=1.62 as=0 ps=0 w=0.55 l=0.59
X1151 VGND _23_.A _63_.CLK VGND sky130_fd_pr__nfet_01v8 ad=0.169 pd=1.82 as=0.08775 ps=0.92 w=0.65 l=0.15
X1152 _38_.X a_3348_7235# VGND VGND sky130_fd_pr__nfet_01v8 ad=0.08775 pd=0.92 as=0.10187 ps=0.99 w=0.65 l=0.15
X1153 VPWR _35_.A_N a_4518_6825# VPWR sky130_fd_pr__pfet_01v8_hvt ad=0.135 pd=1.27 as=0.26 ps=2.52 w=1 l=0.15
X1154 a_7109_6005# a_6891_6409# VGND VGND sky130_fd_pr__nfet_01v8 ad=0.0999 pd=0.985 as=0.1346 ps=1.15 w=0.64 l=0.15
X1155 a_6435_8751# a_5989_8751# a_6339_8751# VGND sky130_fd_pr__special_nfet_01v8 ad=0.1401 pd=1.1 as=0.0594 ps=0.69 w=0.36 l=0.15
X1156 a_7258_8751# _55_.RESET_B VGND VGND sky130_fd_pr__nfet_01v8 ad=0.06405 pd=0.725 as=0.12495 ps=1.015 w=0.42 l=0.15
X1157 VPWR VGND VPWR VPWR sky130_fd_pr__pfet_01v8_hvt ad=0.2262 pd=2.26 as=0 ps=0 w=0.87 l=0.59
X1158 VGND a_6619_4373# _56_.Q VGND sky130_fd_pr__nfet_01v8 ad=0.169 pd=1.82 as=0.08775 ps=0.92 w=0.65 l=0.15
X1159 a_4769_4175# u_loop.u_q.Y output6.A VGND sky130_fd_pr__nfet_01v8 ad=0.08775 pd=0.92 as=0.08775 ps=0.92 w=0.65 l=0.15
X1160 VPWR VGND VPWR VPWR sky130_fd_pr__pfet_01v8_hvt ad=0.2262 pd=2.26 as=0 ps=0 w=0.87 l=0.59
X1161 VGND VPWR VGND VGND sky130_fd_pr__nfet_01v8 ad=0.143 pd=1.62 as=0 ps=0 w=0.55 l=0.59
X1162 a_4351_4175# u_loop.u_gh.B a_4769_4175# VGND sky130_fd_pr__nfet_01v8 ad=0.169 pd=1.82 as=0.08775 ps=0.92 w=0.65 l=0.15
X1163 _36_.A _35_.B VPWR VPWR sky130_fd_pr__pfet_01v8_hvt ad=0.135 pd=1.27 as=0.335 ps=1.67 w=1 l=0.15
X1164 VGND _67_.Q a_8583_6031# VGND sky130_fd_pr__nfet_01v8 ad=0.1228 pd=1.065 as=0.1134 ps=1.38 w=0.42 l=0.15
X1165 VPWR VGND VPWR VPWR sky130_fd_pr__pfet_01v8_hvt ad=0.2262 pd=2.26 as=0 ps=0 w=0.87 l=0.59
X1166 VPWR a_8800_8207# a_8911_8207# VPWR sky130_fd_pr__pfet_01v8_hvt ad=0.2726 pd=1.61 as=0.2173 ps=2.17 w=0.82 l=0.25
X1167 VPWR a_2755_7637# _63_.Q VPWR sky130_fd_pr__pfet_01v8_hvt ad=0.26 pd=2.52 as=0.135 ps=1.27 w=1 l=0.15
X1168 VPWR _39_.B2 _21_.Y VPWR sky130_fd_pr__pfet_01v8_hvt ad=0.26 pd=2.52 as=0.135 ps=1.27 w=1 l=0.15
X1169 VPWR VGND VPWR VPWR sky130_fd_pr__pfet_01v8_hvt ad=0.2262 pd=2.26 as=0 ps=0 w=0.87 l=0.59
X1170 a_3018_4765# a_1941_4399# a_2856_4399# VPWR sky130_fd_pr__pfet_01v8_hvt ad=0.0567 pd=0.69 as=0.0588 ps=0.7 w=0.42 l=0.15
X1171 a_7429_4221# a_7385_3829# a_7263_4233# VGND sky130_fd_pr__nfet_01v8 ad=0.0441 pd=0.63 as=0.1401 ps=1.1 w=0.42 l=0.15
X1172 a_7565_6409# a_6375_6037# a_7456_6409# VGND sky130_fd_pr__special_nfet_01v8 ad=0.0669 pd=0.75 as=0.0711 ps=0.755 w=0.36 l=0.15
X1173 VGND VPWR VGND VGND sky130_fd_pr__nfet_01v8 ad=0.143 pd=1.62 as=0 ps=0 w=0.55 l=0.59
X1174 VGND a_8643_7423# a_8577_7497# VGND sky130_fd_pr__nfet_01v8 ad=0.12495 pd=1.015 as=0.0669 ps=0.75 w=0.42 l=0.15
X1175 a_8165_7485# a_8121_7093# a_7999_7497# VGND sky130_fd_pr__nfet_01v8 ad=0.0441 pd=0.63 as=0.1401 ps=1.1 w=0.42 l=0.15
X1176 VGND VPWR VGND VGND sky130_fd_pr__nfet_01v8 ad=0.143 pd=1.62 as=0 ps=0 w=0.55 l=0.59
X1177 VGND a_7604_6575# a_7715_6575# VGND sky130_fd_pr__nfet_01v8 ad=0.1856 pd=1.26 as=0.17225 ps=1.83 w=0.65 l=0.25
X1178 VGND VPWR VGND VGND sky130_fd_pr__nfet_01v8 ad=0.143 pd=1.62 as=0 ps=0 w=0.55 l=0.59
X1179 a_6987_6409# a_6541_6037# a_6891_6409# VGND sky130_fd_pr__special_nfet_01v8 ad=0.1401 pd=1.1 as=0.0594 ps=0.69 w=0.36 l=0.15
X1180 _23_.Y _23_.A VPWR VPWR sky130_fd_pr__pfet_01v8_hvt ad=0.135 pd=1.27 as=0.26 ps=2.52 w=1 l=0.15
X1181 _25_.A a_8643_5247# VGND VGND sky130_fd_pr__nfet_01v8 ad=0.08775 pd=0.92 as=0.2087 ps=2.02 w=0.65 l=0.15
X1182 VPWR a_8643_7423# _68_.Q VPWR sky130_fd_pr__pfet_01v8_hvt ad=0.26 pd=2.52 as=0.135 ps=1.27 w=1 l=0.15
X1183 VGND _45_.A _57_.CLK VGND sky130_fd_pr__nfet_01v8 ad=0.169 pd=1.82 as=0.08775 ps=0.92 w=0.65 l=0.15
X1184 output7.A u_loop.u_gl.B1 a_4076_3561# VPWR sky130_fd_pr__pfet_01v8_hvt ad=0.14 pd=1.28 as=0.14 ps=1.28 w=1 l=0.15
X1185 _25_.Y _25_.A VPWR VPWR sky130_fd_pr__pfet_01v8_hvt ad=0.135 pd=1.27 as=0.26 ps=2.52 w=1 l=0.15
X1186 VPWR a_6619_4373# a_6606_4765# VPWR sky130_fd_pr__pfet_01v8_hvt ad=0.0819 pd=0.81 as=0.0567 ps=0.69 w=0.42 l=0.15
X1187 VPWR VGND VPWR VPWR sky130_fd_pr__pfet_01v8_hvt ad=0.2262 pd=2.26 as=0 ps=0 w=0.87 l=0.59
X1188 VGND _35_.A_N a_4160_6575# VGND sky130_fd_pr__nfet_01v8 ad=0.08775 pd=0.92 as=0.08775 ps=0.92 w=0.65 l=0.15
X1189 a_7072_4221# _55_.D VGND VGND sky130_fd_pr__nfet_01v8 ad=0.066 pd=0.745 as=0.2205 ps=1.89 w=0.42 l=0.15
X1190 VGND a_6619_4373# a_6553_4399# VGND sky130_fd_pr__nfet_01v8 ad=0.12495 pd=1.015 as=0.0669 ps=0.75 w=0.42 l=0.15
X1191 VGND a_5607_9599# a_5541_9673# VGND sky130_fd_pr__nfet_01v8 ad=0.12495 pd=1.015 as=0.0669 ps=0.75 w=0.42 l=0.15
X1192 VGND VPWR VGND VGND sky130_fd_pr__nfet_01v8 ad=0.143 pd=1.62 as=0 ps=0 w=0.55 l=0.59
X1193 a_6449_7663# a_6283_7663# VPWR VPWR sky130_fd_pr__pfet_01v8_hvt ad=0.1664 pd=1.8 as=0.0864 ps=0.91 w=0.64 l=0.15
X1194 a_1654_6575# _34_.B1 a_1582_6575# VGND sky130_fd_pr__nfet_01v8 ad=0.16535 pd=1.82 as=0.06825 ps=0.86 w=0.65 l=0.15
X1195 VGND _55_.RESET_B a_7153_6397# VGND sky130_fd_pr__nfet_01v8 ad=0.1346 pd=1.15 as=0.0441 ps=0.63 w=0.42 l=0.15
X1196 a_2125_2767# a_1889_2767# VGND VGND sky130_fd_pr__nfet_01v8 ad=0.1092 pd=1.36 as=0.0567 ps=0.69 w=0.42 l=0.5
X1197 VGND VPWR VGND VGND sky130_fd_pr__nfet_01v8 ad=0.143 pd=1.62 as=0 ps=0 w=0.55 l=0.59
X1198 VGND _46_.Y a_6283_7663# VGND sky130_fd_pr__nfet_01v8 ad=0.0567 pd=0.69 as=0.1092 ps=1.36 w=0.42 l=0.15
X1199 VPWR a_3399_6335# a_3386_6031# VPWR sky130_fd_pr__pfet_01v8_hvt ad=0.0819 pd=0.81 as=0.0567 ps=0.69 w=0.42 l=0.15
X1200 a_8117_5487# a_6927_5487# a_8008_5487# VGND sky130_fd_pr__special_nfet_01v8 ad=0.0669 pd=0.75 as=0.0711 ps=0.755 w=0.36 l=0.15
X1201 VGND _50_.Y a_2603_8213# VGND sky130_fd_pr__nfet_01v8 ad=0.0567 pd=0.69 as=0.1092 ps=1.36 w=0.42 l=0.15
X1202 a_2755_7637# u_loop.u_gh.C VPWR VPWR sky130_fd_pr__pfet_01v8_hvt ad=0.0567 pd=0.69 as=0.0819 ps=0.81 w=0.42 l=0.15
X1203 a_1624_7119# a_1407_7119# VPWR VPWR sky130_fd_pr__pfet_01v8_hvt ad=0.2173 pd=2.17 as=0.19265 ps=1.415 w=0.82 l=0.25
X1204 _63_.D _63_.Q VPWR VPWR sky130_fd_pr__pfet_01v8_hvt ad=0.135 pd=1.27 as=0.26 ps=2.52 w=1 l=0.15
X1205 a_6799_7663# a_6449_7663# a_6704_7663# VPWR sky130_fd_pr__pfet_01v8_hvt ad=0.07245 pd=0.765 as=0.0651 ps=0.73 w=0.42 l=0.15
X1206 a_3388_7351# _35_.A_N VPWR VPWR sky130_fd_pr__pfet_01v8_hvt ad=0.1092 pd=1.36 as=0.14575 ps=1.335 w=0.42 l=0.15
X1207 a_5190_5487# _56_.Q a_5389_5737# VPWR sky130_fd_pr__pfet_01v8_hvt ad=0.3875 pd=1.775 as=0.1125 ps=1.225 w=1 l=0.15
X1208 a_4038_8573# u_loop.u_gh.C VGND VGND sky130_fd_pr__nfet_01v8 ad=0.06405 pd=0.725 as=0.12495 ps=1.015 w=0.42 l=0.15
X1209 VGND a_2360_7119# a_2471_7119# VGND sky130_fd_pr__nfet_01v8 ad=0.1856 pd=1.26 as=0.17225 ps=1.83 w=0.65 l=0.25
X1210 VPWR _20_.A _20_.Y VPWR sky130_fd_pr__pfet_01v8_hvt ad=0.26 pd=2.52 as=0.135 ps=1.27 w=1 l=0.15
X1211 VGND VPWR VGND VGND sky130_fd_pr__nfet_01v8 ad=0.143 pd=1.62 as=0 ps=0 w=0.55 l=0.59
X1212 a_5989_8751# a_5823_8751# VPWR VPWR sky130_fd_pr__pfet_01v8_hvt ad=0.1664 pd=1.8 as=0.0864 ps=0.91 w=0.64 l=0.15
X1213 input5.X a_5875_2223# VPWR VPWR sky130_fd_pr__pfet_01v8_hvt ad=0.495 pd=2.99 as=0.2726 ps=1.61 w=1 l=0.15
X1214 _46_.A a_7079_8725# VPWR VPWR sky130_fd_pr__pfet_01v8_hvt ad=0.135 pd=1.27 as=0.3012 ps=2.66 w=1 l=0.15
X1215 _41_.X a_5190_5487# VPWR VPWR sky130_fd_pr__pfet_01v8_hvt ad=0.135 pd=1.27 as=0.165 ps=1.33 w=1 l=0.15
X1216 VPWR VGND VPWR VPWR sky130_fd_pr__pfet_01v8_hvt ad=0.2262 pd=2.26 as=0 ps=0 w=0.87 l=0.59
X1217 VGND VPWR VGND VGND sky130_fd_pr__nfet_01v8 ad=0.143 pd=1.62 as=0 ps=0 w=0.55 l=0.59
X1218 VPWR VGND VPWR VPWR sky130_fd_pr__pfet_01v8_hvt ad=0.2262 pd=2.26 as=0 ps=0 w=0.87 l=0.59
X1219 _67_.Q a_8183_5461# VPWR VPWR sky130_fd_pr__pfet_01v8_hvt ad=0.135 pd=1.27 as=0.3012 ps=2.66 w=1 l=0.15
X1220 VPWR u_loop.u_d1.X a_2625_2767# VPWR sky130_fd_pr__pfet_01v8_hvt ad=0.0567 pd=0.69 as=0.1092 ps=1.36 w=0.42 l=0.15
X1221 VGND u_loop.u_gl.A2 a_4510_3311# VGND sky130_fd_pr__nfet_01v8 ad=0.17225 pd=1.83 as=0.091 ps=0.93 w=0.65 l=0.15
X1222 a_6907_8029# a_6283_7663# a_6799_7663# VPWR sky130_fd_pr__pfet_01v8_hvt ad=0.1155 pd=0.97 as=0.07245 ps=0.765 w=0.42 l=0.15
X1223 a_1624_6031# a_1407_6031# VPWR VPWR sky130_fd_pr__pfet_01v8_hvt ad=0.2173 pd=2.17 as=0.19265 ps=1.415 w=0.82 l=0.25
X1224 a_8362_5487# _55_.RESET_B VGND VGND sky130_fd_pr__nfet_01v8 ad=0.06405 pd=0.725 as=0.12495 ps=1.015 w=0.42 l=0.15
X1225 VPWR VGND VPWR VPWR sky130_fd_pr__pfet_01v8_hvt ad=0.2262 pd=2.26 as=0 ps=0 w=0.87 l=0.59
X1226 VGND src[1] a_1407_7119# VGND sky130_fd_pr__nfet_01v8 ad=0.1228 pd=1.065 as=0.1134 ps=1.38 w=0.42 l=0.15
X1227 VPWR a_3031_4373# _53_.A VPWR sky130_fd_pr__pfet_01v8_hvt ad=0.26 pd=2.52 as=0.135 ps=1.27 w=1 l=0.15
X1228 VPWR a_3337_8181# a_3227_8207# VPWR sky130_fd_pr__pfet_01v8_hvt ad=0.07035 pd=0.755 as=0.1155 ps=0.97 w=0.42 l=0.15
X1229 VGND u_loop.u_d0.X a_2533_2223# VGND sky130_fd_pr__nfet_01v8 ad=0.0567 pd=0.69 as=0.1092 ps=1.36 w=0.42 l=0.15
X1230 VGND VPWR VGND VGND sky130_fd_pr__nfet_01v8 ad=0.143 pd=1.62 as=0 ps=0 w=0.55 l=0.59
X1231 a_1845_6825# _35_.B a_1499_6575# VPWR sky130_fd_pr__pfet_01v8_hvt ad=0.105 pd=1.21 as=0.3675 ps=1.735 w=1 l=0.15
X1232 a_4333_2767# a_4097_2767# VPWR VPWR sky130_fd_pr__pfet_01v8_hvt ad=0.1092 pd=1.36 as=0.0567 ps=0.69 w=0.42 l=0.5
X1233 VPWR _30_.A _48_.Y VPWR sky130_fd_pr__pfet_01v8_hvt ad=0.26 pd=2.52 as=0.135 ps=1.27 w=1 l=0.15
X1234 VPWR VGND VPWR VPWR sky130_fd_pr__pfet_01v8_hvt ad=0.2262 pd=2.26 as=0 ps=0 w=0.87 l=0.59
X1235 VGND a_3491_5247# _28_.A VGND sky130_fd_pr__nfet_01v8 ad=0.169 pd=1.82 as=0.08775 ps=0.92 w=0.65 l=0.15
X1236 a_2291_4399# a_1941_4399# a_2196_4399# VPWR sky130_fd_pr__pfet_01v8_hvt ad=0.07245 pd=0.765 as=0.0651 ps=0.73 w=0.42 l=0.15
X1237 _27_.Y _53_.A VGND VGND sky130_fd_pr__nfet_01v8 ad=0.08775 pd=0.92 as=0.169 ps=1.82 w=0.65 l=0.15
X1238 _41_.C1 a_3992_7235# VPWR VPWR sky130_fd_pr__pfet_01v8_hvt ad=0.135 pd=1.27 as=0.14825 ps=1.34 w=1 l=0.15
X1239 VPWR a_4167_6147# _36_.A VPWR sky130_fd_pr__pfet_01v8_hvt ad=0.335 pd=1.67 as=0.165 ps=1.33 w=1 l=0.15
X1240 a_2689_7663# a_1499_7663# a_2580_7663# VGND sky130_fd_pr__special_nfet_01v8 ad=0.0669 pd=0.75 as=0.0711 ps=0.755 w=0.36 l=0.15
X1241 VGND u_loop.u_d6.X a_6397_2767# VGND sky130_fd_pr__nfet_01v8 ad=0.0567 pd=0.69 as=0.1092 ps=1.36 w=0.42 l=0.15
X1242 _30_.A a_2479_9269# VGND VGND sky130_fd_pr__nfet_01v8 ad=0.08775 pd=0.92 as=0.169 ps=1.82 w=0.65 l=0.15
X1243 VPWR a_7456_6409# a_7631_6335# VPWR sky130_fd_pr__pfet_01v8_hvt ad=0.1134 pd=1.38 as=0.0567 ps=0.69 w=0.42 l=0.15
X1244 VGND VPWR VGND VGND sky130_fd_pr__nfet_01v8 ad=0.143 pd=1.62 as=0 ps=0 w=0.55 l=0.59
X1245 VPWR VGND VPWR VPWR sky130_fd_pr__pfet_01v8_hvt ad=0.2262 pd=2.26 as=0 ps=0 w=0.87 l=0.59
X1246 a_5607_9599# u_loop.u_gh.C VPWR VPWR sky130_fd_pr__pfet_01v8_hvt ad=0.0567 pd=0.69 as=0.0819 ps=0.81 w=0.42 l=0.15
X1247 a_4160_6575# _35_.B a_4075_6825# VPWR sky130_fd_pr__pfet_01v8_hvt ad=0.135 pd=1.27 as=0.135 ps=1.27 w=1 l=0.15
X1248 VGND VPWR VGND VGND sky130_fd_pr__nfet_01v8 ad=0.143 pd=1.62 as=0 ps=0 w=0.55 l=0.59
X1249 a_3425_5321# a_2235_4949# a_3316_5321# VGND sky130_fd_pr__special_nfet_01v8 ad=0.0669 pd=0.75 as=0.0711 ps=0.755 w=0.36 l=0.15
X1250 VPWR _53_.A _53_.Y VPWR sky130_fd_pr__pfet_01v8_hvt ad=0.26 pd=2.52 as=0.135 ps=1.27 w=1 l=0.15
X1251 a_3436_6549# _34_.X VPWR VPWR sky130_fd_pr__pfet_01v8_hvt ad=0.27 pd=2.54 as=0.19265 ps=1.415 w=1 l=0.15
X1252 a_6796_6397# _32_.Y VPWR VPWR sky130_fd_pr__pfet_01v8_hvt ad=0.0651 pd=0.73 as=0.1092 ps=1.36 w=0.42 l=0.15
X1253 VPWR VGND VPWR VPWR sky130_fd_pr__pfet_01v8_hvt ad=0.2262 pd=2.26 as=0 ps=0 w=0.87 l=0.59
X1254 a_6339_8751# a_5989_8751# a_6244_8751# VPWR sky130_fd_pr__pfet_01v8_hvt ad=0.07245 pd=0.765 as=0.0651 ps=0.73 w=0.42 l=0.15
X1255 a_3859_8511# a_3684_8585# a_4038_8573# VGND sky130_fd_pr__nfet_01v8 ad=0.1092 pd=1.36 as=0.06405 ps=0.725 w=0.42 l=0.15
X1256 a_2934_7663# u_loop.u_gh.C VGND VGND sky130_fd_pr__nfet_01v8 ad=0.06405 pd=0.725 as=0.12495 ps=1.015 w=0.42 l=0.15
X1257 VPWR _36_.A u_loop.u_gh.B VPWR sky130_fd_pr__pfet_01v8_hvt ad=0.26 pd=2.52 as=0.135 ps=1.27 w=1 l=0.15
X1258 a_6381_3561# u_loop.u_qb.A VPWR VPWR sky130_fd_pr__pfet_01v8_hvt ad=0.105 pd=1.21 as=0.26 ps=2.52 w=1 l=0.15
X1259 VPWR _63_.CLK a_1499_7663# VPWR sky130_fd_pr__pfet_01v8_hvt ad=0.0864 pd=0.91 as=0.1664 ps=1.8 w=0.64 l=0.15
X1260 VPWR a_2233_7905# a_2123_8029# VPWR sky130_fd_pr__pfet_01v8_hvt ad=0.07035 pd=0.755 as=0.1155 ps=0.97 w=0.42 l=0.15
X1261 _35_.B a_1735_7119# VGND VGND sky130_fd_pr__nfet_01v8 ad=0.2079 pd=1.83 as=0.1856 ps=1.26 w=0.42 l=0.15
X1262 VGND VPWR VGND VGND sky130_fd_pr__nfet_01v8 ad=0.143 pd=1.62 as=0 ps=0 w=0.55 l=0.59
X1263 a_4076_3561# u_loop.u_gl.B1 output7.A VPWR sky130_fd_pr__pfet_01v8_hvt ad=0.155 pd=1.31 as=0.14 ps=1.28 w=1 l=0.15
X1264 a_7109_6005# a_6891_6409# VPWR VPWR sky130_fd_pr__pfet_01v8_hvt ad=0.12915 pd=1.185 as=0.2184 ps=2.2 w=0.84 l=0.15
X1265 u_loop.u_s1.Y u_loop.u_cmp.Y VPWR VPWR sky130_fd_pr__pfet_01v8_hvt ad=0.26 pd=2.52 as=0.26 ps=2.52 w=1 l=0.15
X1266 a_2401_4949# a_2235_4949# VGND VGND sky130_fd_pr__nfet_01v8 ad=0.1092 pd=1.36 as=0.0567 ps=0.69 w=0.42 l=0.15
X1267 VPWR _56_.Q _56_.D VPWR sky130_fd_pr__pfet_01v8_hvt ad=0.26 pd=2.52 as=0.135 ps=1.27 w=1 l=0.15
X1268 VPWR VGND VPWR VPWR sky130_fd_pr__pfet_01v8_hvt ad=0.2262 pd=2.26 as=0 ps=0 w=0.87 l=0.59
X1269 a_7907_4159# _55_.RESET_B VPWR VPWR sky130_fd_pr__pfet_01v8_hvt ad=0.0567 pd=0.69 as=0.0819 ps=0.81 w=0.42 l=0.15
X1270 a_6447_9117# a_5823_8751# a_6339_8751# VPWR sky130_fd_pr__pfet_01v8_hvt ad=0.1155 pd=0.97 as=0.07245 ps=0.765 w=0.42 l=0.15
X1271 VGND VPWR VGND VGND sky130_fd_pr__nfet_01v8 ad=0.143 pd=1.62 as=0 ps=0 w=0.55 l=0.59
X1272 VGND VPWR VGND VGND sky130_fd_pr__nfet_01v8 ad=0.143 pd=1.62 as=0 ps=0 w=0.55 l=0.59
X1273 a_5276_2197# output6.A VPWR VPWR sky130_fd_pr__pfet_01v8_hvt ad=0.27 pd=2.54 as=0.19265 ps=1.415 w=1 l=0.15
X1274 VPWR VGND VPWR VPWR sky130_fd_pr__pfet_01v8_hvt ad=0.2262 pd=2.26 as=0 ps=0 w=0.87 l=0.59
X1275 VGND VPWR VGND VGND sky130_fd_pr__nfet_01v8 ad=0.143 pd=1.62 as=0 ps=0 w=0.55 l=0.59
X1276 VGND u_loop.u_d4.X a_4833_2767# VGND sky130_fd_pr__nfet_01v8 ad=0.0567 pd=0.69 as=0.1092 ps=1.36 w=0.42 l=0.15
X1277 a_4076_3561# u_loop.u_d0.A VPWR VPWR sky130_fd_pr__pfet_01v8_hvt ad=0.14 pd=1.28 as=0.14 ps=1.28 w=1 l=0.15
X1278 VPWR a_5607_9599# a_5594_9295# VPWR sky130_fd_pr__pfet_01v8_hvt ad=0.0819 pd=0.81 as=0.0567 ps=0.69 w=0.42 l=0.15
X1279 a_7456_6409# a_6375_6037# a_7109_6005# VPWR sky130_fd_pr__pfet_01v8_hvt ad=0.0588 pd=0.7 as=0.12915 ps=1.185 w=0.42 l=0.15
X1280 a_7808_5309# _25_.Y VPWR VPWR sky130_fd_pr__pfet_01v8_hvt ad=0.0651 pd=0.73 as=0.1092 ps=1.36 w=0.42 l=0.15
X1281 a_5190_7439# _39_.B2 a_5389_7119# VPWR sky130_fd_pr__pfet_01v8_hvt ad=0.3875 pd=1.775 as=0.1125 ps=1.225 w=1 l=0.15
X1282 VPWR VGND VPWR VPWR sky130_fd_pr__pfet_01v8_hvt ad=0.2262 pd=2.26 as=0 ps=0 w=0.87 l=0.59
X1283 a_2859_4943# a_2235_4949# a_2751_5321# VPWR sky130_fd_pr__pfet_01v8_hvt ad=0.1155 pd=0.97 as=0.07245 ps=0.765 w=0.42 l=0.15
X1284 a_3384_9295# a_3170_9295# VPWR VPWR sky130_fd_pr__pfet_01v8_hvt ad=0.1155 pd=0.97 as=0.07035 ps=0.755 w=0.42 l=0.15
X1285 VGND VPWR VGND VGND sky130_fd_pr__nfet_01v8 ad=0.143 pd=1.62 as=0 ps=0 w=0.55 l=0.59
X1286 VGND VPWR VGND VGND sky130_fd_pr__nfet_01v8 ad=0.143 pd=1.62 as=0 ps=0 w=0.55 l=0.59
X1287 VGND _63_.Q _50_.Y VGND sky130_fd_pr__nfet_01v8 ad=0.169 pd=1.82 as=0.08775 ps=0.92 w=0.65 l=0.15
X1288 VPWR VGND VPWR VPWR sky130_fd_pr__pfet_01v8_hvt ad=0.2262 pd=2.26 as=0 ps=0 w=0.87 l=0.59
X1289 VPWR _52_.Y a_2143_6037# VPWR sky130_fd_pr__pfet_01v8_hvt ad=0.0864 pd=0.91 as=0.1664 ps=1.8 w=0.64 l=0.15
X1290 a_2965_4399# a_1775_4399# a_2856_4399# VGND sky130_fd_pr__special_nfet_01v8 ad=0.0669 pd=0.75 as=0.0711 ps=0.755 w=0.36 l=0.15
X1291 _47_.Y _39_.B2 VPWR VPWR sky130_fd_pr__pfet_01v8_hvt ad=0.135 pd=1.27 as=0.26 ps=2.52 w=1 l=0.15
X1292 VGND a_7079_8725# _46_.A VGND sky130_fd_pr__nfet_01v8 ad=0.169 pd=1.82 as=0.08775 ps=0.92 w=0.65 l=0.15
X1293 VGND VPWR VGND VGND sky130_fd_pr__nfet_01v8 ad=0.143 pd=1.62 as=0 ps=0 w=0.55 l=0.59
X1294 VGND VPWR VGND VGND sky130_fd_pr__nfet_01v8 ad=0.143 pd=1.62 as=0 ps=0 w=0.55 l=0.59
X1295 _39_.X a_5190_7439# VPWR VPWR sky130_fd_pr__pfet_01v8_hvt ad=0.135 pd=1.27 as=0.165 ps=1.33 w=1 l=0.15
X1296 VPWR VGND VPWR VPWR sky130_fd_pr__pfet_01v8_hvt ad=0.2262 pd=2.26 as=0 ps=0 w=0.87 l=0.59
X1297 VPWR _32_.A _56_.CLK VPWR sky130_fd_pr__pfet_01v8_hvt ad=0.26 pd=2.52 as=0.135 ps=1.27 w=1 l=0.15
C0 a_4075_6825# _35_.B 0.10251f
C1 a_3044_9411# a_3684_8585# 0
C2 a_6283_7663# _34_.X 0
C3 _32_.Y a_6796_6397# 0.1576f
C4 u_loop.u_gh.C a_3386_6031# 0
C5 _63_.Q _34_.X 0
C6 a_3044_9411# a_3041_9661# 0
C7 a_2564_6397# a_2755_6409# 0
C8 a_2564_6397# a_2360_7119# 0
C9 _45_.A a_6895_7663# 0.00444f
C10 _22_.Y _68_.D 0
C11 _32_.A a_7153_6397# 0.00224f
C12 a_5989_8751# _31_.Y 0.22396f
C13 a_7551_5853# _55_.RESET_B 0.01638f
C14 a_1499_7663# u_loop.u_gh.C 0.29653f
C15 _52_.Y _28_.A 0.12592f
C16 a_3684_8585# a_3846_8207# 0.00645f
C17 a_6375_6037# a_6796_6397# 0.08638f
C18 a_1654_6575# _35_.B 0.03693f
C19 a_2965_4399# a_2509_4641# 0
C20 a_3119_8585# a_3083_9537# 0
C21 _20_.A a_2564_6397# 0
C22 _52_.Y a_2143_7119# 0
C23 a_6449_7663# _68_.Q 0
C24 a_7079_8725# VPWR 0.45033f
C25 _63_.Q a_3196_6733# 0
C26 a_3070_6549# _63_.Q 0
C27 a_5363_4399# u_loop.u_gl.A2 0
C28 _45_.A _46_.Y 0.0046f
C29 a_3119_8585# a_3170_9295# 0
C30 a_7387_7125# a_7456_6409# 0
C31 _55_.RESET_B _34_.X 0.00338f
C32 a_1499_6575# _28_.Y 0
C33 _63_.D _63_.CLK 0.30721f
C34 _34_.X a_1665_7663# 0
C35 u_loop.u_d3.X a_3597_2767# 0.01908f
C36 a_6449_7663# a_6375_6037# 0
C37 a_3549_9661# u_loop.u_gh.C 0.00282f
C38 a_7553_7125# a_7443_5487# 0
C39 a_2965_4399# a_1941_4399# 0
C40 a_3224_6409# a_3386_6031# 0.00645f
C41 _57_.CLK _25_.A 0
C42 _30_.Y a_4517_9301# 0
C43 a_7443_5487# a_7715_6575# 0.00112f
C44 a_3477_9661# u_loop.u_gh.C 0.00311f
C45 a_7553_7125# a_7661_5729# 0
C46 a_7079_8725# a_7017_7905# 0
C47 _56_.Q _57_.CLK 0
C48 _55_.CLK a_7072_4221# 0
C49 a_7553_7125# a_7093_5487# 0
C50 a_8577_7497# a_8121_7093# 0
C51 a_8170_5853# VPWR 0
C52 a_3384_9295# a_3083_9537# 0
C53 a_7539_7637# _68__14.LO 0
C54 a_7387_7125# a_7631_6335# 0
C55 output6.A u_loop.u_d4.X 0.00441f
C56 a_7715_6575# a_7661_5729# 0
C57 a_4369_6351# u_loop.u_gh.C 0
C58 _34_.B1 a_2235_4949# 0
C59 a_7715_6575# a_7093_5487# 0
C60 a_7387_7125# a_6891_6409# 0
C61 _23_.Y u_loop.u_gh.C 0
C62 a_4351_9301# _48_.Y 0.25405f
C63 a_6397_2767# a_5805_2767# 0
C64 a_3227_8207# _63_.Q 0
C65 a_3384_9295# a_3170_9295# 0.09774f
C66 _55_.CLK output6.A 0
C67 a_7604_6575# a_7443_5487# 0
C68 _55_.CLK a_4769_4175# 0.00107f
C69 u_loop.u_gl.A2 prenh 0
C70 _55_.CLK a_4351_4175# 0
C71 a_3684_8585# u_loop.u_gh.C 0.24503f
C72 a_7631_6335# a_7456_6409# 0.23366f
C73 a_3041_9661# u_loop.u_gh.C 0
C74 a_3041_9661# a_2766_9427# 0.00742f
C75 a_2965_4399# a_1775_4399# 0
C76 a_6891_6409# a_7456_6409# 0
C77 a_2563_6575# a_1665_7663# 0
C78 _53_.Y _34_.B1 0
C79 u_loop.u_q.Y _56_.CLK 0.00967f
C80 a_6283_7663# VPWR 0.49492f
C81 _55_.CLK a_7732_4233# 0
C82 u_loop.u_q.Y _41_.X 0
C83 a_7604_6575# a_7661_5729# 0
C84 a_5377_5487# VPWR 0.00528f
C85 a_7604_6575# a_7093_5487# 0
C86 _63_.Q VPWR 0.97922f
C87 _32_.A a_4369_6351# 0
C88 a_6447_9117# _21_.Y 0
C89 a_4833_2767# a_4910_2197# 0.00107f
C90 _55_.CLK a_7907_4159# 0
C91 _48_.Y a_4772_9661# 0.00136f
C92 a_5911_2767# u_loop.u_d5.X 0
C93 _32_.A a_6796_6397# 0.02406f
C94 a_2471_7119# u_loop.u_gh.C 0.00409f
C95 output7.A a_4439_2767# 0.0115f
C96 a_2877_6005# a_3386_6031# 0
C97 a_3224_6409# a_4369_6351# 0
C98 a_4167_6147# a_4369_6351# 0.05476f
C99 a_2309_6037# a_3386_6031# 0
C100 _55_.CLK a_7167_4233# 0
C101 a_6449_7663# a_5989_8751# 0
C102 _23_.Y a_3224_6409# 0
C103 a_3210_4399# _53_.A 0.00206f
C104 a_7551_5853# a_7443_5487# 0.05722f
C105 a_3381_8573# _23_.A 0
C106 _55_.RESET_B VPWR 2.42204f
C107 _63_.CLK a_2755_7637# 0
C108 a_5293_5487# VPWR 0.00397f
C109 _63_.Q a_2235_6575# 0
C110 _63_.D a_1735_7119# 0.00201f
C111 VPWR a_1665_7663# 0.63077f
C112 a_2452_6575# a_1665_7663# 0
C113 a_6283_7663# a_7017_7905# 0.07009f
C114 a_6339_8751# _46_.A 0.0419f
C115 a_7109_6005# a_7456_6409# 0.05116f
C116 output6.A u_loop.u_gh.B 0.21712f
C117 _23_.Y a_3399_6335# 0
C118 a_7551_5853# a_7661_5729# 0.09774f
C119 a_4351_9301# a_3083_9537# 0.10415f
C120 _63_.Q a_2580_7663# 0.03864f
C121 a_7551_5853# a_7093_5487# 0.03462f
C122 a_6541_6037# _39_.X 0
C123 a_7604_6575# a_6927_5487# 0
C124 u_loop.u_gh.B a_4769_4175# 0.03277f
C125 u_loop.u_gh.B a_4351_4175# 0.1823f
C126 _35_.B a_1845_6825# 0.0016f
C127 u_loop.u_q.Y u_loop.u_d5.X 0
C128 a_6927_5487# a_7387_6575# 0
C129 u_loop.u_gl.B1 u_loop.u_gh.B 0.00139f
C130 a_2231_2767# _53_.Y 0
C131 en _20_.Y 0.08135f
C132 _53_.A a_2965_4399# 0
C133 _53_.Y a_2125_2767# 0
C134 a_4032_7351# u_loop.u_gh.C 0
C135 a_5547_2223# prenh 0
C136 _68_.Q a_8583_8207# 0.20958f
C137 u_loop.u_gl.A2 a_2856_4399# 0
C138 a_3348_7235# a_3388_7351# 0.16753f
C139 u_loop.u_d2.X output7.A 0.00286f
C140 a_2235_6575# a_1665_7663# 0
C141 _55_.RESET_B a_7017_7905# 0.17351f
C142 a_3239_9269# a_2769_8213# 0
C143 _40_.B a_2755_7637# 0.00107f
C144 u_loop.u_d0.X a_2875_2223# 0.00404f
C145 a_2769_8213# a_3859_8511# 0.04176f
C146 a_4772_9661# a_3083_9537# 0
C147 _30_.Y a_3239_9269# 0.00268f
C148 _23_.Y a_2659_6409# 0.00103f
C149 a_7387_7125# _68_.Q 0.00409f
C150 a_5190_5487# u_loop.u_q.Y 0
C151 _30_.Y a_3859_8511# 0.00241f
C152 a_3388_7351# _34_.X 0
C153 a_2580_7663# a_1665_7663# 0.12532f
C154 _55_.CLK a_7385_3829# 0
C155 VPWR a_7348_5487# 0.08228f
C156 a_7109_6005# a_6891_6409# 0.20964f
C157 a_2233_7905# a_2015_7663# 0.20964f
C158 a_3388_7351# a_3436_6549# 0
C159 a_5607_9599# u_loop.u_gh.C 0.27801f
C160 a_2877_6005# _23_.Y 0.00137f
C161 a_5276_2197# prenh 0.00155f
C162 a_2767_6031# u_loop.u_gh.C 0.0122f
C163 a_7551_5853# a_6927_5487# 0
C164 a_3348_7235# a_3430_7235# 0
C165 _23_.Y a_2309_6037# 0.27243f
C166 src[0] _20_.Y 0
C167 _63_.D a_1624_7119# 0.00624f
C168 a_7387_7125# a_6375_6037# 0
C169 a_8008_5487# VPWR 0.2961f
C170 a_3388_7351# a_3196_6733# 0
C171 a_7473_7663# _22_.Y 0
C172 a_1499_7663# a_2143_6037# 0
C173 a_2015_7663# _35_.B 0
C174 a_8800_8207# a_8583_8207# 0.11296f
C175 _67_.D _57_.CLK 0
C176 a_5276_2197# a_5547_2223# 0.14228f
C177 a_5989_8751# a_5607_9599# 0
C178 u_loop.u_gh.C a_3578_6397# 0.00288f
C179 a_6244_8751# a_6435_8751# 0
C180 a_4167_6147# a_4032_7351# 0
C181 a_2471_7119# a_2659_6409# 0
C182 u_loop.u_q.Y _25_.A 0
C183 a_3031_4373# u_loop.u_gl.A2 0
C184 _45_.A _68_.D 0.1582f
C185 a_7456_6409# a_6375_6037# 0.10232f
C186 a_8183_5461# VPWR 0.42308f
C187 a_4518_6575# _34_.X 0.07132f
C188 a_4160_6575# a_4518_6575# 0.01892f
C189 u_loop.u_q.Y _56_.Q 0
C190 _52_.Y a_3386_6031# 0
C191 _56_.CLK _34_.X 0
C192 _47_.Y VPWR 0.38963f
C193 _41_.X _34_.X 0
C194 a_3388_7351# a_3992_7235# 0.06623f
C195 _22_.Y a_5823_8751# 0
C196 a_2309_6037# a_2471_7119# 0
C197 a_4510_3311# a_5036_2381# 0
C198 a_3348_7235# _38_.X 0.12583f
C199 a_2196_4399# a_2387_4399# 0
C200 a_6904_8751# a_6339_8751# 0
C201 _22_.Y a_7539_7637# 0
C202 a_7810_6397# _57_.CLK 0
C203 a_2921_6397# u_loop.u_gh.C 0.00391f
C204 u_loop.u_gh.C a_3333_6409# 0
C205 a_6891_6409# _32_.Y 0
C206 a_2856_4399# a_3018_4765# 0.00645f
C207 a_2233_7905# _34_.X 0
C208 a_7443_5487# VPWR 0.20227f
C209 _38_.X _34_.X 0
C210 a_3348_7235# _35_.B 0.14796f
C211 _57_.CLK a_7565_6409# 0
C212 a_7631_6335# a_6375_6037# 0.04348f
C213 a_4867_9673# _39_.B2 0.00952f
C214 a_3227_8207# a_3388_7351# 0
C215 a_2755_6409# u_loop.u_gh.C 0.00223f
C216 a_3044_9411# _49_.Y 0.00508f
C217 a_6891_6409# a_6375_6037# 0.10879f
C218 _55_.CLK a_6817_3861# 0.00234f
C219 a_2360_7119# u_loop.u_gh.C 0.00327f
C220 a_2564_6397# u_loop.u_gh.C 0.00109f
C221 _23_.A _62_.D 0.02317f
C222 VPWR a_7661_5729# 0.20644f
C223 _34_.X _35_.B 0.25374f
C224 VPWR a_7093_5487# 0.58074f
C225 a_4160_6575# _35_.B 0.25146f
C226 a_4369_6351# a_2143_6037# 0
C227 a_3337_8181# a_3348_7235# 0
C228 _21_.Y a_6557_8993# 0
C229 a_1499_6575# _63_.Q 0
C230 _23_.Y a_2143_6037# 0.17356f
C231 a_3436_6549# _35_.B 0.0035f
C232 u_loop.u_d3.X VPWR 0.24253f
C233 prenl a_4333_2767# 0
C234 _20_.A u_loop.u_gh.C 0
C235 a_2553_4399# a_2291_4399# 0.00171f
C236 a_6339_8751# a_6799_7663# 0
C237 a_7604_6575# _25_.A 0
C238 _57_.CLK a_7153_6397# 0
C239 a_3388_7351# VPWR 0.20602f
C240 a_3119_8585# a_2755_7637# 0
C241 a_3399_6335# a_3578_6397# 0.0074f
C242 _62_.D a_3024_8573# 0.17813f
C243 a_2533_2223# VPWR 0.32565f
C244 a_3337_8181# _34_.X 0
C245 VPWR a_1407_7119# 0.34453f
C246 a_7258_8751# _46_.A 0.00199f
C247 _56_.D _36_.A 0
C248 a_3196_6733# _35_.B 0.0012f
C249 a_3070_6549# _35_.B 0
C250 a_3224_6409# a_3333_6409# 0.00742f
C251 u_loop.u_gl.A2 a_4910_2197# 0.0016f
C252 a_7387_7125# _32_.A 0
C253 a_7109_6005# _32_.Y 0
C254 a_4833_2767# u_loop.u_d0.A 0.00264f
C255 a_3992_7235# _38_.X 0.05844f
C256 a_2767_6031# a_2659_6409# 0.05722f
C257 _23_.Y _52_.Y 0.14667f
C258 a_1499_6575# a_1665_7663# 0.00141f
C259 a_7387_4949# a_7275_3855# 0
C260 _23_.Y a_1735_6031# 0.00119f
C261 a_2143_6037# a_2471_7119# 0
C262 a_1624_6031# _23_.Y 0
C263 a_7808_5309# a_6651_3861# 0
C264 a_3337_8181# a_3196_6733# 0
C265 a_7109_6005# a_6375_6037# 0.05843f
C266 _36_.A u_loop.u_gh.B 0.10626f
C267 a_2767_6031# a_2877_6005# 0.09774f
C268 a_7456_6409# _32_.A 0.04054f
C269 _45_.A a_7903_7497# 0
C270 a_3992_7235# _35_.B 0.14198f
C271 a_6927_5487# VPWR 0.46956f
C272 a_2767_6031# a_2309_6037# 0.03462f
C273 a_7631_6335# u_loop.u_gh.C 0
C274 a_4518_6575# VPWR 0.00316f
C275 _42_.Y a_7275_3855# 0
C276 a_2563_6575# _35_.B 0
C277 a_6891_6409# u_loop.u_gh.C 0
C278 a_3670_5309# _36_.A 0
C279 _56_.CLK VPWR 0.82125f
C280 a_2143_7119# a_2015_7663# 0
C281 _41_.X VPWR 0.83095f
C282 _34_.B1 a_1665_7663# 0
C283 a_1407_6031# _23_.Y 0
C284 _55_.CLK a_6651_3861# 0.26828f
C285 a_6541_6037# a_6283_7663# 0
C286 a_8577_7497# _68_.D 0
C287 _52_.Y a_2471_7119# 0
C288 _55_.CLK a_5691_3829# 0.00171f
C289 x a_5036_2381# 0.00369f
C290 _55_.RESET_B a_8630_7119# 0
C291 a_2387_4399# a_2291_4399# 0.01379f
C292 a_2233_7905# VPWR 0.22404f
C293 a_2921_6397# a_2659_6409# 0.00171f
C294 _49_.Y u_loop.u_gh.C 0.08128f
C295 _55_.CLK a_6798_4399# 0
C296 _38_.X VPWR 0.38954f
C297 a_5541_9673# VPWR 0
C298 _55_.CLK a_6553_4399# 0
C299 a_7631_6335# _32_.A 0.16439f
C300 a_3215_8585# u_loop.u_gh.C 0.00246f
C301 a_6435_8751# _55_.RESET_B 0
C302 a_4910_2197# prenh 0.11078f
C303 a_5911_2767# a_5569_2767# 0.00188f
C304 a_7553_7125# a_8583_6031# 0
C305 a_2769_8213# _63_.CLK 0
C306 a_6891_6409# _32_.A 0.03899f
C307 a_7553_7125# _67_.Q 0
C308 _56_.Q _34_.X 0
C309 a_3031_4373# a_2856_4399# 0.23366f
C310 u_loop.u_q.Y a_5069_2767# 0.00317f
C311 a_2877_6005# a_2921_6397# 0
C312 a_2877_6005# a_3333_6409# 0
C313 a_3337_8181# a_3227_8207# 0.09774f
C314 a_2755_6409# a_2659_6409# 0.01379f
C315 a_8911_8207# VPWR 0.24438f
C316 _38_.X _30_.A 0
C317 a_2564_6397# a_2659_6409# 0.04983f
C318 output7.A a_5036_2381# 0.0013f
C319 a_6541_6037# _55_.RESET_B 0.05143f
C320 a_2309_6037# a_3333_6409# 0
C321 VPWR _35_.B 2.18867f
C322 VPWR a_5649_5737# 0.00739f
C323 a_2452_6575# _35_.B 0.00167f
C324 a_6375_6037# _32_.Y 0.2749f
C325 _22_.Y a_7061_7663# 0
C326 a_4076_3561# a_5036_2381# 0
C327 a_2509_4641# a_2553_4399# 0
C328 a_2877_6005# a_2755_6409# 0
C329 a_6339_8751# a_6601_8751# 0.00171f
C330 a_2233_7905# a_2235_6575# 0
C331 u_loop.u_d2.X a_3361_2767# 0.37578f
C332 a_2755_6409# a_2309_6037# 0
C333 _57_.CLK a_6796_6397# 0.0017f
C334 _34_.X _28_.A 0
C335 _30_.A _35_.B 0.00163f
C336 u_loop.u_d5.X VPWR 0.24842f
C337 a_5389_5737# VPWR 0.00749f
C338 _46_.A _46_.Y 0.25496f
C339 a_2564_6397# a_2309_6037# 0.05884f
C340 a_5691_3829# _56_.D 0.00945f
C341 a_3337_8181# VPWR 0.21034f
C342 a_2196_4399# _23_.A 0
C343 _68_.Q a_8800_8207# 0.01024f
C344 a_2143_7119# _34_.X 0
C345 output6.A a_4439_2767# 0.0029f
C346 a_2934_7663# a_2755_7637# 0.0074f
C347 a_2233_7905# a_2580_7663# 0.05116f
C348 a_2767_6031# a_2143_6037# 0
C349 _55_.CLK _55_.D 0.02502f
C350 _20_.A a_2309_6037# 0
C351 a_2399_4765# a_2291_4399# 0.05722f
C352 a_2235_6575# _35_.B 0.00294f
C353 a_5276_2197# a_4910_2197# 0
C354 a_7903_5321# a_7907_4159# 0.00173f
C355 a_7553_7125# _67_.D 0
C356 a_2769_8213# _40_.B 0.02685f
C357 a_3196_6733# _28_.A 0
C358 _55_.CLK a_6141_4399# 0
C359 _47_.Y _48_.Y 0
C360 a_6449_7663# _57_.CLK 0
C361 a_2196_4399# a_2291_4399# 0.04983f
C362 _30_.Y _40_.B 0.01255f
C363 a_4975_9295# VPWR 0.14356f
C364 a_7109_6005# _32_.A 0.02288f
C365 a_5691_3829# u_loop.u_gh.B 0
C366 a_7732_4233# a_8121_4917# 0
C367 _67_.D a_7715_6575# 0
C368 a_2291_4399# a_2856_4399# 0
C369 a_5190_5487# VPWR 0.58099f
C370 a_3684_8585# a_4075_6825# 0
C371 _55_.CLK a_5975_4399# 0.00107f
C372 a_7429_4221# _42_.Y 0
C373 a_8121_4917# a_7907_4159# 0
C374 a_2689_7663# a_2580_7663# 0.00742f
C375 _45_.A a_7473_7663# 0
C376 a_7553_7125# a_8468_7497# 0.12532f
C377 a_6447_9117# a_5823_8751# 0
C378 a_4975_9295# _30_.A 0
C379 a_6449_7663# a_6704_7663# 0.06418f
C380 a_2767_6031# _52_.Y 0.0028f
C381 _42_.Y a_7263_4233# 0
C382 a_7732_4233# a_7553_4949# 0
C383 _55_.CLK a_6606_4765# 0
C384 a_7364_7663# VPWR 0.29912f
C385 a_3044_9411# u_loop.u_gh.C 0.08657f
C386 a_3044_9411# a_2766_9427# 0.11876f
C387 a_7553_4949# a_7907_4159# 0
C388 _56_.D _55_.D 0
C389 a_7604_6575# _67_.D 0
C390 _23_.A a_3031_4373# 0
C391 a_2563_6575# _28_.A 0
C392 a_2143_6037# a_3333_6409# 0
C393 a_7551_5853# _67_.Q 0
C394 _67_.D a_7387_6575# 0
C395 _30_.Y _39_.B2 0
C396 a_7732_4233# a_7387_4949# 0
C397 a_3348_7235# a_2603_8213# 0.00109f
C398 a_5786_9661# a_5607_9599# 0.0074f
C399 a_2509_4641# a_2387_4399# 0
C400 a_7732_4233# _25_.Y 0
C401 _45_.A a_5823_8751# 0
C402 a_5989_8751# a_7013_8751# 0
C403 a_3846_8207# u_loop.u_gh.C 0
C404 a_5649_7119# _35_.A_N 0
C405 a_2509_4641# a_3018_4765# 0
C406 _25_.A VPWR 0.82563f
C407 a_7553_7125# a_7808_7485# 0.06418f
C408 a_7553_4949# a_7167_4233# 0
C409 a_6375_6037# u_loop.u_gh.C 0
C410 _45_.A a_7539_7637# 0.14808f
C411 a_7907_4159# _25_.Y 0
C412 a_4333_2767# VPWR 0.2974f
C413 a_1499_6575# a_1407_7119# 0
C414 a_5432_9673# _21_.Y 0.0021f
C415 a_2755_6409# a_2143_6037# 0.00188f
C416 a_2143_6037# a_2360_7119# 0
C417 _56_.Q VPWR 1.36452f
C418 a_2564_6397# a_2143_6037# 0.09313f
C419 a_4867_9673# a_4351_9301# 0.10421f
C420 _21_.Y a_5085_9269# 0.04308f
C421 a_7387_4949# a_7167_4233# 0
C422 _32_.A _32_.Y 0.27031f
C423 a_7167_4233# _25_.Y 0
C424 en src[1] 0.00107f
C425 a_2123_8029# a_2015_7663# 0.05722f
C426 a_7364_7663# a_7017_7905# 0.05116f
C427 _20_.A a_2143_6037# 0.10657f
C428 a_1941_4399# a_2387_4399# 0
C429 VPWR a_7526_8029# 0
C430 a_1941_4399# a_3018_4765# 0
C431 _46_.A _21_.Y 0
C432 VPWR _28_.A 0.63887f
C433 a_2603_8213# a_3070_6549# 0
C434 _67__13.LO VPWR 0.42806f
C435 _32_.A a_6375_6037# 0.345f
C436 a_2452_6575# _28_.A 0
C437 a_6541_6037# a_7443_5487# 0
C438 a_5363_4399# u_loop.u_d0.A 0
C439 u_loop.u_gl.A2 u_loop.u_d0.A 0.54185f
C440 _52_.Y a_2360_7119# 0
C441 a_7604_6575# a_7808_7485# 0
C442 a_4075_6825# a_4032_7351# 0
C443 _52_.Y a_2564_6397# 0.01913f
C444 _42_.Y a_7167_4233# 0
C445 a_2143_7119# VPWR 0.27686f
C446 a_4867_9673# a_4772_9661# 0.04983f
C447 input5.X a_5036_2381# 0.00106f
C448 _23_.A a_3024_8573# 0.01736f
C449 a_6895_7663# a_6799_7663# 0.01379f
C450 _23_.A a_2291_4399# 0
C451 a_2509_4641# a_2399_4765# 0.09774f
C452 u_loop.u_d6.X a_6397_2767# 0.29452f
C453 _20_.A _52_.Y 0.0979f
C454 a_6541_6037# a_7093_5487# 0.00195f
C455 _67_.D _34_.X 0
C456 _20_.A a_1735_6031# 0.10772f
C457 src[0] src[1] 0.37063f
C458 a_1624_6031# _20_.A 0.011f
C459 _23_.A _35_.A_N 0.04249f
C460 a_3119_8585# a_2769_8213# 0.21772f
C461 a_2509_4641# a_2856_4399# 0.05116f
C462 _63_.D _63_.Q 0.10484f
C463 _53_.A u_loop.u_gl.A2 0.00164f
C464 a_2235_6575# _28_.A 0
C465 a_2603_8213# a_2563_6575# 0
C466 a_2387_4399# a_1775_4399# 0
C467 a_2479_9269# _63_.Q 0
C468 _53_.A a_2553_4399# 0.00281f
C469 a_6799_7663# _46_.Y 0
C470 a_7017_7905# a_7526_8029# 0
C471 a_2766_9427# u_loop.u_gh.C 0.23829f
C472 a_2143_7119# a_2235_6575# 0
C473 u_loop.u_d3.X u_loop.u_d1.X 0
C474 a_2625_2767# a_2533_2223# 0.00377f
C475 a_7387_4949# a_7385_3829# 0
C476 a_7385_3829# _25_.Y 0
C477 a_1941_4399# a_2399_4765# 0.03462f
C478 a_3227_8207# a_2603_8213# 0
C479 a_1407_6031# _20_.A 0.00134f
C480 u_loop.u_d1.X a_2533_2223# 0.0136f
C481 a_2196_4399# a_1941_4399# 0.06418f
C482 a_1499_6575# _35_.B 0.08797f
C483 a_5363_4399# _41_.B1 0
C484 prenl a_2875_2223# 0
C485 a_1941_4399# a_2856_4399# 0.12532f
C486 a_3549_9661# a_3802_9295# 0
C487 en _63_.CLK 0
C488 _23_.A _41_.C1 0.0642f
C489 prenh u_loop.u_d0.A 0.00108f
C490 _63_.D a_1665_7663# 0.23772f
C491 a_1499_7663# a_2015_7663# 0.11535f
C492 a_8911_6031# VPWR 0.24433f
C493 _42_.Y a_7385_3829# 0.00121f
C494 _32_.A u_loop.u_gh.C 0
C495 a_4833_2767# a_5175_2767# 0.00188f
C496 a_6541_6037# a_6927_5487# 0.001f
C497 _55_.CLK a_5987_4765# 0.00327f
C498 a_2603_8213# VPWR 0.46112f
C499 a_8800_6031# VPWR 0.24749f
C500 a_2603_8213# a_2452_6575# 0
C501 _36_.A _40_.B 0
C502 _21_.Y a_4517_9301# 0.61967f
C503 VPWR _67_.Q 0.43614f
C504 VPWR a_8583_6031# 0.25918f
C505 _34_.B1 _35_.B 0.10546f
C506 a_5547_2223# u_loop.u_d0.A 0
C507 _30_.Y a_3384_9295# 0
C508 xb VPWR 0.44677f
C509 a_6541_6037# _41_.X 0
C510 a_4167_6147# u_loop.u_gh.C 0.00157f
C511 a_3224_6409# u_loop.u_gh.C 0.2562f
C512 a_2399_4765# a_1775_4399# 0
C513 a_2603_8213# _30_.A 0
C514 a_2196_4399# a_1775_4399# 0.09313f
C515 _41_.C1 _35_.A_N 0.49811f
C516 src[0] _63_.CLK 0
C517 a_4975_9295# _48_.Y 0.00108f
C518 _22_.Y a_6447_9117# 0
C519 _45_.A a_7061_7663# 0.00216f
C520 a_1775_4399# a_2856_4399# 0.10236f
C521 _45_.A a_5649_7119# 0
C522 a_7456_6409# _57_.CLK 0
C523 _53_.A a_2387_4399# 0.00537f
C524 a_7553_4949# a_6817_3861# 0
C525 _22_.Y a_5377_7439# 0
C526 a_5823_8751# a_6557_8993# 0.07009f
C527 a_3399_6335# u_loop.u_gh.C 0.29247f
C528 a_3031_4373# a_1941_4399# 0.04251f
C529 a_5276_2197# u_loop.u_d0.A 0
C530 _23_.A a_2509_4641# 0
C531 VPWR a_5069_2767# 0.2948f
C532 _36_.A _39_.B2 0.09108f
C533 u_loop.u_qb.A _55_.RESET_B 0
C534 _56_.D a_5987_4765# 0
C535 a_7387_4949# a_6817_3861# 0
C536 a_6817_3861# _25_.Y 0
C537 _55_.CLK a_5784_4399# 0.00167f
C538 a_2603_8213# a_2580_7663# 0
C539 _67_.D VPWR 0.65502f
C540 a_3031_4373# a_2859_4943# 0
C541 a_5989_8751# a_7066_9117# 0
C542 a_1499_7663# _34_.X 0
C543 _45_.A _22_.Y 0.41396f
C544 _63_.Q a_2755_7637# 0.13591f
C545 a_6397_2767# a_6444_4399# 0
C546 _23_.Y a_2015_7663# 0
C547 VPWR a_6999_6031# 0.14236f
C548 a_2509_4641# a_2291_4399# 0.20964f
C549 a_6339_8751# _39_.B2 0
C550 a_4167_6147# a_3224_6409# 0
C551 a_2801_9661# u_loop.u_gh.C 0.00288f
C552 _20_.A a_1654_6575# 0
C553 a_4038_8573# _35_.B 0
C554 a_2196_4399# u_loop.u_d0.A 0.00188f
C555 a_2196_4399# _27_.Y 0.1576f
C556 u_loop.u_gh.C a_2659_6409# 0.15874f
C557 _42_.Y a_6817_3861# 0
C558 a_7631_6335# _57_.CLK 0
C559 _23_.A a_1941_4399# 0
C560 a_8468_7497# VPWR 0.30224f
C561 a_2856_4399# u_loop.u_d0.A 0
C562 a_6891_6409# _57_.CLK 0.00111f
C563 a_2123_8029# VPWR 0.15154f
C564 a_6907_8029# VPWR 0.14233f
C565 a_5879_4399# a_6397_2767# 0
C566 a_5569_2767# VPWR 0.28154f
C567 a_3031_4373# a_1775_4399# 0.04357f
C568 a_2877_6005# u_loop.u_gh.C 0.17157f
C569 a_6449_7663# a_7387_6575# 0
C570 a_4167_6147# a_3399_6335# 0.00364f
C571 _53_.A a_2399_4765# 0
C572 a_3399_6335# a_3224_6409# 0.23366f
C573 a_2309_6037# u_loop.u_gh.C 0.03411f
C574 a_3337_8181# a_3170_9295# 0
C575 _36_.A a_3316_5321# 0
C576 a_2755_7637# a_1665_7663# 0.04251f
C577 _30_.Y a_4351_9301# 0
C578 a_1941_4399# a_2291_4399# 0.2298f
C579 output6.A a_5036_2381# 0.01024f
C580 _56_.D a_5784_4399# 0.15913f
C581 a_2015_7663# a_2471_7119# 0
C582 en a_1735_7119# 0
C583 a_2196_4399# _53_.A 0.00187f
C584 a_1499_6575# _28_.A 0.0015f
C585 a_5190_7439# _40_.B 0
C586 _53_.A a_2856_4399# 0.04062f
C587 a_6397_2767# a_5529_4399# 0
C588 a_7808_7485# VPWR 0.08228f
C589 a_7808_5309# _55_.Q 0
C590 a_1499_6575# a_2143_7119# 0
C591 a_7553_4949# a_6651_3861# 0
C592 _35_.A_N a_5377_7439# 0
C593 a_2123_8029# a_2235_6575# 0
C594 a_4097_2767# u_loop.u_d0.A 0
C595 a_1499_7663# a_2563_6575# 0
C596 a_7364_7663# a_6541_6037# 0
C597 _23_.A a_1775_4399# 0
C598 a_3684_8585# a_3348_7235# 0
C599 a_5784_4399# u_loop.u_gh.B 0
C600 a_6907_8029# a_7017_7905# 0.09774f
C601 a_3224_6409# a_2659_6409# 0
C602 _23_.Y _34_.X 0
C603 _36_.A a_3491_5247# 0
C604 _30_.Y a_4772_9661# 0
C605 a_3031_4373# u_loop.u_d0.A 0
C606 a_2533_2223# a_2769_2223# 0.22264f
C607 a_7387_4949# a_6651_3861# 0
C608 _25_.Y a_6651_3861# 0
C609 _34_.B1 _28_.A 0
C610 a_7109_6005# _57_.CLK 0
C611 en pre 0.34496f
C612 _45_.A _35_.A_N 0
C613 a_3684_8585# _34_.X 0
C614 a_3684_8585# a_4160_6575# 0
C615 _68_.Q a_8822_7485# 0.00233f
C616 a_6541_6037# _25_.A 0
C617 src[0] a_1735_7119# 0.07402f
C618 a_5190_7439# _39_.B2 0.0872f
C619 _31_.Y VPWR 0.57374f
C620 a_2877_6005# a_3224_6409# 0.05116f
C621 _34_.B1 a_2143_7119# 0
C622 a_1775_4399# a_2291_4399# 0.11322f
C623 a_4167_6147# a_2309_6037# 0
C624 a_3224_6409# a_2309_6037# 0.12532f
C625 a_3348_7235# a_2471_7119# 0
C626 a_6541_6037# _56_.Q 0
C627 VPWR a_3386_6031# 0
C628 _42_.Y a_6651_3861# 0
C629 _41_.C1 a_5377_7439# 0
C630 _31_.Y _30_.A 0
C631 a_4833_2767# u_loop.u_d4.X 0.37578f
C632 u_loop.u_d1.X a_4333_2767# 0
C633 a_6449_7663# _34_.X 0
C634 _53_.A a_3031_4373# 0.15796f
C635 a_6799_7663# _68_.D 0
C636 a_1499_7663# VPWR 0.48419f
C637 a_4292_2223# u_loop.u_gh.C 0
C638 _34_.X a_2471_7119# 0
C639 a_1499_7663# a_2452_6575# 0
C640 a_5363_4399# a_6397_2767# 0
C641 VPWR xa 0.54594f
C642 a_3399_6335# a_2309_6037# 0.04251f
C643 en a_1624_7119# 0
C644 a_2143_6037# u_loop.u_gh.C 0.30932f
C645 pre src[0] 0.16978f
C646 a_6541_6037# _67__13.LO 0
C647 a_3992_7235# a_4369_6351# 0
C648 _45_.A _41_.C1 0
C649 _22_.Y _41_.B1 0
C650 VPWR a_2875_2223# 0.18636f
C651 a_2401_4949# _36_.A 0
C652 output7.A u_loop.u_d3.X 0.03857f
C653 a_4403_2223# prenh 0.0026f
C654 _23_.Y a_2563_6575# 0
C655 _50_.Y _62_.D 0.00218f
C656 u_loop.u_q.B u_loop.u_d5.X 0.00124f
C657 _55_.RESET_B a_7894_3855# 0
C658 a_2291_4399# u_loop.u_d0.A 0
C659 a_3684_8585# a_3992_7235# 0
C660 _27_.Y a_2291_4399# 0
C661 output7.A a_2533_2223# 0
C662 _23_.A _53_.A 0
C663 _57_.CLK _32_.Y 0.0689f
C664 a_2877_6005# a_2659_6409# 0.20964f
C665 _55_.RESET_B a_7275_3855# 0.0122f
C666 _55_.D _25_.Y 0.00124f
C667 a_1499_7663# a_2235_6575# 0
C668 a_2509_4641# a_1941_4399# 0.18639f
C669 a_2309_6037# a_2659_6409# 0.2298f
C670 _52_.Y u_loop.u_gh.C 0.00129f
C671 src[0] a_1624_7119# 0.05635f
C672 a_8086_4221# _55_.RESET_B 0.00305f
C673 a_1735_6031# u_loop.u_gh.C 0
C674 _22_.Y a_6557_8993# 0
C675 a_1624_6031# u_loop.u_gh.C 0
C676 a_6375_6037# _57_.CLK 0.26807f
C677 _34_.B1 a_2603_8213# 0
C678 a_1499_7663# a_2580_7663# 0.10236f
C679 a_6704_7663# _32_.Y 0
C680 a_7387_7125# a_7553_7125# 0.90207f
C681 _20_.A a_1845_6825# 0
C682 _53_.A a_2291_4399# 0.02735f
C683 a_2877_6005# a_2309_6037# 0.18639f
C684 _63_.D a_2233_7905# 0
C685 _55_.D _42_.Y 0.05292f
C686 _23_.A _41_.B1 0
C687 a_8643_7423# _39_.X 0
C688 a_4160_6575# a_4032_7351# 0
C689 a_4032_7351# _34_.X 0
C690 a_1920_7663# _63_.CLK 0.01576f
C691 a_2233_7905# a_2479_9269# 0
C692 a_2563_6575# a_2471_7119# 0
C693 a_3224_6409# a_2143_6037# 0.10232f
C694 a_7387_7125# a_7715_6575# 0.00194f
C695 a_7841_4233# _55_.RESET_B 0
C696 a_4167_6147# a_2143_6037# 0
C697 a_4369_6351# VPWR 0.00339f
C698 _36_.A a_2235_4949# 0
C699 a_5786_9661# u_loop.u_gh.C 0.00288f
C700 a_4510_3311# a_4333_2767# 0.00116f
C701 _23_.Y VPWR 0.66183f
C702 a_5432_9673# a_5823_8751# 0.00118f
C703 u_loop.u_d3.X a_4075_2223# 0
C704 _23_.Y a_2452_6575# 0.00253f
C705 a_7553_7125# a_7456_6409# 0
C706 a_4833_2767# u_loop.u_gh.B 0
C707 a_1407_6031# u_loop.u_gh.C 0
C708 VPWR a_6796_6397# 0.08336f
C709 a_8630_7119# _67_.Q 0
C710 _63_.D _35_.B 0.00494f
C711 a_3684_8585# VPWR 0.29437f
C712 en _28_.Y 0
C713 a_7456_6409# a_7715_6575# 0
C714 a_6541_6037# a_8911_6031# 0
C715 a_2509_4641# a_1775_4399# 0.07009f
C716 a_3399_6335# a_2143_6037# 0.04348f
C717 a_1941_4399# a_2859_4943# 0
C718 u_loop.u_d7.X a_6633_2767# 0.01141f
C719 a_7387_7125# a_7604_6575# 0
C720 a_6541_6037# a_8800_6031# 0
C721 _52_.Y a_3224_6409# 0
C722 _35_.A_N _41_.B1 0.02528f
C723 a_7387_7125# a_7387_6575# 0.00221f
C724 a_5823_8751# _46_.A 0.09691f
C725 a_2015_7663# a_2360_7119# 0.00449f
C726 a_3684_8585# _30_.A 0.00555f
C727 en a_2235_4949# 0
C728 a_6541_6037# _67_.Q 0
C729 _45_.A a_5377_7439# 0.02146f
C730 a_6541_6037# a_8583_6031# 0
C731 _55_.CLK a_6619_4373# 0.01374f
C732 a_2603_8213# a_3083_9537# 0
C733 a_6449_7663# VPWR 0.59732f
C734 _55_.CLK a_6444_4399# 0.02152f
C735 a_3514_7235# u_loop.u_gh.C 0
C736 a_6541_6037# xb 0
C737 _23_.Y a_2235_6575# 0.00358f
C738 a_2861_2767# a_2856_4399# 0
C739 a_2471_7119# VPWR 0.22546f
C740 a_7539_7637# _46_.A 0
C741 _36_.A _39_.X 0.01059f
C742 a_2452_6575# a_2471_7119# 0.00119f
C743 a_3992_7235# a_4032_7351# 0.16753f
C744 x u_loop.u_d5.X 0.00542f
C745 a_7553_7125# a_7631_6335# 0
C746 a_7604_6575# a_7456_6409# 0
C747 a_2603_8213# a_3170_9295# 0
C748 a_7718_7663# a_7539_7637# 0.0074f
C749 a_7456_6409# a_7387_6575# 0
C750 _52_.Y a_3399_6335# 0
C751 a_1941_4399# a_1775_4399# 0.90159f
C752 _57_.CLK u_loop.u_gh.C 0
C753 a_2143_6037# a_2659_6409# 0.11535f
C754 a_5879_4399# _55_.CLK 0.00843f
C755 en _53_.Y 0
C756 a_7631_6335# a_7715_6575# 0.00206f
C757 a_2111_7663# a_1665_7663# 0
C758 a_2509_4641# u_loop.u_d0.A 0
C759 a_7429_4221# _55_.RESET_B 0.00392f
C760 output6.A a_5377_5487# 0
C761 _41_.C1 _41_.B1 0.08582f
C762 a_2877_6005# a_2143_6037# 0.06944f
C763 a_1775_4399# a_2859_4943# 0
C764 output7.A u_loop.u_d5.X 0
C765 a_2143_6037# a_2309_6037# 0.88759f
C766 _63_.Q a_2769_8213# 0.04353f
C767 a_1941_4399# a_2967_2767# 0
C768 _55_.RESET_B a_7263_4233# 0.00493f
C769 a_8468_7497# a_8630_7119# 0.00645f
C770 a_7072_4221# _55_.RESET_B 0.00283f
C771 _56_.D a_6619_4373# 0
C772 a_3348_7235# a_2360_7119# 0
C773 _56_.D a_6444_4399# 0
C774 a_6541_6037# _67_.D 0.26383f
C775 _55_.CLK a_6097_4641# 0.01579f
C776 a_6449_7663# a_7017_7905# 0.18639f
C777 a_4075_6825# u_loop.u_gh.C 0
C778 _55_.CLK a_5529_4399# 0.04397f
C779 a_5175_2767# a_5276_2197# 0
C780 a_6541_6037# a_6999_6031# 0.03462f
C781 _52_.Y a_2659_6409# 0.01194f
C782 _32_.A _57_.CLK 0.17065f
C783 a_8011_7119# a_8121_7093# 0.09774f
C784 a_7604_6575# a_7631_6335# 0.00392f
C785 a_3703_2767# u_loop.u_d0.X 0
C786 a_3031_4373# a_2861_2767# 0
C787 _46_.Y _39_.B2 0.00256f
C788 _53_.A a_2509_4641# 0.02347f
C789 a_2580_7663# a_2471_7119# 0
C790 a_6891_6409# a_7387_6575# 0
C791 _34_.X a_2360_7119# 0
C792 a_4032_7351# VPWR 0.23827f
C793 a_5879_4399# _56_.D 0.00103f
C794 _48_.Y _31_.Y 0
C795 a_1941_4399# u_loop.u_d0.A 0.0032f
C796 a_5293_5487# output6.A 0
C797 a_2877_6005# _52_.Y 0.00138f
C798 a_7387_7125# _34_.X 0
C799 a_1654_6575# u_loop.u_gh.C 0
C800 _27_.Y a_1941_4399# 0.23405f
C801 a_1920_7663# a_1735_7119# 0
C802 a_6541_6037# a_6907_8029# 0
C803 _52_.Y a_2309_6037# 0.21017f
C804 a_4032_7351# _30_.A 0
C805 a_2755_7637# _35_.B 0
C806 a_1499_6575# a_1499_7663# 0.00136f
C807 a_7732_4233# _55_.RESET_B 0.23801f
C808 a_6397_2767# a_6739_2767# 0.00188f
C809 a_1775_4399# a_2967_2767# 0
C810 a_7456_6409# _34_.X 0
C811 a_6097_4641# _56_.D 0.00136f
C812 _55_.RESET_B a_7907_4159# 0.27977f
C813 a_5879_4399# u_loop.u_gh.B 0
C814 a_6541_6037# a_7565_6409# 0
C815 a_5607_9599# VPWR 0.48019f
C816 _53_.A a_1941_4399# 0.01612f
C817 a_5293_7439# VPWR 0.00371f
C818 _56_.D a_5529_4399# 0.27254f
C819 u_loop.u_d4.X u_loop.u_gl.A2 0.00355f
C820 u_loop.u_cmp.Y _56_.CLK 0
C821 a_2767_6031# VPWR 0.14213f
C822 a_6904_8751# a_5823_8751# 0.10236f
C823 a_4167_6147# a_4075_6825# 0
C824 a_5190_7439# _39_.X 0.15437f
C825 a_7631_6335# a_7551_5853# 0
C826 _55_.CLK a_5363_4399# 0.03468f
C827 _55_.CLK u_loop.u_gl.A2 0.01068f
C828 a_1775_4399# u_loop.u_d0.A 0.2685f
C829 a_6244_8751# a_6339_8751# 0.04983f
C830 a_1499_7663# _34_.B1 0
C831 _55_.RESET_B a_7167_4233# 0.17996f
C832 _27_.Y a_1775_4399# 0.2888f
C833 output7.A a_4333_2767# 0.02565f
C834 input5.X _56_.CLK 0
C835 a_5129_9661# u_loop.u_gh.C 0.00316f
C836 a_6097_4641# u_loop.u_gh.B 0
C837 a_4076_3561# a_4333_2767# 0
C838 u_loop.u_gh.B a_5529_4399# 0.00116f
C839 a_4963_9673# u_loop.u_gh.C 0.0031f
C840 _41_.B1 a_5377_7439# 0.01938f
C841 a_2563_6575# a_2360_7119# 0
C842 _40_.B _21_.Y 0
C843 a_2967_2767# u_loop.u_d0.A 0
C844 a_6891_6409# _34_.X 0.00133f
C845 a_7553_7125# _68_.Q 0.00296f
C846 _53_.A a_1775_4399# 0.03756f
C847 _45_.A _41_.B1 0
C848 a_6799_7663# a_5823_8751# 0
C849 a_4403_2223# a_4910_2197# 0.01384f
C850 u_loop.u_d3.X a_3361_2767# 0
C851 _23_.A _50_.Y 0.17542f
C852 a_3044_9411# a_3802_9295# 0.05936f
C853 a_6447_9117# a_6557_8993# 0.09774f
C854 _56_.D u_loop.u_gl.A2 0
C855 _56_.D a_5363_4399# 0.17345f
C856 _52_.Y a_2143_6037# 0.30446f
C857 u_loop.u_cmp.Y u_loop.u_d5.X 0.00168f
C858 a_2143_6037# a_1735_6031# 0.00111f
C859 _27_.Y u_loop.u_d0.A 0.08158f
C860 a_1624_6031# a_2143_6037# 0
C861 u_loop.u_d4.X prenh 0.00159f
C862 a_8583_8207# VPWR 0.35414f
C863 _21_.Y _39_.B2 0.22666f
C864 a_5569_2767# a_5764_2223# 0.00184f
C865 a_3793_8585# _40_.B 0
C866 _50_.Y a_3024_8573# 0
C867 a_2360_7119# VPWR 0.23579f
C868 a_2564_6397# VPWR 0.07883f
C869 u_loop.u_d5.X input5.X 0.03897f
C870 a_2452_6575# a_2360_7119# 0.00303f
C871 a_2564_6397# a_2452_6575# 0
C872 _22_.Y _46_.A 0.00806f
C873 a_7387_7125# VPWR 0.47254f
C874 _55_.RESET_B a_7385_3829# 0.16841f
C875 a_5363_4399# u_loop.u_gh.B 0.0069f
C876 u_loop.u_gh.B u_loop.u_gl.A2 0.35695f
C877 a_4867_9673# a_4975_9295# 0.05722f
C878 _34_.B1 _23_.Y 0
C879 _63_.D a_2603_8213# 0
C880 a_5784_4399# _42_.Y 0
C881 _22_.Y a_7718_7663# 0
C882 u_loop.u_d1.X a_2875_2223# 0.1316f
C883 a_5911_2767# u_loop.u_d7.X 0
C884 _20_.A VPWR 0.72095f
C885 _53_.A u_loop.u_d0.A 0.35448f
C886 a_2603_8213# a_2479_9269# 0
C887 a_1407_6031# a_2143_6037# 0
C888 _27_.Y _53_.A 0.16552f
C889 a_7109_6005# _34_.X 0
C890 _55_.Q a_7903_5321# 0
C891 _52_.Y a_1735_6031# 0.02406f
C892 a_1624_6031# _52_.Y 0.00346f
C893 u_loop.u_q.B a_5569_2767# 0.00434f
C894 a_8643_7423# _55_.RESET_B 0.2741f
C895 a_7456_6409# VPWR 0.29547f
C896 a_1624_6031# a_1735_6031# 0.34134f
C897 _39_.X a_8121_7093# 0
C898 a_6375_6037# a_7387_6575# 0.00875f
C899 u_loop.u_q.Y u_loop.u_gh.C 0
C900 a_4518_6825# _38_.X 0
C901 a_2235_6575# a_2360_7119# 0.00288f
C902 a_3549_9661# a_3170_9295# 0
C903 a_3992_7235# _49_.Y 0
C904 _55_.Q a_8121_4917# 0
C905 _36_.A a_5377_5487# 0.05841f
C906 a_7732_4233# a_7443_5487# 0
C907 u_loop.u_gh.C a_1582_6575# 0
C908 u_loop.u_d3.X output6.A 0
C909 _34_.B1 a_2471_7119# 0
C910 a_1407_6031# _52_.Y 0.0011f
C911 a_2580_7663# a_2360_7119# 0
C912 a_4518_6825# _35_.B 0.04295f
C913 a_1407_6031# a_1735_6031# 0
C914 a_1407_6031# a_1624_6031# 0.11296f
C915 _23_.A _20_.Y 0.00106f
C916 u_loop.u_gl.B1 u_loop.u_d3.X 0.00784f
C917 _55_.Q a_7553_4949# 0
C918 a_3477_9661# a_3170_9295# 0
C919 a_6283_7663# a_6339_8751# 0
C920 u_loop.u_q.Y _32_.A 0
C921 a_6541_6037# a_6796_6397# 0.06418f
C922 u_loop.u_q.Y u_loop.u_d7.X 0.08019f
C923 a_7631_6335# VPWR 0.42027f
C924 a_3388_7351# a_2769_8213# 0
C925 _56_.Q u_loop.u_cmp.Y 0
C926 a_7167_4233# a_7443_5487# 0
C927 u_loop.u_gh.B prenh 0
C928 a_6891_6409# VPWR 0.20283f
C929 a_3802_9295# u_loop.u_gh.C 0.02003f
C930 a_5293_5487# _36_.A 0.00296f
C931 _55_.Q a_7387_4949# 0.00211f
C932 a_3684_8585# a_3083_9537# 0
C933 _55_.Q _25_.Y 0.10504f
C934 a_3041_9661# a_3083_9537# 0
C935 a_7072_4221# a_6927_5487# 0
C936 a_2233_7905# a_2111_7663# 0
C937 _34_.X _32_.Y 0
C938 prenl u_loop.u_gh.C 0
C939 _55_.RESET_B a_6817_3861# 0.04492f
C940 a_6449_7663# a_6541_6037# 0
C941 a_1941_4399# a_2861_2767# 0
C942 a_7553_7125# _32_.A 0
C943 a_7167_4233# a_7093_5487# 0
C944 output7.A a_5069_2767# 0.00337f
C945 a_3041_9661# a_3170_9295# 0
C946 a_6339_8751# _55_.RESET_B 0.15325f
C947 _49_.Y VPWR 0.75847f
C948 _20_.Y _35_.A_N 0
C949 _55_.Q _42_.Y 0.28592f
C950 a_7604_6575# u_loop.u_gh.C 0
C951 a_6375_6037# _34_.X 0
C952 a_2015_7663# u_loop.u_gh.C 0.15386f
C953 output6.A _56_.CLK 0
C954 x a_5569_2767# 0.00102f
C955 en a_1665_7663# 0
C956 _49_.Y _30_.A 0.23153f
C957 src[0] _63_.Q 0.00158f
C958 _56_.CLK a_4769_4175# 0
C959 a_7732_4233# a_6927_5487# 0
C960 a_2603_8213# a_2755_7637# 0.01098f
C961 a_6891_6409# a_7017_7905# 0
C962 _39_.X _46_.Y 0
C963 a_8643_7423# a_8183_5461# 0
C964 a_4097_2767# u_loop.u_d4.X 0
C965 a_6927_5487# a_7907_4159# 0
C966 a_6799_7663# a_7061_7663# 0.00171f
C967 a_4074_7235# _35_.A_N 0.00145f
C968 a_7109_6005# VPWR 0.2232f
C969 a_7604_6575# _32_.A 0
C970 a_1775_4399# a_2861_2767# 0
C971 a_7079_8725# a_7258_8751# 0.0074f
C972 _32_.A a_7387_6575# 0
C973 a_2769_8213# _38_.X 0
C974 a_6927_5487# a_7167_4233# 0
C975 a_1624_6031# a_1654_6575# 0
C976 src[0] a_1665_7663# 0
C977 a_6799_7663# _22_.Y 0.00161f
C978 a_2861_2767# a_2967_2767# 0.41909f
C979 a_3348_7235# u_loop.u_gh.C 0.00483f
C980 a_2769_8213# _35_.B 0
C981 u_loop.u_gh.B a_2856_4399# 0
C982 _41_.C1 a_4074_7235# 0
C983 _55_.RESET_B a_6651_3861# 0.40895f
C984 output6.A u_loop.u_d5.X 0.0462f
C985 a_2875_2223# a_2769_2223# 0.41909f
C986 a_4160_6575# u_loop.u_gh.C 0
C987 _34_.X u_loop.u_gh.C 0.20285f
C988 _63_.D a_1499_7663# 0.19268f
C989 a_3436_6549# u_loop.u_gh.C 0.00234f
C990 a_3337_8181# a_2769_8213# 0.18493f
C991 _68_.D a_8011_7119# 0
C992 a_2861_2767# u_loop.u_d0.A 0.00127f
C993 a_4403_2223# u_loop.u_d0.A 0
C994 _55_.RESET_B a_6798_4399# 0.00288f
C995 a_3044_9411# VPWR 0.27169f
C996 _68_.Q VPWR 0.57872f
C997 u_loop.u_d0.X a_3597_2767# 0
C998 a_6553_4399# _55_.RESET_B 0
C999 VPWR _32_.Y 0.649f
C1000 a_3196_6733# u_loop.u_gh.C 0.01282f
C1001 a_3070_6549# u_loop.u_gh.C 0.11956f
C1002 a_1499_6575# _20_.A 0.00397f
C1003 a_3044_9411# _30_.A 0.5491f
C1004 a_3846_8207# VPWR 0
C1005 a_6244_8751# _46_.Y 0
C1006 a_6619_4373# _25_.Y 0
C1007 _32_.A _34_.X 0
C1008 a_6444_4399# _25_.Y 0
C1009 a_6375_6037# VPWR 0.49273f
C1010 a_6447_9117# _46_.A 0
C1011 _53_.A a_2861_2767# 0
C1012 a_3348_7235# a_3224_6409# 0
C1013 a_3031_4373# u_loop.u_gh.B 0
C1014 a_4351_9301# _21_.Y 0.48959f
C1015 _34_.B1 a_2360_7119# 0
C1016 u_loop.u_d4.X a_4910_2197# 0.00214f
C1017 a_3703_2767# a_3597_2767# 0.41909f
C1018 _36_.A a_7093_5487# 0
C1019 a_3992_7235# u_loop.u_gh.C 0
C1020 a_6619_4373# _42_.Y 0
C1021 a_4167_6147# _34_.X 0
C1022 a_4167_6147# a_4160_6575# 0
C1023 a_2233_7905# a_2277_7663# 0
C1024 a_3224_6409# _34_.X 0.0015f
C1025 input5.X a_5069_2767# 0
C1026 _42_.Y a_6444_4399# 0
C1027 _20_.A _34_.B1 0
C1028 a_3224_6409# a_3436_6549# 0.00121f
C1029 _68_.Q a_7017_7905# 0
C1030 a_8800_8207# VPWR 0.24703f
C1031 output7.A a_2875_2223# 0
C1032 a_3348_7235# a_3399_6335# 0
C1033 _45_.A _46_.A 0.00359f
C1034 _55_.D _55_.RESET_B 0.25991f
C1035 a_2563_6575# u_loop.u_gh.C 0.00458f
C1036 a_6141_4399# _55_.RESET_B 0.00316f
C1037 _45_.A a_7718_7663# 0.00198f
C1038 output6.A a_4333_2767# 0.00324f
C1039 _63_.CLK _62_.D 0
C1040 a_4772_9661# _21_.Y 0.17121f
C1041 a_5879_4399# _42_.Y 0
C1042 _56_.Q output6.A 0
C1043 a_3399_6335# _34_.X 0
C1044 a_3224_6409# a_3196_6733# 0.00104f
C1045 a_6375_6037# a_7017_7905# 0
C1046 _55_.RESET_B a_7258_8751# 0.00231f
C1047 u_loop.u_gl.B1 a_4333_2767# 0.00173f
C1048 a_3399_6335# a_3436_6549# 0.00528f
C1049 _55_.RESET_B a_5975_4399# 0
C1050 _25_.Y a_5529_4399# 0
C1051 a_3227_8207# u_loop.u_gh.C 0.01625f
C1052 u_loop.u_cmp.Y a_5569_2767# 0.00302f
C1053 a_7732_4233# _25_.A 0
C1054 a_8165_7485# a_8121_7093# 0
C1055 a_7387_7125# a_6541_6037# 0
C1056 a_3381_8573# a_3119_8585# 0.00171f
C1057 _55_.RESET_B a_8121_7093# 0.17278f
C1058 _20_.Y a_1775_4399# 0
C1059 a_7907_4159# _25_.A 0.01506f
C1060 _55_.RESET_B a_6606_4765# 0
C1061 input5.X a_5569_2767# 0.0291f
C1062 _23_.A a_3239_9269# 0
C1063 a_6097_4641# _42_.Y 0
C1064 u_loop.u_gl.A2 a_4439_2767# 0
C1065 a_3399_6335# a_3196_6733# 0.0014f
C1066 _42_.Y a_5529_4399# 0
C1067 a_8911_8207# a_8643_7423# 0
C1068 _23_.A a_3859_8511# 0
C1069 _36_.A a_6927_5487# 0
C1070 a_1499_7663# a_2755_7637# 0.04359f
C1071 a_4167_6147# a_3992_7235# 0
C1072 VPWR u_loop.u_gh.C 3.9037f
C1073 _67_.D a_7275_3855# 0
C1074 a_2766_9427# VPWR 0.28327f
C1075 a_2452_6575# u_loop.u_gh.C 0.00228f
C1076 a_6541_6037# a_7456_6409# 0.12532f
C1077 _34_.X a_2659_6409# 0
C1078 _48_.Y _49_.Y 0.31536f
C1079 a_4075_2223# a_2875_2223# 0
C1080 a_7167_4233# _25_.A 0
C1081 a_8011_7119# a_7903_7497# 0.05722f
C1082 prenl a_4292_2223# 0.01818f
C1083 u_loop.u_q.Y a_6633_2767# 0.02505f
C1084 a_3348_7235# a_2309_6037# 0
C1085 _36_.A _56_.CLK 0.00248f
C1086 a_6927_5487# a_6817_3861# 0
C1087 _36_.A _41_.X 0.01061f
C1088 a_6283_7663# a_6895_7663# 0
C1089 _40_.B _62_.D 0.09771f
C1090 _30_.A u_loop.u_gh.C 0.09328f
C1091 a_7443_5487# a_6651_3861# 0
C1092 a_2766_9427# _30_.A 0.0551f
C1093 a_2877_6005# _34_.X 0
C1094 a_5989_8751# VPWR 0.62487f
C1095 a_2309_6037# _34_.X 0
C1096 a_6244_8751# _21_.Y 0
C1097 a_1920_7663# _63_.Q 0
C1098 a_3070_6549# a_2659_6409# 0.00573f
C1099 src[0] a_3388_7351# 0
C1100 _36_.A _38_.X 0
C1101 _32_.A VPWR 0.80436f
C1102 a_5363_4399# _25_.Y 0
C1103 _20_.Y u_loop.u_d0.A 0
C1104 _35_.A_N a_3859_8511# 0
C1105 src[0] a_1407_7119# 0.06977f
C1106 u_loop.u_d7.X VPWR 0.68693f
C1107 a_2235_6575# u_loop.u_gh.C 0.00109f
C1108 a_5989_8751# _30_.A 0
C1109 a_6651_3861# a_7661_5729# 0
C1110 a_6651_3861# a_7093_5487# 0
C1111 a_2015_7663# a_2143_6037# 0
C1112 a_6283_7663# _46_.Y 0.24955f
C1113 _39_.X _68_.D 0.00193f
C1114 a_6541_6037# a_7631_6335# 0.04251f
C1115 a_6541_6037# a_6891_6409# 0.22549f
C1116 _41_.C1 u_loop.u_gh.B 0
C1117 a_6895_7663# _55_.RESET_B 0
C1118 a_2309_6037# a_3196_6733# 0.00672f
C1119 a_3070_6549# a_2309_6037# 0
C1120 _36_.A _35_.B 0.15159f
C1121 a_2580_7663# u_loop.u_gh.C 0.24424f
C1122 _36_.A a_5649_5737# 0.00124f
C1123 a_5363_4399# _42_.Y 0
C1124 a_4167_6147# VPWR 0.22148f
C1125 a_3224_6409# VPWR 0.2973f
C1126 a_2766_9427# a_2580_7663# 0
C1127 a_5823_8751# _39_.B2 0.00538f
C1128 en a_2233_7905# 0
C1129 src[0] a_3430_7235# 0
C1130 a_8008_5487# a_8121_7093# 0
C1131 _53_.A _20_.Y 0
C1132 a_4833_2767# a_5036_2381# 0.00403f
C1133 a_2563_6575# a_2659_6409# 0.00131f
C1134 a_1920_7663# a_1665_7663# 0.06044f
C1135 _36_.A a_5389_5737# 0.0012f
C1136 _41_.C1 a_3859_8511# 0
C1137 _55_.RESET_B _46_.Y 0
C1138 a_7066_9117# VPWR 0
C1139 a_3399_6335# VPWR 0.42656f
C1140 _32_.A a_7017_7905# 0
C1141 _49_.Y a_3083_9537# 0.25296f
C1142 en _35_.B 0.0088f
C1143 a_2603_8213# a_2769_8213# 0.89205f
C1144 a_2563_6575# a_2309_6037# 0
C1145 a_3348_7235# a_2143_6037# 0
C1146 u_loop.u_d5.X a_5805_2767# 0.00315f
C1147 a_6927_5487# a_6651_3861# 0
C1148 a_3170_9295# _49_.Y 0
C1149 a_3044_9411# _48_.Y 0
C1150 a_5190_5487# _36_.A 0.12938f
C1151 _45_.A a_6799_7663# 0.03585f
C1152 src[0] _38_.X 0
C1153 a_7109_6005# a_6541_6037# 0.17749f
C1154 _41_.X a_6651_3861# 0
C1155 a_2143_6037# _34_.X 0
C1156 a_5190_7439# _41_.X 0
C1157 _46_.A a_6557_8993# 0.02549f
C1158 VPWR a_2659_6409# 0.19846f
C1159 _57_.CLK a_7715_6575# 0
C1160 _55_.Q a_8362_5487# 0
C1161 a_5691_3829# _56_.CLK 0
C1162 output6.A a_5069_2767# 0.01894f
C1163 a_2452_6575# a_2659_6409# 0
C1164 src[0] _35_.B 0.31289f
C1165 a_2877_6005# VPWR 0.20517f
C1166 _55_.RESET_B a_5987_4765# 0.0122f
C1167 a_5190_7439# _38_.X 0.11423f
C1168 a_2143_6037# a_3196_6733# 0.00344f
C1169 a_3070_6549# a_2143_6037# 0
C1170 a_2309_6037# VPWR 0.47573f
C1171 a_3119_8585# _62_.D 0.01276f
C1172 a_2452_6575# a_2309_6037# 0
C1173 _36_.A _25_.A 0.08261f
C1174 a_1654_6575# a_1845_6825# 0
C1175 _52_.Y _34_.X 0
C1176 a_1654_6575# a_1582_6575# 0
C1177 a_7604_6575# _57_.CLK 0
C1178 u_loop.u_d4.X u_loop.u_d0.A 0.0038f
C1179 a_7387_6575# _57_.CLK 0
C1180 a_5190_7439# _35_.B 0
C1181 a_2656_5309# a_2291_4399# 0
C1182 _35_.A_N src[1] 0
C1183 _36_.A _56_.Q 0.19404f
C1184 _39_.X a_7903_7497# 0
C1185 a_6817_3861# _25_.A 0
C1186 a_7539_7637# a_8011_7119# 0
C1187 _55_.CLK u_loop.u_d0.A 0
C1188 _55_.D a_6927_5487# 0
C1189 VPWR u_loop.u_d0.X 0.49632f
C1190 a_6541_6037# _32_.Y 0.30774f
C1191 a_2563_6575# a_2143_6037# 0
C1192 a_2235_6575# a_2309_6037# 0
C1193 _55_.D _41_.X 0
C1194 a_3044_9411# a_3083_9537# 0.87804f
C1195 _55_.D _56_.CLK 0
C1196 _36_.A _28_.A 0
C1197 _67_.D a_7167_4233# 0
C1198 a_2877_6005# a_2580_7663# 0
C1199 _55_.RESET_B _21_.Y 0
C1200 _63_.D _20_.A 0
C1201 a_5784_4399# _55_.RESET_B 0
C1202 a_1499_6575# u_loop.u_gh.C 0
C1203 a_2580_7663# a_2309_6037# 0
C1204 a_6541_6037# a_6375_6037# 0.72678f
C1205 a_3044_9411# a_3170_9295# 0.18122f
C1206 a_4097_2767# a_4439_2767# 0.00188f
C1207 _48_.Y u_loop.u_gh.C 0.03815f
C1208 _23_.A _63_.CLK 0.10702f
C1209 a_1499_7663# a_2111_7663# 0.00188f
C1210 a_8643_7423# a_8911_6031# 0
C1211 a_3703_2767# VPWR 0.19482f
C1212 _52_.Y a_2563_6575# 0
C1213 _56_.D u_loop.u_d0.A 0.00235f
C1214 a_4292_2223# VPWR 0.23713f
C1215 en _28_.A 0
C1216 u_loop.u_q.Y a_5911_2767# 0
C1217 a_6606_4765# _56_.CLK 0
C1218 a_8643_7423# a_8800_6031# 0
C1219 u_loop.u_d2.X a_2856_4399# 0
C1220 a_5989_8751# _48_.Y 0
C1221 _63_.CLK a_3024_8573# 0
C1222 _34_.B1 u_loop.u_gh.C 0.21513f
C1223 a_2143_6037# VPWR 0.42794f
C1224 a_6904_8751# a_6557_8993# 0.05116f
C1225 a_8643_7423# a_8583_6031# 0
C1226 a_8643_7423# _67_.Q 0
C1227 en a_2143_7119# 0.00575f
C1228 a_8643_7423# xb 0
C1229 a_2143_6037# a_2452_6575# 0.01463f
C1230 _55_.CLK a_8011_4943# 0
C1231 _57_.CLK _34_.X 0.10599f
C1232 a_4160_6575# _57_.CLK 0
C1233 a_5594_9295# a_5432_9673# 0.00645f
C1234 u_loop.u_gh.B u_loop.u_d0.A 0.06649f
C1235 _35_.A_N _63_.CLK 0
C1236 a_5594_9295# a_5085_9269# 0
C1237 _25_.A a_6651_3861# 0
C1238 _22_.Y _39_.B2 0.00338f
C1239 _23_.A _40_.B 0.04345f
C1240 _56_.Q a_6651_3861# 0
C1241 a_6283_7663# _68_.D 0
C1242 a_4075_6825# _34_.X 0.01195f
C1243 a_4075_6825# a_4160_6575# 0.15895f
C1244 _52_.Y VPWR 0.78351f
C1245 a_5190_7439# _56_.Q 0
C1246 _52_.Y a_2452_6575# 0
C1247 VPWR a_1735_6031# 0.23835f
C1248 a_4075_6825# a_3436_6549# 0
C1249 a_2235_6575# a_2143_6037# 0
C1250 a_1624_6031# VPWR 0.24729f
C1251 a_5691_3829# _56_.Q 0
C1252 src[0] a_2143_7119# 0.21017f
C1253 _53_.A u_loop.u_gh.B 0
C1254 a_6541_6037# u_loop.u_gh.C 0
C1255 _40_.B a_3024_8573# 0
C1256 VPWR a_6633_2767# 0.30918f
C1257 a_5989_8751# a_6435_8751# 0
C1258 a_2625_2767# u_loop.u_gh.C 0
C1259 u_loop.u_gh.C a_3083_9537# 0.69719f
C1260 a_1654_6575# _34_.X 0.00808f
C1261 _55_.RESET_B _55_.Q 0.03603f
C1262 a_2766_9427# a_3083_9537# 0.10236f
C1263 u_loop.u_gl.A2 a_5036_2381# 0.00147f
C1264 u_loop.u_d1.X u_loop.u_gh.C 0
C1265 a_4075_6825# a_3196_6733# 0
C1266 a_5786_9661# VPWR 0
C1267 a_4075_6825# a_3070_6549# 0
C1268 a_8165_7485# _68_.D 0
C1269 _55_.RESET_B u_loop.u_d6.X 0
C1270 a_4038_8573# u_loop.u_gh.C 0.00288f
C1271 _35_.A_N _40_.B 0.11854f
C1272 a_2751_5321# a_2856_4399# 0.01165f
C1273 _55_.RESET_B _68_.D 0.38241f
C1274 a_1407_6031# VPWR 0.35473f
C1275 a_3170_9295# u_loop.u_gh.C 0.17722f
C1276 _52_.Y a_2235_6575# 0
C1277 a_8643_7423# a_8468_7497# 0.23366f
C1278 a_2766_9427# a_3170_9295# 0.05116f
C1279 _47_.Y _21_.Y 0.0056f
C1280 _39_.X a_5823_8751# 0
C1281 a_6541_6037# _32_.A 0.03982f
C1282 a_5432_9673# a_5085_9269# 0.05116f
C1283 a_3031_4373# a_3316_5321# 0.00125f
C1284 _55_.D _25_.A 0
C1285 _52_.Y a_2580_7663# 0
C1286 a_4075_6825# a_3992_7235# 0
C1287 _23_.A a_1735_7119# 0
C1288 a_2856_4399# a_2969_4917# 0
C1289 a_4075_6825# a_2563_6575# 0
C1290 _36_.A _67_.D 0
C1291 _55_.D _56_.Q 0.03072f
C1292 _36_.A a_6999_6031# 0
C1293 _35_.A_N _39_.B2 0
C1294 a_7553_7125# a_7715_6575# 0.0016f
C1295 _41_.C1 _40_.B 0.02952f
C1296 _67_.D a_6817_3861# 0
C1297 _57_.CLK VPWR 0.36783f
C1298 _55_.Q a_7348_5487# 0
C1299 a_2401_4949# a_2856_4399# 0
C1300 a_3031_4373# a_3491_5247# 0.00441f
C1301 _53_.Y a_2387_4399# 0
C1302 a_3684_8585# a_2769_8213# 0.12499f
C1303 _23_.A a_3316_5321# 0
C1304 a_3031_4373# a_2751_5321# 0
C1305 a_5036_2381# prenh 0.00675f
C1306 _30_.Y a_3684_8585# 0.00108f
C1307 _53_.Y a_3018_4765# 0
C1308 a_5594_9295# a_4517_9301# 0
C1309 a_2877_6005# _34_.B1 0.00212f
C1310 a_1735_7119# _35_.A_N 0
C1311 a_5987_4765# _56_.CLK 0.00201f
C1312 a_4510_3311# u_loop.u_gh.C 0
C1313 a_6704_7663# VPWR 0.08229f
C1314 _56_.Q a_6606_4765# 0
C1315 _55_.Q a_8008_5487# 0
C1316 _34_.B1 a_2309_6037# 0
C1317 a_2399_4765# _28_.Y 0
C1318 a_7553_7125# a_7604_6575# 0
C1319 a_7553_7125# a_7387_6575# 0.00218f
C1320 a_4075_6825# VPWR 0.38827f
C1321 a_5389_7119# VPWR 0.00749f
C1322 _41_.C1 _39_.B2 0.00625f
C1323 a_4075_6825# a_2452_6575# 0
C1324 a_3044_9411# a_2479_9269# 0.04251f
C1325 _23_.A a_3119_8585# 0.03225f
C1326 a_3031_4373# a_2969_4917# 0
C1327 a_7604_6575# a_7715_6575# 0.34134f
C1328 a_5569_2767# a_5805_2767# 0.22264f
C1329 a_6601_8751# a_6557_8993# 0
C1330 a_7387_6575# a_7715_6575# 0
C1331 _55_.Q a_8183_5461# 0
C1332 _23_.A a_3491_5247# 0
C1333 en a_2123_8029# 0
C1334 a_5911_2767# a_5875_2223# 0.00273f
C1335 a_8643_7423# xa 0
C1336 a_6244_8751# a_5823_8751# 0.09169f
C1337 a_1654_6575# VPWR 0.00445f
C1338 a_3119_8585# a_3024_8573# 0.04983f
C1339 pre _35_.A_N 0
C1340 a_2856_4399# a_2235_4949# 0
C1341 a_2401_4949# a_3031_4373# 0.00271f
C1342 a_8165_7485# a_7903_7497# 0.00171f
C1343 _55_.RESET_B a_7999_7497# 0.00512f
C1344 a_5276_2197# a_5036_2381# 0.11296f
C1345 _55_.RESET_B a_7903_7497# 0.20208f
C1346 _53_.Y a_2399_4765# 0.00455f
C1347 a_2751_5321# a_2291_4399# 0
C1348 _23_.A a_2969_4917# 0
C1349 a_7604_6575# a_7387_6575# 0.11296f
C1350 a_6619_4373# _55_.RESET_B 0.35202f
C1351 a_1499_6575# a_2143_6037# 0
C1352 _55_.RESET_B a_6444_4399# 0.24473f
C1353 a_2196_4399# _53_.Y 0.00935f
C1354 _55_.Q a_7443_5487# 0
C1355 a_3119_8585# _35_.A_N 0
C1356 a_5784_4399# _56_.CLK 0.01396f
C1357 a_5432_9673# a_4517_9301# 0.11876f
C1358 a_7364_7663# _46_.Y 0
C1359 _67_.D a_6651_3861# 0
C1360 _53_.Y a_2856_4399# 0.00253f
C1361 src[0] a_2123_8029# 0
C1362 a_2742_8029# _63_.CLK 0
C1363 a_7079_8725# a_5823_8751# 0.04359f
C1364 a_5377_7439# _40_.B 0
C1365 a_7443_5487# _68_.D 0
C1366 a_5085_9269# a_4517_9301# 0.17402f
C1367 _35_.A_N a_1624_7119# 0
C1368 u_loop.u_q.B u_loop.u_d7.X 0.09003f
C1369 _34_.X a_1582_6575# 0
C1370 _34_.X a_1845_6825# 0
C1371 u_loop.u_q.Y a_5875_2223# 0
C1372 a_6339_8751# _31_.Y 0
C1373 a_5879_4399# _55_.RESET_B 0.15328f
C1374 _55_.Q a_7661_5729# 0
C1375 a_2401_4949# _23_.A 0
C1376 _21_.Y _38_.X 0
C1377 _55_.Q a_7093_5487# 0
C1378 _30_.Y a_4032_7351# 0
C1379 a_5129_9661# VPWR 0
C1380 a_5175_2767# u_loop.u_d4.X 0
C1381 a_2625_2767# u_loop.u_d0.X 0.09265f
C1382 a_4963_9673# VPWR 0
C1383 _34_.B1 a_2143_6037# 0
C1384 _68_.D a_7661_5729# 0
C1385 _68_.D a_7093_5487# 0
C1386 a_1499_6575# _52_.Y 0
C1387 u_loop.u_d1.X u_loop.u_d0.X 0.07766f
C1388 a_3031_4373# a_2235_4949# 0
C1389 a_1499_6575# a_1735_6031# 0
C1390 a_1499_6575# a_1624_6031# 0
C1391 a_7715_6575# _34_.X 0.0025f
C1392 a_6447_9117# _39_.B2 0
C1393 a_5649_7119# _39_.X 0
C1394 a_2231_2767# u_loop.u_d0.X 0.1316f
C1395 a_2401_4949# a_2291_4399# 0.00383f
C1396 a_7604_6575# a_7551_5853# 0
C1397 a_6904_8751# _46_.A 0.04205f
C1398 a_5691_3829# a_5569_2767# 0.00138f
C1399 a_6097_4641# _55_.RESET_B 0.16612f
C1400 _55_.RESET_B a_5529_4399# 0.02764f
C1401 a_5377_7439# _39_.B2 0.05422f
C1402 _63_.D u_loop.u_gh.C 0.00787f
C1403 en a_1499_7663# 0
C1404 a_2125_2767# u_loop.u_d0.X 0.01139f
C1405 a_2479_9269# u_loop.u_gh.C 0.28053f
C1406 _23_.A _28_.Y 0
C1407 a_2479_9269# a_2766_9427# 0.23366f
C1408 a_3044_9411# a_2755_7637# 0
C1409 a_5911_2767# VPWR 0.24046f
C1410 _53_.Y a_3031_4373# 0.00171f
C1411 a_8630_4943# a_8468_5321# 0.00645f
C1412 _34_.B1 _52_.Y 0
C1413 a_1499_6575# a_1407_6031# 0.00149f
C1414 a_7473_7663# a_6283_7663# 0
C1415 _34_.B1 a_1735_6031# 0
C1416 a_8008_5487# a_7903_7497# 0
C1417 a_1624_6031# _34_.B1 0.00218f
C1418 _39_.X _22_.Y 0.02777f
C1419 a_7604_6575# _34_.X 0.00346f
C1420 _45_.A _39_.B2 0.03134f
C1421 _23_.A a_2235_4949# 0.01373f
C1422 a_3703_2767# u_loop.u_d1.X 0.00211f
C1423 a_7387_6575# _34_.X 0.20072f
C1424 _55_.D _67_.D 0
C1425 _55_.Q a_6927_5487# 0
C1426 a_4292_2223# u_loop.u_d1.X 0
C1427 a_2015_7663# _34_.X 0
C1428 _55_.D a_6999_6031# 0
C1429 _28_.Y a_2291_4399# 0
C1430 a_4975_9295# _21_.Y 0.00657f
C1431 a_6283_7663# _68__14.LO 0
C1432 a_8183_5461# a_7903_7497# 0
C1433 _56_.Q a_5987_4765# 0
C1434 _36_.A a_4369_6351# 0.08695f
C1435 a_6799_7663# _46_.A 0.00157f
C1436 _63_.Q _62_.D 0.04934f
C1437 output7.A u_loop.u_gh.C 0
C1438 src[0] a_1499_7663# 0
C1439 a_2291_4399# a_2235_4949# 0.00447f
C1440 a_6283_7663# a_5823_8751# 0
C1441 _53_.Y _23_.A 0.01508f
C1442 a_4439_2767# u_loop.u_d0.A 0.01191f
C1443 u_loop.u_d0.X a_1889_2767# 0.00134f
C1444 _36_.A a_6796_6397# 0
C1445 a_4076_3561# u_loop.u_gh.C 0.00217f
C1446 a_3337_8181# a_3793_8585# 0
C1447 a_7473_7663# _55_.RESET_B 0
C1448 _50_.Y a_3859_8511# 0
C1449 x u_loop.u_d7.X 0
C1450 VPWR a_3597_2767# 0.30097f
C1451 a_6283_7663# a_7539_7637# 0.04359f
C1452 _55_.RESET_B u_loop.u_gl.A2 0
C1453 a_5363_4399# _55_.RESET_B 0.29684f
C1454 _67_.D a_8121_7093# 0
C1455 u_loop.u_q.Y VPWR 1.22622f
C1456 _53_.Y a_2291_4399# 0.02014f
C1457 _55_.RESET_B _68__14.LO 0
C1458 a_7443_5487# a_7903_7497# 0
C1459 VPWR a_1582_6575# 0
C1460 en _23_.Y 0
C1461 VPWR a_1845_6825# 0.00884f
C1462 a_3348_7235# _34_.X 0
C1463 a_8468_7497# a_8121_7093# 0.05116f
C1464 _55_.RESET_B a_5823_8751# 0.2978f
C1465 a_7808_5309# a_7999_5321# 0
C1466 a_3348_7235# a_3436_6549# 0
C1467 u_loop.u_d2.X a_2967_2767# 0.14649f
C1468 a_1941_4399# a_2751_5321# 0
C1469 a_7553_7125# VPWR 0.58985f
C1470 _55_.RESET_B a_7539_7637# 0.30187f
C1471 a_7903_5321# a_8011_4943# 0.05722f
C1472 _56_.Q a_5784_4399# 0
C1473 a_7903_7497# a_7093_5487# 0
C1474 a_4160_6575# _34_.X 0.08033f
C1475 a_8630_4943# a_8121_4917# 0
C1476 a_4075_2223# u_loop.u_gh.C 0
C1477 a_8822_5309# a_8643_5247# 0.0074f
C1478 a_7715_6575# VPWR 0.23201f
C1479 a_6449_7663# a_6339_8751# 0
C1480 a_3436_6549# _34_.X 0.26734f
C1481 a_2401_4949# a_2509_4641# 0
C1482 a_4160_6575# a_3436_6549# 0
C1483 _35_.A_N _39_.X 0
C1484 a_3802_9295# VPWR 0.07842f
C1485 a_3348_7235# a_3196_6733# 0
C1486 u_loop.u_d6.X u_loop.u_d5.X 0.00342f
C1487 a_2751_5321# a_2859_4943# 0.05722f
C1488 a_2755_7637# u_loop.u_gh.C 0.35026f
C1489 _41_.B1 _40_.B 0
C1490 a_2766_9427# a_2755_7637# 0
C1491 a_8121_4917# a_8011_4943# 0.09774f
C1492 u_loop.u_d2.X u_loop.u_d0.A 0
C1493 a_1499_6575# a_1654_6575# 0.03438f
C1494 a_8630_4943# a_7553_4949# 0
C1495 a_1941_4399# a_2969_4917# 0.00725f
C1496 a_2479_9269# a_2801_9661# 0.0074f
C1497 a_5036_2381# a_4910_2197# 0.34134f
C1498 prenl VPWR 0.18586f
C1499 a_3802_9295# _30_.A 0.01644f
C1500 a_3070_6549# _34_.X 0.06008f
C1501 _34_.X a_3196_6733# 0.06132f
C1502 _34_.B1 a_4075_6825# 0
C1503 a_3436_6549# a_3196_6733# 0.11296f
C1504 a_3070_6549# a_3436_6549# 0
C1505 a_4833_2767# u_loop.u_d5.X 0
C1506 a_7604_6575# VPWR 0.23638f
C1507 a_7553_4949# a_8011_4943# 0.03462f
C1508 a_2859_4943# a_2969_4917# 0.09774f
C1509 a_3348_7235# a_3992_7235# 0
C1510 a_7387_6575# VPWR 0.30244f
C1511 _55_.CLK a_7808_5309# 0
C1512 a_2751_5321# a_1775_4399# 0
C1513 a_2401_4949# a_1941_4399# 0
C1514 a_6541_6037# _57_.CLK 0.00382f
C1515 a_2015_7663# VPWR 0.24011f
C1516 a_2509_4641# _28_.Y 0.00297f
C1517 a_2015_7663# a_2452_6575# 0
C1518 _36_.A a_4032_7351# 0
C1519 _41_.C1 _39_.X 0
C1520 _34_.B1 a_1654_6575# 0.07722f
C1521 u_loop.u_d0.X a_2769_2223# 0.00944f
C1522 a_6904_8751# a_6799_7663# 0
C1523 _41_.B1 _39_.B2 0.14862f
C1524 a_3070_6549# a_3196_6733# 0.34134f
C1525 a_6601_8751# _46_.A 0.00256f
C1526 a_7387_4949# a_8011_4943# 0
C1527 _25_.Y a_8011_4943# 0
C1528 a_3992_7235# _34_.X 0
C1529 a_4160_6575# a_3992_7235# 0
C1530 a_2509_4641# a_2235_4949# 0
C1531 a_2015_7663# _30_.A 0
C1532 a_6619_4373# a_6927_5487# 0
C1533 a_2401_4949# a_2859_4943# 0.03462f
C1534 src[0] a_2471_7119# 0.00327f
C1535 a_2563_6575# _34_.X 0.04309f
C1536 a_1775_4399# a_2969_4917# 0
C1537 a_7364_7663# _68_.D 0.01475f
C1538 a_4867_9673# u_loop.u_gh.C 0.17391f
C1539 a_6619_4373# _56_.CLK 0
C1540 _55_.Q _25_.A 0.08965f
C1541 a_6619_4373# _41_.X 0
C1542 _56_.CLK a_6444_4399# 0
C1543 a_2769_8213# _49_.Y 0
C1544 a_2235_6575# a_2015_7663# 0
C1545 a_1941_4399# _28_.Y 0
C1546 a_3215_8585# a_2769_8213# 0
C1547 _30_.Y _49_.Y 0.15349f
C1548 a_6557_8993# _39_.B2 0
C1549 _53_.Y a_2509_4641# 0.00635f
C1550 _56_.Q _55_.Q 0.00207f
C1551 u_loop.u_d7.X a_6457_2473# 0
C1552 a_7551_5853# VPWR 0.1421f
C1553 input5.X u_loop.u_gh.C 0
C1554 a_2401_4949# a_1775_4399# 0
C1555 a_2563_6575# a_3196_6733# 0
C1556 a_4292_2223# a_2769_2223# 0
C1557 a_3070_6549# a_2563_6575# 0.01384f
C1558 a_3348_7235# VPWR 0.14664f
C1559 a_5879_4399# _56_.CLK 0.00491f
C1560 a_1941_4399# a_2235_4949# 0.00219f
C1561 a_5879_4399# _41_.X 0
C1562 a_8643_7423# a_8583_8207# 0
C1563 _47_.Y a_5823_8751# 0.26439f
C1564 a_2580_7663# a_2015_7663# 0
C1565 a_3337_8181# a_3381_8573# 0
C1566 a_7387_7125# a_8643_7423# 0.04359f
C1567 a_3227_8207# a_3196_6733# 0
C1568 _34_.X VPWR 1.10416f
C1569 a_4160_6575# VPWR 0.27873f
C1570 a_8577_5321# a_8468_5321# 0.00742f
C1571 _55_.Q _67__13.LO 0
C1572 _55_.CLK _56_.D 0.01234f
C1573 a_2859_4943# a_2235_4949# 0
C1574 _53_.A a_3491_5247# 0.00122f
C1575 a_4833_2767# a_4333_2767# 0
C1576 a_2452_6575# _34_.X 0.03877f
C1577 output7.A u_loop.u_d0.X 0
C1578 _53_.A a_2751_5321# 0
C1579 a_3436_6549# VPWR 0.33679f
C1580 a_6097_4641# _56_.CLK 0.00109f
C1581 _53_.Y a_1941_4399# 0.05652f
C1582 input5.X u_loop.u_d7.X 0
C1583 _56_.CLK a_5529_4399# 0.16212f
C1584 _41_.X a_5529_4399# 0
C1585 _28_.Y a_1775_4399# 0
C1586 a_2755_7637# a_2659_6409# 0
C1587 u_loop.u_gh.B u_loop.u_d4.X 0.00108f
C1588 x a_4292_2223# 0
C1589 a_5875_2223# VPWR 0.23872f
C1590 a_6283_7663# _22_.Y 0.22318f
C1591 en a_3578_6397# 0
C1592 a_3196_6733# VPWR 0.23777f
C1593 _53_.Y a_2859_4943# 0.00133f
C1594 a_3070_6549# VPWR 0.22585f
C1595 a_2452_6575# a_3196_6733# 0.00104f
C1596 _55_.CLK u_loop.u_gh.B 0.0027f
C1597 a_3070_6549# a_2452_6575# 0
C1598 _55_.RESET_B a_7061_7663# 0.00207f
C1599 a_1775_4399# a_2235_4949# 0.01108f
C1600 a_2877_6005# a_2755_7637# 0
C1601 _31_.Y _46_.Y 0
C1602 u_loop.u_gh.B a_3478_4943# 0
C1603 a_3793_8585# a_2603_8213# 0
C1604 a_2235_6575# _34_.X 0.12711f
C1605 a_2309_6037# a_2755_7637# 0
C1606 a_1920_7663# a_1499_7663# 0.0894f
C1607 a_3703_2767# output7.A 0.01247f
C1608 a_4403_2223# a_4439_2767# 0.00273f
C1609 output7.A a_4292_2223# 0.0142f
C1610 _20_.Y src[1] 0
C1611 _50_.Y _63_.CLK 0
C1612 _45_.A _39_.X 0.48048f
C1613 _63_.D a_1735_6031# 0
C1614 a_4076_3561# a_4292_2223# 0
C1615 a_3992_7235# VPWR 0.1168f
C1616 a_2401_4949# _53_.A 0.0011f
C1617 _55_.RESET_B _22_.Y 0.02338f
C1618 _53_.Y a_1775_4399# 0.04407f
C1619 a_4075_2223# u_loop.u_d0.X 0
C1620 a_3044_9411# a_2769_8213# 0
C1621 en a_2921_6397# 0
C1622 en a_3333_6409# 0
C1623 a_1499_6575# a_1582_6575# 0.00726f
C1624 a_1499_6575# a_1845_6825# 0.01147f
C1625 a_3044_9411# _30_.Y 0.27225f
C1626 a_2563_6575# VPWR 0.22194f
C1627 a_5190_7439# a_5293_7439# 0.02752f
C1628 _27_.Y _28_.Y 0
C1629 a_2563_6575# a_2452_6575# 0.34134f
C1630 _23_.A _63_.Q 0.21934f
C1631 a_3992_7235# _30_.A 0
C1632 a_5363_4399# _56_.CLK 0.30291f
C1633 _56_.CLK u_loop.u_gl.A2 0
C1634 a_3361_2767# u_loop.u_gh.C 0
C1635 _56_.D u_loop.u_gh.B 0.03058f
C1636 en a_2755_6409# 0
C1637 a_2769_8213# a_3846_8207# 0
C1638 a_5363_4399# _41_.X 0
C1639 a_5879_4399# a_5190_5487# 0
C1640 en a_2564_6397# 0.00168f
C1641 a_8577_5321# a_8121_4917# 0
C1642 a_3227_8207# VPWR 0.13708f
C1643 _25_.A a_7903_7497# 0
C1644 _63_.Q a_3024_8573# 0.00346f
C1645 _34_.B1 a_1582_6575# 0
C1646 _34_.B1 a_1845_6825# 0.00142f
C1647 en _20_.A 0.07412f
C1648 a_6619_4373# _25_.A 0
C1649 _53_.A _28_.Y 0
C1650 a_6444_4399# _25_.A 0
C1651 _50_.Y _40_.B 0
C1652 a_4292_2223# a_4075_2223# 0.11296f
C1653 u_loop.u_d2.X a_2861_2767# 0.01641f
C1654 a_2111_7663# u_loop.u_gh.C 0.00132f
C1655 a_4167_6147# a_4518_6825# 0
C1656 a_2563_6575# a_2235_6575# 0
C1657 a_8577_5321# a_7553_4949# 0
C1658 _53_.Y u_loop.u_d0.A 0.03872f
C1659 _23_.A a_1665_7663# 0.00314f
C1660 a_5190_5487# a_5529_4399# 0
C1661 _56_.Q a_6619_4373# 0.13668f
C1662 _27_.Y _53_.Y 0.01058f
C1663 _56_.Q a_6444_4399# 0.04048f
C1664 _53_.A a_2235_4949# 0
C1665 a_2452_6575# VPWR 0.24036f
C1666 a_5594_9295# _39_.B2 0
C1667 src[0] a_2360_7119# 0.00447f
C1668 a_6891_6409# _36_.A 0
C1669 a_2143_6037# a_2755_7637# 0
C1670 a_1499_6575# a_2015_7663# 0
C1671 a_8577_5321# a_7387_4949# 0
C1672 a_7553_7125# a_8630_7119# 0
C1673 a_5036_2381# u_loop.u_d0.A 0
C1674 u_loop.u_d1.X a_3597_2767# 0.00343f
C1675 _30_.A VPWR 1.59476f
C1676 a_5879_4399# _56_.Q 0
C1677 _20_.Y _63_.CLK 0
C1678 a_6449_7663# a_6895_7663# 0
C1679 _53_.Y _53_.A 0.2696f
C1680 a_5363_4399# u_loop.u_d5.X 0
C1681 src[0] _20_.A 0
C1682 _31_.Y _21_.Y 0
C1683 _67_.D _55_.Q 0
C1684 a_6097_4641# _25_.A 0
C1685 _25_.A a_5529_4399# 0
C1686 _35_.A_N a_1665_7663# 0
C1687 a_7553_7125# a_6541_6037# 0
C1688 output6.A u_loop.u_gh.C 0.17635f
C1689 _41_.C1 a_5377_5487# 0
C1690 a_2235_6575# VPWR 0.28211f
C1691 a_7903_5321# a_8165_5309# 0.00171f
C1692 a_2235_6575# a_2452_6575# 0.11296f
C1693 a_3337_8181# _62_.D 0
C1694 _67_.D _68_.D 0
C1695 a_4769_4175# u_loop.u_gh.C 0.00136f
C1696 a_4351_4175# u_loop.u_gh.C 0.20463f
C1697 a_6097_4641# _56_.Q 0.00158f
C1698 a_4833_2767# a_5069_2767# 0.22264f
C1699 u_loop.u_gl.B1 u_loop.u_gh.C 0.12848f
C1700 a_2769_8213# u_loop.u_gh.C 0.06244f
C1701 _56_.Q a_5529_4399# 0.00627f
C1702 a_7017_7905# VPWR 0.20461f
C1703 a_2769_8213# a_2766_9427# 0
C1704 a_6449_7663# _46_.Y 0.00239f
C1705 _30_.Y u_loop.u_gh.C 0.07234f
C1706 _30_.Y a_2766_9427# 0
C1707 a_5911_2767# a_5764_2223# 0.00146f
C1708 a_7072_4221# u_loop.u_d7.X 0
C1709 a_2580_7663# VPWR 0.29446f
C1710 a_2580_7663# a_2452_6575# 0
C1711 a_8121_4917# a_8165_5309# 0
C1712 a_3802_9295# a_3083_9537# 0.08638f
C1713 _45_.A a_7079_8725# 0
C1714 a_7109_6005# _36_.A 0
C1715 a_8468_7497# _68_.D 0
C1716 _39_.X _41_.B1 0
C1717 _63_.D a_1654_6575# 0
C1718 u_loop.u_d6.X a_5569_2767# 0
C1719 a_7364_7663# a_7473_7663# 0.00742f
C1720 a_5432_9673# _39_.B2 0.06004f
C1721 a_5293_5487# _41_.C1 0.00251f
C1722 output6.A u_loop.u_d7.X 0
C1723 a_4292_2223# input5.X 0
C1724 a_8643_7423# _68_.Q 0.17028f
C1725 a_6541_6037# a_7604_6575# 0
C1726 prenl u_loop.u_d1.X 0
C1727 a_1499_6575# _34_.X 0.16318f
C1728 a_5085_9269# _39_.B2 0.0228f
C1729 a_5911_2767# u_loop.u_q.B 0.01253f
C1730 a_6541_6037# a_7387_6575# 0.00141f
C1731 a_7167_4233# u_loop.u_gh.C 0
C1732 a_5363_4399# _25_.A 0
C1733 _46_.A _39_.B2 0.04289f
C1734 a_7808_7485# _68_.D 0.17273f
C1735 u_loop.u_d3.X a_4097_2767# 0.37578f
C1736 u_loop.u_q.Y a_5764_2223# 0
C1737 a_4074_7235# _40_.B 0
C1738 a_4333_2767# u_loop.u_gl.A2 0.01009f
C1739 _56_.Q a_5363_4399# 0.00502f
C1740 a_7364_7663# a_7539_7637# 0.23366f
C1741 _34_.B1 _34_.X 0.46704f
C1742 _50_.Y a_3119_8585# 0
C1743 u_loop.u_d5.X a_5547_2223# 0
C1744 a_8643_7423# a_8800_8207# 0
C1745 a_7903_5321# a_7999_5321# 0.01379f
C1746 u_loop.u_q.Y u_loop.u_q.B 0.59115f
C1747 a_3361_2767# u_loop.u_d0.X 0
C1748 a_6541_6037# a_7551_5853# 0
C1749 _36_.A _32_.Y 0.00303f
C1750 _34_.B1 a_3196_6733# 0
C1751 _34_.B1 a_3070_6549# 0.00245f
C1752 a_7387_7125# a_8121_7093# 0.07009f
C1753 a_8121_4917# a_7999_5321# 0
C1754 a_2277_7663# u_loop.u_gh.C 0.00337f
C1755 _48_.Y a_3992_7235# 0
C1756 a_7808_5309# a_7903_5321# 0.04983f
C1757 a_5607_9599# _46_.Y 0
C1758 _45_.A a_6283_7663# 0.17434f
C1759 _36_.A a_6375_6037# 0
C1760 _67_.D a_7903_7497# 0.00152f
C1761 a_6541_6037# _34_.X 0.00832f
C1762 _55_.RESET_B a_6447_9117# 0.0122f
C1763 _68_.D xa 0
C1764 a_7553_4949# a_7999_5321# 0
C1765 u_loop.u_q.Y a_6381_3561# 0.00301f
C1766 _23_.A a_3388_7351# 0.16602f
C1767 a_3703_2767# a_3361_2767# 0.00188f
C1768 _55_.CLK a_7903_5321# 0
C1769 pre _20_.Y 0.02853f
C1770 a_6891_6409# _55_.D 0
C1771 _34_.B1 a_2563_6575# 0.11063f
C1772 a_8468_7497# a_7903_7497# 0
C1773 _63_.Q a_2742_8029# 0
C1774 a_3684_8585# a_3793_8585# 0.00742f
C1775 u_loop.u_d4.X a_4439_2767# 0.1513f
C1776 a_7808_5309# a_7553_4949# 0.06418f
C1777 _45_.A _55_.RESET_B 0.51627f
C1778 a_4517_9301# _39_.B2 0.13082f
C1779 a_1499_6575# VPWR 0.58534f
C1780 _55_.CLK a_8121_4917# 0
C1781 _22_.Y _38_.X 0
C1782 _23_.A a_3430_7235# 0
C1783 _48_.Y VPWR 0.58788f
C1784 _35_.A_N a_3388_7351# 0.21276f
C1785 a_7808_5309# a_7387_4949# 0.08638f
C1786 a_7631_6335# a_8121_7093# 0
C1787 _35_.A_N a_1407_7119# 0
C1788 a_7808_5309# _25_.Y 0.16124f
C1789 a_6904_8751# _39_.B2 0
C1790 a_7808_7485# a_7999_7497# 0
C1791 a_7808_7485# a_7903_7497# 0.04983f
C1792 _55_.CLK a_7553_4949# 0
C1793 u_loop.u_qb.A a_5911_2767# 0.0016f
C1794 _48_.Y _30_.A 0.13588f
C1795 a_2742_8029# a_1665_7663# 0
C1796 a_4403_2223# a_5036_2381# 0
C1797 u_loop.u_q.Y x 0
C1798 _34_.B1 VPWR 0.23905f
C1799 _34_.B1 a_2452_6575# 0.03126f
C1800 _36_.A u_loop.u_gh.C 0.09705f
C1801 a_1920_7663# _20_.A 0
C1802 a_1499_6575# a_2235_6575# 0.00164f
C1803 _55_.CLK a_7387_4949# 0
C1804 _55_.CLK _25_.Y 0
C1805 _23_.A a_2233_7905# 0
C1806 a_3430_7235# _35_.A_N 0
C1807 _23_.A _38_.X 0.00587f
C1808 a_2603_8213# _62_.D 0.32589f
C1809 a_6817_3861# u_loop.u_gh.C 0
C1810 prenl a_2769_2223# 0
C1811 _41_.C1 a_3388_7351# 0
C1812 VPWR a_8630_7119# 0
C1813 output7.A a_3597_2767# 0.01105f
C1814 a_4292_2223# output6.A 0.0011f
C1815 _35_.A_N a_4518_6575# 0.10853f
C1816 a_6799_7663# _39_.B2 0
C1817 a_6435_8751# VPWR 0
C1818 _55_.CLK _42_.Y 0
C1819 a_4076_3561# u_loop.u_q.Y 0
C1820 _23_.A _35_.B 0.22493f
C1821 en u_loop.u_gh.C 0.0189f
C1822 u_loop.u_gl.B1 a_4292_2223# 0
C1823 a_5293_7439# _21_.Y 0
C1824 u_loop.u_gl.A2 a_5069_2767# 0.00248f
C1825 a_5607_9599# _21_.Y 0.00106f
C1826 _36_.A _32_.A 0.03972f
C1827 _34_.B1 a_2235_6575# 0.02786f
C1828 u_loop.u_q.Y u_loop.u_qb.A 0.08048f
C1829 a_5989_8751# a_6339_8751# 0.2298f
C1830 a_6541_6037# VPWR 0.58787f
C1831 a_5764_2223# a_5875_2223# 0.34134f
C1832 a_2625_2767# VPWR 0.28749f
C1833 a_2233_7905# _35_.A_N 0
C1834 _23_.A a_5389_5737# 0
C1835 a_2847_5321# a_2656_5309# 0
C1836 a_3337_8181# _23_.A 0.00601f
C1837 VPWR a_3083_9537# 0.43031f
C1838 a_6817_3861# u_loop.u_d7.X 0
C1839 _35_.A_N _38_.X 0.39774f
C1840 a_2399_4765# _28_.A 0
C1841 x prenl 0
C1842 a_4167_6147# _36_.A 0.15317f
C1843 _36_.A a_3224_6409# 0
C1844 _41_.B1 a_5377_5487# 0.01938f
C1845 u_loop.u_d1.X VPWR 0.55253f
C1846 a_5129_9661# a_4867_9673# 0.00171f
C1847 a_7364_7663# _22_.Y 0
C1848 _63_.D a_2015_7663# 0.00165f
C1849 a_2196_4399# _28_.A 0
C1850 a_5805_2767# u_loop.u_d7.X 0
C1851 a_4867_9673# a_4963_9673# 0.01379f
C1852 _56_.Q a_5649_7119# 0
C1853 a_2231_2767# VPWR 0.2084f
C1854 a_2479_9269# a_2015_7663# 0
C1855 a_3170_9295# VPWR 0.20811f
C1856 a_3239_9269# _40_.B 0.00395f
C1857 _30_.A a_3083_9537# 0.04548f
C1858 _41_.C1 _56_.CLK 0
C1859 a_4351_9301# a_5432_9673# 0.10236f
C1860 _40_.B a_3859_8511# 0.17716f
C1861 _35_.A_N _35_.B 1.43611f
C1862 a_3316_5321# a_3478_4943# 0.00645f
C1863 a_5911_2767# u_loop.u_s1.Y 0.00317f
C1864 a_2125_2767# VPWR 0.36782f
C1865 src[0] u_loop.u_gh.C 0
C1866 _56_.D _42_.Y 0
C1867 u_loop.u_q.B a_5875_2223# 0.01502f
C1868 a_4075_6825# a_4518_6825# 0.02665f
C1869 a_5175_2767# a_5036_2381# 0
C1870 prenl output7.A 0.00382f
C1871 _36_.A a_3399_6335# 0
C1872 a_4097_2767# a_4333_2767# 0.22264f
C1873 a_3170_9295# _30_.A 0.01862f
C1874 a_5190_5487# _23_.A 0
C1875 _67_.D a_7539_7637# 0
C1876 a_4351_9301# a_5085_9269# 0.05811f
C1877 a_6283_7663# a_6557_8993# 0
C1878 a_4076_3561# prenl 0
C1879 en a_3224_6409# 0
C1880 a_5293_5487# _41_.B1 0.01678f
C1881 a_6541_6037# a_7017_7905# 0
C1882 a_3337_8181# _35_.A_N 0
C1883 _41_.C1 _38_.X 0.07428f
C1884 a_7618_6031# _25_.Y 0
C1885 a_8577_7497# _55_.RESET_B 0
C1886 _55_.RESET_B a_8011_4943# 0
C1887 a_6651_3861# u_loop.u_gh.C 0
C1888 _68_.Q a_8121_7093# 0.00312f
C1889 a_3859_8511# _39_.B2 0.00191f
C1890 _39_.X _46_.A 0
C1891 en a_3399_6335# 0
C1892 _41_.C1 _35_.B 0.1953f
C1893 a_5911_2767# input5.X 0.0098f
C1894 VPWR a_1889_2767# 0.37621f
C1895 _55_.RESET_B a_6557_8993# 0.16102f
C1896 u_loop.u_q.Y u_loop.u_s1.Y 0.00567f
C1897 a_3031_4373# _28_.A 0
C1898 u_loop.u_q.Y a_6457_2473# 0.01481f
C1899 a_4510_3311# VPWR 0.00464f
C1900 u_loop.u_d7.X a_6651_3861# 0
C1901 prenl a_4075_2223# 0.00221f
C1902 _23_.A _56_.Q 0
C1903 a_3478_4943# a_2969_4917# 0
C1904 _36_.A a_2309_6037# 0
C1905 a_3316_5321# u_loop.u_gh.B 0
C1906 a_5764_2223# VPWR 0.23188f
C1907 _63_.CLK src[1] 0
C1908 u_loop.u_q.Y u_loop.u_cmp.Y 0.00268f
C1909 en a_2659_6409# 0.0012f
C1910 a_5276_2197# a_5069_2767# 0.01911f
C1911 a_2401_4949# a_3478_4943# 0
C1912 _23_.A _28_.A 0.22418f
C1913 u_loop.u_q.Y input5.X 0.0192f
C1914 a_5823_8751# _31_.Y 0.17396f
C1915 en a_2877_6005# 0
C1916 a_5190_5487# _41_.C1 0.11417f
C1917 x a_5875_2223# 0.00552f
C1918 a_5569_2767# a_5547_2223# 0.01966f
C1919 _55_.D u_loop.u_gh.C 0
C1920 u_loop.u_q.B VPWR 0.42091f
C1921 _23_.A a_2143_7119# 0
C1922 en a_2309_6037# 0.00459f
C1923 a_3425_5321# a_3316_5321# 0.00742f
C1924 u_loop.u_gh.B a_3491_5247# 0
C1925 a_2751_5321# u_loop.u_gh.B 0
C1926 _68__14.LO xa 0
C1927 a_2291_4399# _28_.A 0
C1928 a_5377_7439# _38_.X 0
C1929 _45_.A _41_.X 0
C1930 a_1499_6575# _34_.B1 0.12475f
C1931 a_3119_8585# a_3239_9269# 0
C1932 u_loop.u_q.Y a_7894_3855# 0
C1933 u_loop.u_d3.X u_loop.u_d0.A 0
C1934 a_4351_9301# a_4517_9301# 0.68865f
C1935 a_3670_5309# a_3491_5247# 0.0074f
C1936 a_8183_5461# a_8011_4943# 0
C1937 a_6381_3561# VPWR 0.00729f
C1938 a_6244_8751# _46_.A 0.01451f
C1939 a_8643_5247# a_8468_5321# 0.23366f
C1940 a_7539_7637# xa 0
C1941 u_loop.u_q.Y a_7275_3855# 0
C1942 _46_.Y _32_.Y 0
C1943 _41_.C1 _25_.A 0
C1944 _55_.D u_loop.u_d7.X 0.00273f
C1945 a_2533_2223# u_loop.u_d0.A 0
C1946 u_loop.u_gh.B a_2969_4917# 0
C1947 _49_.Y _21_.Y 0
C1948 _35_.A_N a_2143_7119# 0.00138f
C1949 a_7903_5321# a_8468_5321# 0
C1950 _56_.Q _41_.C1 0
C1951 VPWR a_2769_2223# 0.29949f
C1952 a_7387_7125# _68_.D 0.32511f
C1953 prenl input5.X 0
C1954 _36_.A a_2143_6037# 0
C1955 _45_.A _35_.B 0.00149f
C1956 a_3013_5309# a_2751_5321# 0.00171f
C1957 a_4772_9661# a_4517_9301# 0.06121f
C1958 a_7456_6409# _55_.Q 0
C1959 a_2401_4949# u_loop.u_gh.B 0
C1960 a_8643_7423# a_8822_7485# 0.0074f
C1961 a_2233_7905# a_2742_8029# 0
C1962 _32_.A a_8121_7093# 0
C1963 a_8121_4917# a_8468_5321# 0.05116f
C1964 a_7079_8725# _46_.A 0.16688f
C1965 _34_.X a_2755_7637# 0
C1966 a_3425_5321# a_2969_4917# 0
C1967 _63_.D VPWR 0.77189f
C1968 _53_.Y a_3478_4943# 0
C1969 _41_.C1 _28_.A 0.00123f
C1970 a_3384_9295# a_3239_9269# 0.05722f
C1971 _23_.A a_2603_8213# 0.06494f
C1972 a_2479_9269# VPWR 0.42857f
C1973 _48_.Y a_3083_9537# 0.00464f
C1974 a_8011_4943# a_7093_5487# 0
C1975 a_7553_4949# a_8468_5321# 0.12532f
C1976 _50_.Y _63_.Q 0.24869f
C1977 en a_2143_6037# 0.06232f
C1978 a_3013_5309# a_2969_4917# 0
C1979 _56_.CLK u_loop.u_d0.A 0.00115f
C1980 x VPWR 0.07031f
C1981 a_3361_2767# a_3597_2767# 0.22264f
C1982 a_3388_7351# _41_.B1 0
C1983 a_1735_7119# src[1] 0.00268f
C1984 a_2755_7637# a_3196_6733# 0.00238f
C1985 a_2479_9269# _30_.A 0.13624f
C1986 a_2401_4949# a_3425_5321# 0
C1987 a_6449_7663# a_7473_7663# 0
C1988 a_3070_6549# a_2755_7637# 0
C1989 a_6799_7663# _39_.X 0
C1990 a_2603_8213# a_3024_8573# 0.08638f
C1991 a_7631_6335# _55_.Q 0
C1992 a_7387_4949# a_8468_5321# 0.10236f
C1993 a_6891_6409# _55_.Q 0
C1994 a_1920_7663# u_loop.u_gh.C 0
C1995 _55_.RESET_B a_6397_2767# 0
C1996 u_loop.u_gh.B a_2235_4949# 0
C1997 a_7631_6335# _68_.D 0
C1998 output7.A VPWR 0.3278f
C1999 a_6817_3861# a_6633_2767# 0
C2000 a_2603_8213# _35_.A_N 0
C2001 a_6449_7663# _68__14.LO 0
C2002 en _52_.Y 0.02527f
C2003 a_4076_3561# VPWR 0.77125f
C2004 u_loop.u_s1.Y a_5875_2223# 0
C2005 en a_1735_6031# 0.04186f
C2006 a_6449_7663# a_5823_8751# 0
C2007 en a_1624_6031# 0.04782f
C2008 pre src[1] 0.02861f
C2009 _50_.Y a_1665_7663# 0
C2010 a_2509_4641# _28_.A 0
C2011 _63_.D a_2580_7663# 0
C2012 src[0] a_2143_6037# 0
C2013 _45_.A a_7364_7663# 0.03876f
C2014 a_3210_4399# u_loop.u_gh.C 0.00224f
C2015 a_8121_4917# a_7903_5321# 0.20964f
C2016 a_2847_5321# a_2751_5321# 0.01379f
C2017 u_loop.u_qb.A VPWR 0.37883f
C2018 a_7553_4949# a_8643_5247# 0.04251f
C2019 a_2563_6575# a_2755_7637# 0.00112f
C2020 a_6449_7663# a_7539_7637# 0.04251f
C2021 a_3044_9411# _21_.Y 0
C2022 _41_.B1 a_4518_6575# 0.08693f
C2023 a_6927_5487# a_8011_4943# 0
C2024 _41_.B1 _56_.CLK 0.00108f
C2025 a_5989_8751# _46_.Y 0
C2026 _41_.X _41_.B1 0
C2027 a_7808_7485# _22_.Y 0
C2028 a_3425_5321# a_2235_4949# 0
C2029 u_loop.u_d5.X u_loop.u_d0.A 0
C2030 _45_.A _25_.A 0
C2031 u_loop.u_q.Y a_7072_4221# 0
C2032 a_7553_4949# a_7903_5321# 0.21986f
C2033 a_7387_4949# a_8643_5247# 0.04359f
C2034 a_1407_6031# en 0.04828f
C2035 a_6283_7663# _46_.A 0.03431f
C2036 a_3227_8207# a_2755_7637# 0
C2037 _32_.A _46_.Y 0
C2038 a_2847_5321# a_2969_4917# 0
C2039 _23_.A a_2123_8029# 0
C2040 a_7387_7125# a_7999_7497# 0
C2041 u_loop.u_d1.X a_2625_2767# 0.32896f
C2042 _45_.A _56_.Q 0
C2043 src[0] _52_.Y 0.00143f
C2044 a_1941_4399# _28_.A 0
C2045 a_7387_7125# a_7903_7497# 0.10748f
C2046 a_1624_7119# src[1] 0.00388f
C2047 input5.X a_5875_2223# 0.12533f
C2048 _41_.B1 _38_.X 0.06889f
C2049 a_7109_6005# _55_.Q 0
C2050 src[0] a_1735_6031# 0
C2051 src[0] a_1624_6031# 0
C2052 a_7553_4949# a_8121_4917# 0.17589f
C2053 u_loop.u_q.Y output6.A 0.50517f
C2054 a_7387_4949# a_7903_5321# 0.10317f
C2055 a_7903_5321# _25_.Y 0.0031f
C2056 _36_.A _57_.CLK 0.02147f
C2057 a_4075_2223# VPWR 0.33593f
C2058 a_4351_9301# a_3859_8511# 0
C2059 a_2965_4399# u_loop.u_gh.C 0
C2060 u_loop.u_q.Y a_4351_4175# 0.00105f
C2061 a_2656_5309# a_2751_5321# 0.04983f
C2062 a_1735_7119# _63_.CLK 0
C2063 a_6904_8751# a_7079_8725# 0.23366f
C2064 u_loop.u_q.Y a_4769_4175# 0.05536f
C2065 a_3170_9295# a_3083_9537# 0.07009f
C2066 u_loop.u_gl.B1 u_loop.u_q.Y 0
C2067 a_2231_2767# u_loop.u_d1.X 0.01946f
C2068 _22_.Y _31_.Y 0.00197f
C2069 a_2125_2767# a_2625_2767# 0
C2070 a_2755_7637# VPWR 0.4063f
C2071 a_2401_4949# a_2847_5321# 0
C2072 u_loop.u_q.Y a_7732_4233# 0
C2073 _41_.B1 _35_.B 0.10007f
C2074 a_2125_2767# u_loop.u_d1.X 0.01061f
C2075 a_7387_4949# a_8121_4917# 0.05348f
C2076 _55_.RESET_B _46_.A 0.4891f
C2077 a_2231_2767# a_2125_2767# 0.41909f
C2078 u_loop.u_q.Y a_7907_4159# 0
C2079 a_2755_7637# _30_.A 0
C2080 _36_.A a_5389_7119# 0.0012f
C2081 _40_.B _39_.B2 0.04601f
C2082 _36_.A a_4075_6825# 0
C2083 a_6651_3861# a_6633_2767# 0.0013f
C2084 _55_.RESET_B a_7718_7663# 0.00234f
C2085 a_2111_7663# a_2015_7663# 0.01379f
C2086 _41_.B1 a_5389_5737# 0.00199f
C2087 a_7387_4949# a_7553_4949# 0.70199f
C2088 a_7553_4949# _25_.Y 0.28101f
C2089 a_1775_4399# _28_.A 0
C2090 a_2399_4765# _23_.Y 0
C2091 _32_.A a_5987_4765# 0
C2092 a_4518_6825# _34_.X 0.00648f
C2093 a_4160_6575# a_4518_6825# 0.27101f
C2094 u_loop.u_s1.Y VPWR 0.3466f
C2095 u_loop.u_q.Y a_7167_4233# 0.0011f
C2096 VPWR a_6457_2473# 0.00457f
C2097 a_7079_8725# a_6799_7663# 0
C2098 a_3802_9295# a_2769_8213# 0
C2099 a_5607_9599# a_5823_8751# 0
C2100 a_2401_4949# a_2656_5309# 0.06418f
C2101 prenl output6.A 0.00175f
C2102 a_7631_6335# a_7903_7497# 0
C2103 a_7387_4949# _25_.Y 0.16591f
C2104 _30_.Y a_3802_9295# 0.16052f
C2105 a_4333_2767# u_loop.u_d0.A 0.0096f
C2106 a_7553_4949# _42_.Y 0.00638f
C2107 a_3119_8585# _63_.CLK 0
C2108 u_loop.u_d1.X a_1889_2767# 0
C2109 a_2580_7663# a_2755_7637# 0.23366f
C2110 _21_.Y u_loop.u_gh.C 0.03098f
C2111 _23_.A a_3386_6031# 0
C2112 a_4867_9673# VPWR 0.22469f
C2113 a_2847_5321# a_2235_4949# 0
C2114 a_5190_5487# _41_.B1 0.09641f
C2115 _68_.Q _68_.D 0.03223f
C2116 u_loop.u_cmp.Y VPWR 0.36171f
C2117 a_2231_2767# a_1889_2767# 0.00188f
C2118 _23_.A a_1499_7663# 0.00161f
C2119 a_1624_7119# _63_.CLK 0
C2120 a_7387_4949# _42_.Y 0.25336f
C2121 _42_.Y _25_.Y 0.13041f
C2122 a_4867_9673# _30_.A 0
C2123 a_2125_2767# a_1889_2767# 0.22264f
C2124 en a_1654_6575# 0.00309f
C2125 a_5989_8751# _21_.Y 0
C2126 input5.X VPWR 0.94067f
C2127 _27_.Y _28_.A 0.0065f
C2128 a_1499_6575# _63_.D 0
C2129 a_2656_5309# _28_.Y 0.1576f
C2130 a_8630_4943# _25_.A 0
C2131 _47_.Y a_5432_9673# 0.00343f
C2132 a_3793_8585# u_loop.u_gh.C 0
C2133 _41_.B1 _25_.A 0
C2134 _55_.RESET_B a_7999_5321# 0
C2135 a_2656_5309# a_2235_4949# 0.08968f
C2136 a_3119_8585# _40_.B 0.00374f
C2137 a_7894_3855# VPWR 0
C2138 u_loop.u_q.Y a_7385_3829# 0
C2139 _25_.A a_8011_4943# 0.00766f
C2140 a_1499_7663# _35_.A_N 0
C2141 _56_.Q _41_.B1 0.12303f
C2142 _53_.A _28_.A 0.003f
C2143 _63_.D _34_.B1 0
C2144 a_7275_3855# VPWR 0.1421f
C2145 a_6904_8751# _55_.RESET_B 0.22941f
C2146 a_7808_5309# _55_.RESET_B 0.00218f
C2147 a_5190_7439# a_5389_7119# 0.0129f
C2148 _47_.Y _46_.A 0
C2149 _53_.Y a_2656_5309# 0.00208f
C2150 a_8822_5309# _25_.A 0
C2151 a_6283_7663# a_6799_7663# 0.11053f
C2152 a_3348_7235# a_2769_8213# 0.00108f
C2153 a_6449_7663# _22_.Y 0.23394f
C2154 a_7387_7125# a_7539_7637# 0.00684f
C2155 _23_.A _23_.Y 0.18699f
C2156 a_2625_2767# a_2769_2223# 0.00402f
C2157 _55_.Q u_loop.u_gh.C 0
C2158 a_2769_8213# _34_.X 0
C2159 a_4518_6825# VPWR 0.52992f
C2160 _55_.CLK _55_.RESET_B 0.0515f
C2161 _45_.A _67_.D 0
C2162 a_5911_2767# a_5805_2767# 0.41909f
C2163 u_loop.u_d1.X a_2769_2223# 0.01139f
C2164 a_3684_8585# _23_.A 0
C2165 a_7553_7125# a_8643_7423# 0.04251f
C2166 a_3384_9295# _40_.B 0.00113f
C2167 output6.A a_5875_2223# 0.00201f
C2168 a_7456_6409# a_7539_7637# 0
C2169 a_7551_5853# a_7167_4233# 0
C2170 _23_.Y a_2291_4399# 0
C2171 _56_.D a_5377_5487# 0
C2172 a_6799_7663# _55_.RESET_B 0.16561f
C2173 _68_.Q a_7999_7497# 0
C2174 a_2015_7663# a_2277_7663# 0.00171f
C2175 _68_.Q a_7903_7497# 0
C2176 a_2769_8213# a_3196_6733# 0
C2177 a_3070_6549# a_2769_8213# 0
C2178 a_2479_9269# a_3083_9537# 0.04359f
C2179 u_loop.u_q.Y _36_.A 0
C2180 a_3361_2767# VPWR 0.29142f
C2181 _35_.A_N a_4369_6351# 0.0179f
C2182 _23_.Y _35_.A_N 0
C2183 _23_.A a_2471_7119# 0
C2184 a_1735_7119# a_1624_7119# 0.34134f
C2185 _50_.Y a_2233_7905# 0
C2186 u_loop.u_q.B a_5764_2223# 0.00346f
C2187 a_6444_4399# _32_.Y 0
C2188 u_loop.u_d6.X u_loop.u_d7.X 0
C2189 _32_.A _68_.D 0
C2190 u_loop.u_q.Y a_6817_3861# 0.00381f
C2191 a_3684_8585# _35_.A_N 0
C2192 _56_.D _55_.RESET_B 0
C2193 _20_.Y a_1407_7119# 0.00561f
C2194 u_loop.u_q.Y a_5805_2767# 0
C2195 a_7631_6335# a_7539_7637# 0
C2196 a_3316_5321# a_3491_5247# 0.23366f
C2197 a_2111_7663# VPWR 0.00524f
C2198 _45_.A a_7808_7485# 0
C2199 a_5069_2767# u_loop.u_d0.A 0
C2200 a_2751_5321# a_3316_5321# 0
C2201 _50_.Y _35_.B 0
C2202 output7.A a_2625_2767# 0
C2203 _49_.Y _62_.D 0.00867f
C2204 _63_.Q a_3859_8511# 0
C2205 _41_.C1 a_4369_6351# 0.00689f
C2206 output7.A u_loop.u_d1.X 0.02029f
C2207 _35_.A_N a_2471_7119# 0.09613f
C2208 a_3215_8585# _62_.D 0.00176f
C2209 a_5823_8751# _49_.Y 0
C2210 a_8630_4943# _67_.Q 0
C2211 _55_.RESET_B u_loop.u_gh.B 0
C2212 _34_.B1 a_2755_7637# 0
C2213 en a_1582_6575# 0
C2214 a_3337_8181# _50_.Y 0
C2215 a_5293_7439# _22_.Y 0
C2216 a_5432_9673# a_5541_9673# 0.00742f
C2217 a_7072_4221# VPWR 0.08229f
C2218 a_3316_5321# a_2969_4917# 0.05116f
C2219 a_3227_8207# a_2769_8213# 0.03063f
C2220 _55_.RESET_B a_7618_6031# 0
C2221 _45_.A _31_.Y 0
C2222 a_2767_6031# a_3031_4373# 0
C2223 a_5541_9673# a_5085_9269# 0
C2224 a_6381_3561# u_loop.u_q.B 0.01266f
C2225 a_5569_2767# u_loop.u_d0.A 0
C2226 output6.A VPWR 1.54868f
C2227 a_3381_8573# u_loop.u_gh.C 0.00401f
C2228 a_4403_2223# a_4333_2767# 0
C2229 a_7808_5309# a_7443_5487# 0
C2230 a_4867_9673# _48_.Y 0.00131f
C2231 a_4769_4175# VPWR 0.00657f
C2232 a_4351_4175# VPWR 0.009f
C2233 a_2401_4949# a_3316_5321# 0.12532f
C2234 a_5175_2767# u_loop.u_d5.X 0.1513f
C2235 u_loop.u_gl.B1 VPWR 0.66652f
C2236 a_2769_8213# VPWR 0.39355f
C2237 _30_.Y VPWR 0.64072f
C2238 _45_.A xa 0
C2239 a_7732_4233# VPWR 0.30183f
C2240 a_4075_2223# u_loop.u_d1.X 0
C2241 a_2751_5321# a_2969_4917# 0.20964f
C2242 a_6895_7663# a_6704_7663# 0
C2243 x a_5764_2223# 0.00884f
C2244 u_loop.u_q.Y a_6651_3861# 0.00644f
C2245 a_2509_4641# _23_.Y 0
C2246 a_6601_8751# _55_.RESET_B 0.0022f
C2247 a_2769_8213# _30_.A 0
C2248 a_2767_6031# _23_.A 0.00268f
C2249 a_3384_9295# a_3119_8585# 0
C2250 a_6619_4373# u_loop.u_gh.C 0
C2251 _35_.A_N a_4032_7351# 0.28246f
C2252 a_7907_4159# VPWR 0.43216f
C2253 _30_.Y _30_.A 0.21891f
C2254 _57_.CLK _46_.Y 0
C2255 a_4351_9301# _39_.B2 0.00442f
C2256 a_5691_3829# u_loop.u_q.Y 0.28769f
C2257 a_8577_5321# _25_.A 0
C2258 _20_.Y _35_.B 0.01378f
C2259 en a_2015_7663# 0
C2260 a_3170_9295# a_2755_7637# 0
C2261 a_2401_4949# a_3491_5247# 0.04251f
C2262 a_4510_3311# output7.A 0.17975f
C2263 _23_.A a_3578_6397# 0
C2264 a_2401_4949# a_2751_5321# 0.2298f
C2265 _39_.X _39_.B2 0.00278f
C2266 a_4074_7235# _38_.X 0
C2267 a_5879_4399# u_loop.u_gh.C 0
C2268 a_7167_4233# VPWR 0.2087f
C2269 u_loop.u_d3.X u_loop.u_d4.X 0.00342f
C2270 x u_loop.u_q.B 0.0073f
C2271 _46_.Y a_6704_7663# 0
C2272 a_4975_9295# a_5085_9269# 0.09774f
C2273 a_3044_9411# _62_.D 0
C2274 a_8577_7497# a_8468_7497# 0.00742f
C2275 _68_.Q _68__14.LO 0.01199f
C2276 a_5823_8751# a_7013_8751# 0
C2277 a_3316_5321# a_2235_4949# 0.10236f
C2278 a_7387_7125# _22_.Y 0
C2279 a_1941_4399# _23_.Y 0
C2280 a_2769_8213# a_2580_7663# 0
C2281 a_4772_9661# _39_.B2 0
C2282 _41_.C1 a_4032_7351# 0.14555f
C2283 a_4074_7235# _35_.B 0.00119f
C2284 a_2401_4949# a_2969_4917# 0.18639f
C2285 a_2967_2767# a_2875_2223# 0
C2286 _36_.A a_4160_6575# 0
C2287 _68_.Q a_7539_7637# 0.00424f
C2288 _36_.A _34_.X 0.03294f
C2289 a_6097_4641# u_loop.u_gh.C 0
C2290 u_loop.u_gh.C a_5529_4399# 0
C2291 _23_.A a_3333_6409# 0
C2292 src[0] a_2015_7663# 0
C2293 a_2751_5321# _28_.Y 0
C2294 a_5879_4399# _32_.A 0
C2295 _53_.Y a_3316_5321# 0
C2296 u_loop.u_q.Y _55_.D 0.00258f
C2297 u_loop.u_qb.A u_loop.u_q.B 0.0623f
C2298 a_3491_5247# a_2235_4949# 0.04359f
C2299 a_7364_7663# _46_.A 0
C2300 a_2751_5321# a_2235_4949# 0.11053f
C2301 a_5541_9673# a_4517_9301# 0
C2302 _23_.A a_2360_7119# 0
C2303 _23_.A a_2564_6397# 0
C2304 a_5293_7439# _41_.C1 0
C2305 a_2277_7663# VPWR 0
C2306 en _34_.X 0.09492f
C2307 _23_.Y a_1775_4399# 0
C2308 a_6097_4641# _32_.A 0
C2309 _32_.A a_5529_4399# 0
C2310 en a_3436_6549# 0
C2311 _23_.A _20_.A 0.03086f
C2312 a_7385_3829# VPWR 0.21156f
C2313 a_5805_2767# a_5875_2223# 0
C2314 _45_.A a_6449_7663# 0.02384f
C2315 a_8165_5309# _25_.A 0
C2316 _53_.Y a_3491_5247# 0
C2317 _53_.Y a_2751_5321# 0.00207f
C2318 _55_.CLK _56_.CLK 0.01416f
C2319 _55_.CLK _41_.X 0
C2320 _41_.C1 a_3578_6397# 0
C2321 a_2235_4949# a_2969_4917# 0.07009f
C2322 output7.A a_2769_2223# 0.0012f
C2323 _36_.A a_3992_7235# 0
C2324 a_6244_8751# _39_.B2 0
C2325 src[0] a_3348_7235# 0
C2326 a_2401_4949# _28_.Y 0.23011f
C2327 en a_3196_6733# 0
C2328 a_8643_7423# VPWR 0.45347f
C2329 en a_3070_6549# 0
C2330 _35_.A_N a_2360_7119# 0.00594f
C2331 u_loop.u_gl.A2 u_loop.u_gh.C 0.01277f
C2332 _35_.A_N a_2564_6397# 0
C2333 a_2553_4399# u_loop.u_gh.C 0.00203f
C2334 _31_.Y a_6557_8993# 0
C2335 a_7551_5853# a_6651_3861# 0
C2336 a_2401_4949# a_2235_4949# 0.9011f
C2337 u_loop.u_s1.Y a_5764_2223# 0
C2338 src[0] _34_.X 0
C2339 _53_.Y a_2969_4917# 0.00138f
C2340 a_7553_7125# a_8121_7093# 0.18639f
C2341 _20_.A _35_.A_N 0.00172f
C2342 _62_.D u_loop.u_gh.C 0.06942f
C2343 a_2766_9427# _62_.D 0
C2344 _55_.RESET_B a_6987_6409# 0
C2345 _41_.C1 a_3333_6409# 0
C2346 a_4975_9295# a_4517_9301# 0.03462f
C2347 _20_.Y _28_.A 0.00108f
C2348 x output7.A 0
C2349 _63_.Q _63_.CLK 0.01339f
C2350 _56_.D _56_.CLK 0.20629f
C2351 _50_.Y a_2603_8213# 0.23971f
C2352 u_loop.u_d6.X a_6633_2767# 0.00315f
C2353 en a_2563_6575# 0.0042f
C2354 _32_.A a_5363_4399# 0
C2355 u_loop.u_d5.X u_loop.u_d4.X 0.00342f
C2356 a_2401_4949# _53_.Y 0.01602f
C2357 u_loop.u_cmp.Y a_5764_2223# 0
C2358 a_5190_7439# _34_.X 0
C2359 _35_.A_N a_4158_7235# 0.00151f
C2360 u_loop.u_q.B u_loop.u_s1.Y 0.00107f
C2361 u_loop.u_q.B a_6457_2473# 0
C2362 a_4075_2223# a_2769_2223# 0
C2363 a_4510_3311# input5.X 0.00128f
C2364 a_5989_8751# a_5823_8751# 0.90596f
C2365 _36_.A VPWR 2.06691f
C2366 _28_.Y a_2235_4949# 0.28344f
C2367 input5.X a_5764_2223# 0.04838f
C2368 a_7705_5487# _25_.Y 0
C2369 u_loop.u_gh.B a_4518_6575# 0
C2370 a_5293_7439# a_5377_7439# 0.06696f
C2371 u_loop.u_gh.B _56_.CLK 0.00346f
C2372 a_2767_6031# a_1941_4399# 0
C2373 _25_.Y a_7539_5487# 0
C2374 a_4076_3561# output7.A 0.16951f
C2375 a_6817_3861# VPWR 0.58541f
C2376 u_loop.u_cmp.Y u_loop.u_q.B 0
C2377 _23_.A a_3215_8585# 0
C2378 _32_.A a_7539_7637# 0
C2379 a_7999_5321# _25_.A 0.00238f
C2380 a_3361_2767# u_loop.u_d1.X 0.00671f
C2381 _63_.CLK a_1665_7663# 0.17344f
C2382 a_6339_8751# VPWR 0.22409f
C2383 _41_.B1 a_4369_6351# 0.00126f
C2384 _30_.Y _48_.Y 0.01237f
C2385 a_5805_2767# VPWR 0.34192f
C2386 _53_.Y _28_.Y 0.05934f
C2387 _63_.D a_2755_7637# 0
C2388 _45_.A a_5293_7439# 0
C2389 _41_.C1 a_4158_7235# 0
C2390 u_loop.u_q.B input5.X 0.06962f
C2391 en VPWR 0.20727f
C2392 _63_.Q _40_.B 0
C2393 x a_4075_2223# 0
C2394 a_2387_4399# u_loop.u_gh.C 0
C2395 a_2479_9269# a_2755_7637# 0
C2396 en a_2452_6575# 0.00735f
C2397 a_3215_8585# a_3024_8573# 0
C2398 u_loop.u_gh.C a_3018_4765# 0
C2399 a_7808_5309# _25_.A 0.00622f
C2400 _53_.Y a_2235_4949# 0.26425f
C2401 _55_.RESET_B a_7903_5321# 0.01133f
C2402 _56_.D u_loop.u_d5.X 0
C2403 a_6381_3561# u_loop.u_cmp.Y 0
C2404 a_2509_4641# a_2564_6397# 0
C2405 a_7808_5309# _56_.Q 0
C2406 u_loop.u_d7.X prenh 0
C2407 a_5175_2767# a_5069_2767# 0.41909f
C2408 a_3859_8511# _38_.X 0
C2409 output7.A a_4075_2223# 0.23662f
C2410 _55_.RESET_B a_8121_4917# 0
C2411 a_7364_7663# a_6799_7663# 0
C2412 a_4333_2767# u_loop.u_d4.X 0.01908f
C2413 _55_.CLK _25_.A 0
C2414 _22_.Y _32_.Y 0
C2415 en a_2235_6575# 0.19759f
C2416 a_6283_7663# _39_.B2 0
C2417 _40_.B a_1665_7663# 0
C2418 src[0] VPWR 0.42479f
C2419 _56_.D a_5190_5487# 0
C2420 _68_.D a_6704_7663# 0
C2421 a_8183_5461# a_8468_5321# 0
C2422 a_3859_8511# _35_.B 0
C2423 _55_.RESET_B a_7553_4949# 0.0021f
C2424 _55_.CLK _56_.Q 0.23668f
C2425 a_6375_6037# _22_.Y 0
C2426 a_3337_8181# a_3239_9269# 0
C2427 a_6449_7663# a_6557_8993# 0
C2428 a_2399_4765# u_loop.u_gh.C 0.01288f
C2429 VPWR a_6651_3861# 0.48063f
C2430 a_1920_7663# a_2015_7663# 0.04983f
C2431 a_2769_8213# a_3083_9537# 0.00128f
C2432 _55_.RESET_B a_7387_4949# 0.00825f
C2433 _20_.A a_1941_4399# 0
C2434 _55_.RESET_B _25_.Y 0.00722f
C2435 a_5190_7439# VPWR 0.60782f
C2436 a_2196_4399# u_loop.u_gh.C 0
C2437 _30_.Y a_3083_9537# 0.16462f
C2438 a_3044_9411# _23_.A 0
C2439 x u_loop.u_cmp.Y 0
C2440 _55_.RESET_B _39_.B2 0
C2441 src[1] a_1407_7119# 0.19236f
C2442 a_5691_3829# VPWR 0.33399f
C2443 a_2856_4399# u_loop.u_gh.C 0.2371f
C2444 a_4351_9301# a_4772_9661# 0.08341f
C2445 src[0] a_2235_6575# 0
C2446 a_6619_4373# a_6633_2767# 0
C2447 a_2769_8213# a_3170_9295# 0
C2448 a_6444_4399# a_6633_2767# 0
C2449 _45_.A a_7387_7125# 0.00374f
C2450 a_2861_2767# a_2875_2223# 0.01305f
C2451 _56_.D _25_.A 0
C2452 _30_.Y a_3170_9295# 0
C2453 a_6553_4399# VPWR 0
C2454 _23_.A a_3846_8207# 0
C2455 x input5.X 0.03492f
C2456 _55_.RESET_B _42_.Y 0.13327f
C2457 a_8008_5487# a_7903_5321# 0.00135f
C2458 u_loop.u_qb.A u_loop.u_s1.Y 0.09431f
C2459 a_3044_9411# a_3024_8573# 0
C2460 _41_.B1 a_4032_7351# 0
C2461 a_8643_5247# a_8183_5461# 0.01237f
C2462 a_2553_4399# u_loop.u_d0.X 0
C2463 _56_.D _56_.Q 0.18211f
C2464 output7.A u_loop.u_cmp.Y 0
C2465 a_6907_8029# _46_.A 0
C2466 a_4076_3561# u_loop.u_cmp.Y 0
C2467 a_1735_7119# a_1665_7663# 0
C2468 a_7903_5321# a_8183_5461# 0
C2469 a_8008_5487# a_8121_4917# 0.00104f
C2470 _20_.A a_1775_4399# 0.00167f
C2471 output7.A input5.X 0.00224f
C2472 u_loop.u_qb.A u_loop.u_cmp.Y 0
C2473 a_1499_7663# _50_.Y 0.00406f
C2474 a_3119_8585# _63_.Q 0.00265f
C2475 a_5293_7439# _41_.B1 0.01678f
C2476 a_8121_4917# a_8183_5461# 0
C2477 a_8008_5487# a_7553_4949# 0.00598f
C2478 u_loop.u_qb.A input5.X 0
C2479 a_3031_4373# u_loop.u_gh.C 0.35635f
C2480 _55_.D VPWR 0.47083f
C2481 a_4510_3311# output6.A 0.00404f
C2482 a_7903_5321# a_7443_5487# 0
C2483 _45_.A a_7631_6335# 0
C2484 u_loop.u_d7.X a_6739_2767# 0.1316f
C2485 output6.A a_5764_2223# 0.00258f
C2486 u_loop.u_gl.B1 a_4510_3311# 0
C2487 a_6141_4399# VPWR 0.00258f
C2488 a_7553_4949# a_8183_5461# 0.0025f
C2489 a_5989_8751# _22_.Y 0
C2490 u_loop.u_gh.B _28_.A 0
C2491 a_8008_5487# a_7387_4949# 0
C2492 _46_.Y _34_.X 0
C2493 _45_.A a_6891_6409# 0
C2494 _42_.Y a_7348_5487# 0
C2495 a_5975_4399# VPWR 0.00524f
C2496 a_3802_9295# _21_.Y 0
C2497 u_loop.u_d6.X a_5911_2767# 0.14526f
C2498 _63_.CLK a_1407_7119# 0.00563f
C2499 _32_.A _22_.Y 0
C2500 _55_.RESET_B a_8011_7119# 0.01573f
C2501 _27_.Y _20_.A 0
C2502 src[1] _35_.B 0.0012f
C2503 a_7903_5321# a_7093_5487# 0
C2504 VPWR a_8121_7093# 0.21256f
C2505 _46_.A _31_.Y 0.30033f
C2506 a_7387_4949# a_8183_5461# 0
C2507 a_5879_4399# _57_.CLK 0
C2508 a_3670_5309# _28_.A 0.00198f
C2509 a_4075_2223# input5.X 0
C2510 a_2387_4399# u_loop.u_d0.X 0
C2511 a_6606_4765# VPWR 0
C2512 output6.A u_loop.u_q.B 0.00796f
C2513 _23_.A u_loop.u_gh.C 0.76238f
C2514 _23_.A a_2766_9427# 0
C2515 a_1624_7119# a_1665_7663# 0
C2516 a_3425_5321# _28_.A 0
C2517 a_7553_4949# a_7443_5487# 0.00133f
C2518 _47_.Y _39_.B2 0.15621f
C2519 a_8121_4917# a_7093_5487# 0.00144f
C2520 a_7079_8725# _39_.X 0
C2521 u_loop.u_d4.X a_5069_2767# 0.00315f
C2522 a_1499_6575# en 0.02746f
C2523 a_3024_8573# u_loop.u_gh.C 0
C2524 u_loop.u_d3.X a_4439_2767# 0
C2525 _53_.A _20_.A 0
C2526 a_6097_4641# _57_.CLK 0
C2527 a_2291_4399# u_loop.u_gh.C 0.15343f
C2528 a_4292_2223# prenh 0
C2529 a_3013_5309# _28_.A 0.00232f
C2530 _57_.CLK a_5529_4399# 0
C2531 u_loop.u_cmp.Y u_loop.u_s1.Y 0.09545f
C2532 output6.A a_6381_3561# 0
C2533 a_7387_4949# a_7443_5487# 0.01253f
C2534 a_7443_5487# _25_.Y 0
C2535 a_1499_7663# _20_.Y 0
C2536 a_7553_4949# a_7661_5729# 0
C2537 a_7553_4949# a_7093_5487# 0.00905f
C2538 a_3388_7351# _40_.B 0.02306f
C2539 u_loop.u_q.Y u_loop.u_d6.X 0.0214f
C2540 a_3684_8585# _50_.Y 0
C2541 _35_.A_N u_loop.u_gh.C 0.09711f
C2542 output7.A a_3361_2767# 0.00463f
C2543 a_7387_7125# a_8577_7497# 0
C2544 input5.X u_loop.u_s1.Y 0.00259f
C2545 en _34_.B1 0.03093f
C2546 a_7387_4949# a_7661_5729# 0
C2547 a_6927_5487# a_7903_5321# 0
C2548 _25_.Y a_7661_5729# 0.00328f
C2549 a_7387_4949# a_7093_5487# 0.00965f
C2550 _42_.Y a_7443_5487# 0
C2551 _25_.Y a_7093_5487# 0
C2552 a_2233_7905# _63_.CLK 0.0028f
C2553 a_4167_6147# _23_.A 0.01413f
C2554 _23_.A a_3224_6409# 0.02683f
C2555 a_6799_7663# _67_.D 0
C2556 a_1499_6575# src[0] 0
C2557 _50_.Y a_2471_7119# 0
C2558 a_6541_6037# _36_.A 0
C2559 a_3430_7235# _40_.B 0
C2560 a_6799_7663# a_6999_6031# 0
C2561 a_7553_7125# _68_.D 0.23675f
C2562 u_loop.u_cmp.Y input5.X 0.10994f
C2563 a_6927_5487# a_8121_4917# 0.00104f
C2564 a_6435_8751# a_6339_8751# 0.01379f
C2565 a_1920_7663# VPWR 0.09177f
C2566 _42_.Y a_7661_5729# 0
C2567 _42_.Y a_7093_5487# 0
C2568 _68_.D a_7715_6575# 0.00181f
C2569 a_7618_6031# _67_.Q 0
C2570 _23_.A a_3399_6335# 0.10983f
C2571 _63_.CLK _35_.B 0
C2572 _63_.D a_2769_8213# 0
C2573 _41_.C1 u_loop.u_gh.C 0.01719f
C2574 u_loop.u_d2.X u_loop.u_d3.X 0.00342f
C2575 a_2603_8213# a_3239_9269# 0
C2576 a_7618_6031# xb 0
C2577 a_6907_8029# a_6799_7663# 0.05722f
C2578 _46_.Y VPWR 0.47211f
C2579 a_2603_8213# a_3859_8511# 0.04359f
C2580 a_2479_9269# a_2769_8213# 0
C2581 a_6927_5487# a_7553_4949# 0
C2582 x output6.A 0.11565f
C2583 _30_.Y a_2479_9269# 0
C2584 src[0] _34_.B1 0
C2585 _35_.A_N a_3224_6409# 0
C2586 a_4167_6147# _35_.A_N 0.17814f
C2587 a_2847_5321# _28_.A 0.00488f
C2588 _45_.A _68_.Q 0.00249f
C2589 a_3031_4373# a_2309_6037# 0
C2590 _23_.Y _20_.Y 0.01654f
C2591 _45_.A _32_.Y 0
C2592 a_1735_7119# a_1407_7119# 0
C2593 a_6904_8751# _31_.Y 0
C2594 a_6283_7663# _39_.X 0.01166f
C2595 a_6895_7663# a_7017_7905# 0
C2596 a_6927_5487# a_7387_4949# 0.00105f
C2597 _40_.B _38_.X 0.03698f
C2598 a_6927_5487# _25_.Y 0
C2599 a_7631_6335# a_8011_4943# 0
C2600 a_7604_6575# _68_.D 0.01413f
C2601 _23_.A a_2659_6409# 0.00483f
C2602 output7.A output6.A 0.04177f
C2603 a_4097_2767# u_loop.u_d0.X 0
C2604 _45_.A a_6375_6037# 0
C2605 _56_.D a_5569_2767# 0
C2606 _35_.A_N a_3399_6335# 0.00887f
C2607 a_4076_3561# output6.A 0.00456f
C2608 u_loop.u_gl.B1 output7.A 0.3046f
C2609 a_6449_7663# _46_.A 0.00879f
C2610 _67_.D a_7618_6031# 0
C2611 _40_.B _35_.B 0.2215f
C2612 a_6927_5487# _42_.Y 0.00757f
C2613 a_8468_5321# _25_.A 0.06365f
C2614 a_2877_6005# _23_.A 0.00845f
C2615 a_4076_3561# u_loop.u_gl.B1 0.0825f
C2616 a_2509_4641# u_loop.u_gh.C 0.16158f
C2617 a_2143_7119# src[1] 0
C2618 u_loop.u_qb.A output6.A 0.00238f
C2619 a_7017_7905# _46_.Y 0
C2620 a_4167_6147# _41_.C1 0.01826f
C2621 _41_.C1 a_3224_6409# 0.00114f
C2622 _23_.A a_2309_6037# 0.03256f
C2623 pre a_1407_7119# 0
C2624 _55_.RESET_B _39_.X 0.00349f
C2625 a_2656_5309# _28_.A 0.02721f
C2626 a_5987_4765# VPWR 0.15775f
C2627 a_2399_4765# _52_.Y 0
C2628 _38_.X _39_.B2 0
C2629 a_3337_8181# _40_.B 0.00836f
C2630 a_7551_5853# _55_.Q 0
C2631 a_3119_8585# a_3388_7351# 0
C2632 _35_.A_N a_2659_6409# 0
C2633 a_2196_4399# _52_.Y 0
C2634 a_4292_2223# a_4097_2767# 0.00184f
C2635 u_loop.u_q.Y a_6444_4399# 0
C2636 a_5911_2767# a_5529_4399# 0
C2637 _41_.C1 a_3399_6335# 0.00627f
C2638 a_8468_5321# _67__13.LO 0
C2639 _39_.B2 _35_.B 0
C2640 a_2877_6005# _35_.A_N 0
C2641 output6.A a_4075_2223# 0
C2642 a_1941_4399# u_loop.u_gh.C 0.02774f
C2643 a_1624_7119# a_1407_7119# 0.11296f
C2644 _35_.A_N a_2309_6037# 0
C2645 u_loop.u_gl.B1 a_4075_2223# 0.00135f
C2646 a_7553_7125# a_7999_7497# 0
C2647 a_8643_5247# _25_.A 0.16364f
C2648 a_7553_7125# a_7903_7497# 0.2298f
C2649 a_5879_4399# u_loop.u_q.Y 0
C2650 a_5805_2767# a_5764_2223# 0.00983f
C2651 a_5989_8751# a_6447_9117# 0.03462f
C2652 a_2859_4943# u_loop.u_gh.C 0.01411f
C2653 a_2769_8213# a_2755_7637# 0.00213f
C2654 a_7715_6575# a_7903_7497# 0
C2655 _45_.A u_loop.u_gh.C 0
C2656 a_1735_7119# _35_.B 0.11822f
C2657 a_5607_9599# a_5432_9673# 0.23366f
C2658 a_7903_5321# _25_.A 0.05506f
C2659 _21_.Y VPWR 0.62437f
C2660 a_5784_4399# VPWR 0.08497f
C2661 a_6739_2767# a_6633_2767# 0.41909f
C2662 a_6097_4641# u_loop.u_q.Y 0.00186f
C2663 _56_.Q a_7903_5321# 0
C2664 u_loop.u_q.Y a_5529_4399# 0.00114f
C2665 u_loop.u_q.B a_5805_2767# 0.01114f
C2666 a_4975_9295# _39_.B2 0.00365f
C2667 a_8121_4917# _25_.A 0.05319f
C2668 _21_.Y _30_.A 0.00164f
C2669 _45_.A a_5989_8751# 0
C2670 a_1775_4399# u_loop.u_gh.C 0.29734f
C2671 _41_.C1 a_2309_6037# 0
C2672 output6.A u_loop.u_s1.Y 0.00501f
C2673 a_5190_5487# _39_.B2 0
C2674 _23_.A a_2143_6037# 0.03473f
C2675 a_5363_4399# a_5911_2767# 0
C2676 a_2742_8029# u_loop.u_gh.C 0
C2677 a_4333_2767# a_4439_2767# 0.41909f
C2678 a_3044_9411# a_3000_9295# 0
C2679 _55_.RESET_B a_8362_5487# 0.00288f
C2680 _56_.Q a_8121_4917# 0
C2681 a_6244_8751# _55_.RESET_B 0
C2682 a_6283_7663# a_7079_8725# 0
C2683 _45_.A _32_.A 0.00291f
C2684 _41_.B1 _32_.Y 0
C2685 a_8577_7497# _68_.Q 0.00105f
C2686 pre _35_.B 0.00449f
C2687 a_7553_4949# _25_.A 0.37343f
C2688 a_4074_7235# a_4032_7351# 0.00657f
C2689 a_8121_7093# a_8630_7119# 0
C2690 output6.A u_loop.u_cmp.Y 0.01605f
C2691 _56_.Q a_7553_4949# 0
C2692 u_loop.u_gl.B1 u_loop.u_cmp.Y 0
C2693 a_6557_8993# a_7013_8751# 0
C2694 a_3119_8585# _35_.B 0
C2695 a_7387_4949# _25_.A 0.34825f
C2696 _25_.A _25_.Y 0.17544f
C2697 _23_.A _52_.Y 0.06569f
C2698 output6.A input5.X 0.35925f
C2699 a_8800_6031# a_8468_5321# 0
C2700 a_3491_5247# _35_.B 0
C2701 a_4292_2223# a_4910_2197# 0
C2702 _23_.A a_1735_6031# 0
C2703 a_1624_6031# _23_.A 0
C2704 a_8468_5321# a_8583_6031# 0
C2705 _35_.A_N a_2143_6037# 0
C2706 a_8468_5321# _67_.Q 0
C2707 a_7079_8725# _55_.RESET_B 0.27968f
C2708 input5.X a_4769_4175# 0
C2709 _56_.Q a_7387_4949# 0.0025f
C2710 u_loop.u_gl.B1 input5.X 0
C2711 _56_.Q _25_.Y 0.00405f
C2712 u_loop.u_gh.C u_loop.u_d0.A 0.02466f
C2713 _27_.Y u_loop.u_gh.C 0.00473f
C2714 a_1624_7119# _35_.B 0.02914f
C2715 a_5691_3829# a_5764_2223# 0
C2716 a_2509_4641# a_2309_6037# 0
C2717 _56_.Q _39_.B2 0
C2718 u_loop.u_q.Y u_loop.u_gl.A2 0.01255f
C2719 a_3337_8181# a_3119_8585# 0.20964f
C2720 u_loop.u_q.Y a_5363_4399# 0.00906f
C2721 a_7553_4949# _67__13.LO 0.00112f
C2722 _42_.Y _25_.A 0.01522f
C2723 _52_.Y a_2291_4399# 0
C2724 _55_.RESET_B a_8117_5487# 0
C2725 a_6449_7663# a_6799_7663# 0.2298f
C2726 a_3549_9661# a_3239_9269# 0.01379f
C2727 a_1941_4399# a_2659_6409# 0
C2728 a_7705_5487# _55_.RESET_B 0.0022f
C2729 _55_.Q VPWR 0.59366f
C2730 _56_.Q _42_.Y 0.00125f
C2731 a_7387_4949# _67__13.LO 0
C2732 a_2603_8213# _63_.CLK 0
C2733 en _63_.D 0
C2734 _22_.Y _57_.CLK 0
C2735 a_8643_5247# a_8911_6031# 0
C2736 u_loop.u_d6.X VPWR 0.4266f
C2737 _52_.Y _35_.A_N 0
C2738 _53_.A u_loop.u_gh.C 0.5535f
C2739 _55_.RESET_B a_7539_5487# 0.00133f
C2740 _35_.A_N a_1735_6031# 0.00121f
C2741 _68_.D VPWR 0.38202f
C2742 a_2509_4641# u_loop.u_d0.X 0
C2743 a_2877_6005# a_1941_4399# 0
C2744 a_7732_4233# a_7894_3855# 0.00645f
C2745 a_8800_6031# a_8643_5247# 0
C2746 a_3477_9661# a_3239_9269# 0.00171f
C2747 a_1941_4399# a_2309_6037# 0
C2748 a_8643_5247# a_8583_6031# 0
C2749 a_8643_5247# _67_.Q 0
C2750 a_4076_3561# _36_.A 0
C2751 a_8170_5853# _55_.RESET_B 0
C2752 _22_.Y a_6704_7663# 0.15942f
C2753 a_8643_5247# xb 0
C2754 _20_.Y a_2564_6397# 0
C2755 a_5607_9599# a_4517_9301# 0.04251f
C2756 a_7553_7125# _68__14.LO 0
C2757 a_4833_2767# VPWR 0.28767f
C2758 _23_.A a_3514_7235# 0
C2759 _41_.B1 u_loop.u_gh.C 0
C2760 a_3000_9295# u_loop.u_gh.C 0
C2761 a_3000_9295# a_2766_9427# 0.00645f
C2762 a_8183_5461# a_8362_5487# 0.0074f
C2763 _20_.A _20_.Y 0.20022f
C2764 prenl u_loop.u_gl.A2 0
C2765 u_loop.u_gh.C a_8011_4943# 0.0122f
C2766 _63_.D src[0] 0
C2767 a_7553_7125# a_7539_7637# 0.00866f
C2768 a_1735_7119# a_2143_7119# 0
C2769 a_8086_4221# a_7907_4159# 0.0074f
C2770 u_loop.u_q.Y prenh 0
C2771 a_2603_8213# _40_.B 0.01288f
C2772 a_3684_8585# a_3859_8511# 0.23366f
C2773 a_7841_4233# a_7732_4233# 0.00742f
C2774 a_7167_4233# a_7275_3855# 0.05722f
C2775 _25_.A a_8011_7119# 0
C2776 a_7017_7905# _68_.D 0
C2777 a_6283_7663# _55_.RESET_B 0.33072f
C2778 a_8822_5309# u_loop.u_gh.C 0.00288f
C2779 a_3316_5321# _28_.A 0.03889f
C2780 _39_.X a_6927_5487# 0
C2781 _55_.RESET_B a_5377_5487# 0
C2782 a_5293_5487# a_5377_5487# 0.06696f
C2783 _32_.A _41_.B1 0
C2784 a_7539_5487# a_7348_5487# 0
C2785 u_loop.u_q.Y a_5547_2223# 0
C2786 _63_.Q a_1665_7663# 0.00107f
C2787 a_3514_7235# _35_.A_N 0
C2788 a_8008_5487# a_8117_5487# 0.00742f
C2789 a_7553_4949# _67_.Q 0
C2790 _39_.X _41_.X 0
C2791 a_7553_4949# a_8583_6031# 0
C2792 _23_.A a_4075_6825# 0
C2793 a_2123_8029# _63_.CLK 0.00272f
C2794 _67_.D a_7903_5321# 0
C2795 a_7604_6575# a_7539_7637# 0
C2796 a_4351_9301# a_5541_9673# 0
C2797 a_1499_7663# src[1] 0
C2798 a_5989_8751# a_6557_8993# 0.18639f
C2799 _35_.A_N _57_.CLK 0
C2800 a_4167_6147# _41_.B1 0
C2801 a_7539_7637# a_7387_6575# 0.0012f
C2802 _55_.RESET_B a_8165_7485# 0.00399f
C2803 a_7387_4949# _67_.Q 0
C2804 a_7387_4949# a_8583_6031# 0
C2805 a_7072_4221# a_7263_4233# 0
C2806 a_3491_5247# _28_.A 0.14714f
C2807 a_2509_4641# _52_.Y 0
C2808 a_2751_5321# _28_.A 0.03675f
C2809 u_loop.u_q.Y a_5276_2197# 0
C2810 a_1941_4399# a_2143_6037# 0
C2811 a_8170_5853# a_8008_5487# 0.00645f
C2812 _48_.Y _21_.Y 0.03662f
C2813 prenl prenh 0.40649f
C2814 a_7894_3855# a_7385_3829# 0
C2815 a_2143_7119# a_1624_7119# 0.00157f
C2816 a_4075_6825# _35_.A_N 0.03676f
C2817 _39_.X _35_.B 0
C2818 u_loop.u_d0.X a_2967_2767# 0
C2819 _35_.A_N a_5389_7119# 0
C2820 a_7385_3829# a_7275_3855# 0.09774f
C2821 a_7072_4221# output6.A 0
C2822 VPWR a_7903_7497# 0.20713f
C2823 _28_.A a_2969_4917# 0.02237f
C2824 a_7705_5487# a_7443_5487# 0.00171f
C2825 a_6619_4373# VPWR 0.39084f
C2826 a_6444_4399# VPWR 0.28306f
C2827 _35_.A_N a_1654_6575# 0.01706f
C2828 a_1941_4399# _52_.Y 0
C2829 a_7443_5487# a_7539_5487# 0.01379f
C2830 u_loop.u_s1.Y a_5805_2767# 0.0018f
C2831 a_3859_8511# a_4032_7351# 0
C2832 _67_.D a_7387_4949# 0
C2833 _67_.D _25_.Y 0
C2834 a_7066_9117# a_6557_8993# 0
C2835 u_loop.u_d0.X u_loop.u_d0.A 0.00133f
C2836 a_8117_5487# a_7661_5729# 0
C2837 a_8117_5487# a_7093_5487# 0
C2838 output6.A a_4769_4175# 0.15617f
C2839 output6.A a_4351_4175# 0.02865f
C2840 u_loop.u_gl.B1 output6.A 0.0034f
C2841 a_2401_4949# _28_.A 0.02703f
C2842 a_4351_9301# a_4975_9295# 0
C2843 a_7841_4233# a_7385_3829# 0
C2844 a_5879_4399# VPWR 0.23856f
C2845 a_4351_4175# a_4769_4175# 0.13998f
C2846 a_7705_5487# a_7661_5729# 0
C2847 u_loop.u_gl.B1 a_4351_4175# 0.01626f
C2848 a_7429_4221# a_7167_4233# 0.00171f
C2849 a_4075_6825# _41_.C1 0.01314f
C2850 _55_.RESET_B a_7348_5487# 0.02391f
C2851 a_7539_5487# a_7661_5729# 0
C2852 a_7539_5487# a_7093_5487# 0
C2853 u_loop.u_cmp.Y a_5805_2767# 0.00223f
C2854 _67_.D _42_.Y 0
C2855 a_7167_4233# a_7263_4233# 0.01379f
C2856 a_5190_5487# _39_.X 0
C2857 a_7072_4221# a_7167_4233# 0.04983f
C2858 u_loop.u_q.Y a_6739_2767# 0.01141f
C2859 a_1499_7663# _63_.CLK 0.44838f
C2860 _53_.A u_loop.u_d0.X 0
C2861 a_3119_8585# a_2603_8213# 0.11261f
C2862 a_2861_2767# u_loop.u_gh.C 0
C2863 a_8170_5853# a_7661_5729# 0
C2864 _55_.RESET_B a_8008_5487# 0.23312f
C2865 a_4097_2767# a_3597_2767# 0
C2866 a_8170_5853# a_7093_5487# 0
C2867 a_4403_2223# u_loop.u_gh.C 0
C2868 input5.X a_5805_2767# 0.0182f
C2869 a_6097_4641# VPWR 0.2447f
C2870 VPWR a_5529_4399# 0.54609f
C2871 _52_.Y a_1775_4399# 0
C2872 _21_.Y a_3083_9537# 0
C2873 a_4292_2223# u_loop.u_d0.A 0
C2874 a_7364_7663# _39_.X 0
C2875 a_7732_4233# a_7907_4159# 0.23366f
C2876 _28_.Y _28_.A 0.53448f
C2877 _55_.RESET_B a_8183_5461# 0.28027f
C2878 a_7894_3855# a_6817_3861# 0
C2879 _46_.A a_7013_8751# 0
C2880 _27_.Y a_2143_6037# 0
C2881 a_6927_5487# a_8117_5487# 0
C2882 _49_.Y a_4517_9301# 0
C2883 a_2235_4949# _28_.A 0.16909f
C2884 _47_.Y _55_.RESET_B 0
C2885 a_6817_3861# a_7275_3855# 0.03462f
C2886 a_6987_6409# a_6796_6397# 0
C2887 a_7732_4233# a_7167_4233# 0
C2888 a_5594_9295# u_loop.u_gh.C 0
C2889 a_5875_2223# prenh 0
C2890 a_7553_7125# _22_.Y 0
C2891 a_8577_5321# u_loop.u_gh.C 0
C2892 a_1499_7663# _40_.B 0
C2893 a_7429_4221# a_7385_3829# 0
C2894 a_7705_5487# _56_.CLK 0
C2895 _36_.A a_4518_6825# 0
C2896 _56_.CLK a_7539_5487# 0
C2897 _53_.Y _28_.A 0.0696f
C2898 _55_.RESET_B a_7443_5487# 0.17327f
C2899 _50_.Y u_loop.u_gh.C 0
C2900 a_7385_3829# a_7263_4233# 0
C2901 _27_.Y _52_.Y 0
C2902 a_1735_6031# u_loop.u_d0.A 0
C2903 a_5875_2223# a_5547_2223# 0
C2904 _31_.Y _39_.B2 0.02594f
C2905 a_1624_6031# u_loop.u_d0.A 0
C2906 a_7841_4233# a_6817_3861# 0
C2907 a_6891_6409# a_6799_7663# 0
C2908 u_loop.u_gl.A2 VPWR 0.5827f
C2909 a_5363_4399# VPWR 0.47189f
C2910 _45_.A _57_.CLK 0.15229f
C2911 _63_.D a_1920_7663# 0.15888f
C2912 a_5691_3829# u_loop.u_cmp.Y 0.00216f
C2913 a_2553_4399# VPWR 0
C2914 a_5377_7439# a_5389_7119# 0
C2915 _55_.RESET_B a_7661_5729# 0.16462f
C2916 _55_.RESET_B a_7093_5487# 0.07477f
C2917 _68__14.LO VPWR 0.50684f
C2918 _62_.D VPWR 0.47052f
C2919 _45_.A a_6704_7663# 0.02535f
C2920 _53_.A _52_.Y 0
C2921 a_6397_2767# u_loop.u_d7.X 0.00526f
C2922 a_7456_6409# a_7618_6031# 0.00645f
C2923 a_6541_6037# _55_.Q 0
C2924 a_5823_8751# VPWR 0.54234f
C2925 a_1624_6031# _53_.A 0
C2926 a_1407_6031# _27_.Y 0
C2927 a_5432_9673# u_loop.u_gh.C 0.23506f
C2928 a_7539_7637# VPWR 0.41946f
C2929 a_8008_5487# a_8183_5461# 0.23366f
C2930 a_7732_4233# a_7385_3829# 0.05116f
C2931 _62_.D _30_.A 0
C2932 u_loop.u_q.Y a_4910_2197# 0
C2933 a_7473_7663# a_7017_7905# 0
C2934 a_5085_9269# u_loop.u_gh.C 0.1665f
C2935 a_1499_7663# a_1735_7119# 0.00414f
C2936 _56_.CLK a_5377_5487# 0.00862f
C2937 _41_.X a_5377_5487# 0
C2938 a_7275_3855# a_6651_3861# 0
C2939 _35_.A_N a_1845_6825# 0
C2940 a_7443_5487# a_7348_5487# 0.04983f
C2941 a_8362_5487# _25_.A 0
C2942 a_1407_6031# _53_.A 0
C2943 a_3044_9411# a_4517_9301# 0.00469f
C2944 a_7109_6005# a_6799_7663# 0
C2945 a_5175_2767# u_loop.u_d7.X 0
C2946 a_8165_5309# u_loop.u_gh.C 0.00316f
C2947 a_2233_7905# _63_.Q 0.00479f
C2948 a_7167_4233# a_7385_3829# 0.20964f
C2949 a_6904_8751# a_7013_8751# 0.00742f
C2950 a_3684_8585# _40_.B 0.05808f
C2951 _55_.RESET_B a_6927_5487# 0.59364f
C2952 VPWR prenh 0.1765f
C2953 a_8008_5487# a_7443_5487# 0
C2954 _20_.Y u_loop.u_gh.C 0
C2955 a_7093_5487# a_7348_5487# 0.06418f
C2956 u_loop.u_q.Y _41_.C1 0
C2957 a_2580_7663# _62_.D 0.00731f
C2958 _23_.A a_2015_7663# 0
C2959 a_6817_3861# a_7263_4233# 0
C2960 _55_.RESET_B _56_.CLK 0.0096f
C2961 a_7841_4233# a_6651_3861# 0
C2962 _55_.RESET_B _41_.X 0.00226f
C2963 a_7072_4221# a_6817_3861# 0.06418f
C2964 a_5293_5487# _56_.CLK 0.00156f
C2965 a_5989_8751# _46_.A 0.02004f
C2966 a_2387_4399# VPWR 0
C2967 _36_.A output6.A 0
C2968 VPWR a_5547_2223# 0.23401f
C2969 _63_.Q _35_.B 0
C2970 VPWR a_3018_4765# 0
C2971 a_8008_5487# a_7661_5729# 0.05116f
C2972 _36_.A a_4769_4175# 0
C2973 _36_.A a_4351_4175# 0
C2974 a_8008_5487# a_7093_5487# 0.12532f
C2975 _32_.A _46_.A 0
C2976 _22_.Y _34_.X 0
C2977 prenl a_4910_2197# 0.00256f
C2978 output6.A a_6817_3861# 0
C2979 a_2861_2767# u_loop.u_d0.X 0.00219f
C2980 a_2233_7905# a_1665_7663# 0.18639f
C2981 a_3684_8585# _39_.B2 0
C2982 a_3859_8511# _49_.Y 0.001f
C2983 a_8117_5487# _25_.A 0
C2984 a_3337_8181# _63_.Q 0.00101f
C2985 a_5377_5487# a_5389_5737# 0
C2986 _55_.CLK _32_.Y 0
C2987 a_8183_5461# a_7093_5487# 0.04251f
C2988 _35_.A_N a_2015_7663# 0
C2989 a_7705_5487# _25_.A 0.00256f
C2990 _68_.Q a_6799_7663# 0
C2991 a_1499_7663# a_1624_7119# 0.00148f
C2992 a_5276_2197# VPWR 0.2545f
C2993 _25_.A a_7539_5487# 0.00503f
C2994 a_7732_4233# a_6817_3861# 0.12532f
C2995 _55_.CLK a_6375_6037# 0
C2996 _23_.A a_3348_7235# 0.06466f
C2997 a_7109_6005# a_7618_6031# 0
C2998 a_6449_7663# _39_.B2 0
C2999 a_6927_5487# a_7348_5487# 0.08638f
C3000 _35_.B a_1665_7663# 0.00173f
C3001 a_2689_7663# a_1665_7663# 0
C3002 _41_.B1 _57_.CLK 0
C3003 a_6817_3861# a_7907_4159# 0.04251f
C3004 a_5036_2381# a_5069_2767# 0.00572f
C3005 a_6799_7663# a_6375_6037# 0
C3006 _23_.A a_4160_6575# 0.00147f
C3007 _23_.A _34_.X 0.03307f
C3008 _56_.CLK a_7348_5487# 0
C3009 a_5190_5487# a_5377_5487# 0.03258f
C3010 a_7443_5487# a_7661_5729# 0.20964f
C3011 a_7443_5487# a_7093_5487# 0.2298f
C3012 _67_.D _39_.X 0
C3013 a_2399_4765# VPWR 0.14344f
C3014 _23_.A a_3436_6549# 0.02316f
C3015 a_4833_2767# a_4510_3311# 0.00186f
C3016 a_6927_5487# a_8008_5487# 0.10236f
C3017 a_4403_2223# a_4292_2223# 0.34134f
C3018 a_7999_5321# u_loop.u_gh.C 0.0031f
C3019 a_6817_3861# a_7167_4233# 0.2298f
C3020 a_2196_4399# VPWR 0.10446f
C3021 a_4517_9301# u_loop.u_gh.C 0.05391f
C3022 _40_.B a_4032_7351# 0.16131f
C3023 u_loop.u_d6.X u_loop.u_q.B 0.05099f
C3024 pre _23_.Y 0
C3025 a_7364_7663# a_6283_7663# 0.10236f
C3026 a_4075_6825# _41_.B1 0
C3027 _41_.B1 a_5389_7119# 0.00207f
C3028 a_2856_4399# VPWR 0.29659f
C3029 a_3348_7235# _35_.A_N 0.09915f
C3030 a_7072_4221# a_6651_3861# 0.08813f
C3031 a_6927_5487# a_8183_5461# 0.04359f
C3032 a_7093_5487# a_7661_5729# 0.18639f
C3033 _23_.A a_3196_6733# 0.02948f
C3034 _23_.A a_3070_6549# 0.01063f
C3035 _39_.X a_8468_7497# 0
C3036 a_7808_5309# u_loop.u_gh.C 0.01777f
C3037 a_5190_5487# _55_.RESET_B 0
C3038 a_5190_5487# a_5293_5487# 0.02752f
C3039 a_5377_5487# _25_.A 0.02573f
C3040 _35_.A_N _34_.X 0.26667f
C3041 _35_.A_N a_4160_6575# 0.41446f
C3042 a_5649_7119# VPWR 0.00739f
C3043 a_5293_7439# _40_.B 0
C3044 output6.A a_6651_3861# 0
C3045 _35_.A_N a_3436_6549# 0
C3046 a_3070_6549# a_3024_8573# 0
C3047 a_3684_8585# a_3119_8585# 0
C3048 _20_.Y a_2659_6409# 0
C3049 VPWR a_6739_2767# 0.20596f
C3050 _56_.Q a_5377_5487# 0.06831f
C3051 a_7364_7663# _55_.RESET_B 0.23476f
C3052 a_6904_8751# a_5989_8751# 0.12532f
C3053 a_4032_7351# _39_.B2 0
C3054 a_3044_9411# a_3239_9269# 0.21686f
C3055 _23_.A a_3992_7235# 0
C3056 a_5691_3829# output6.A 0.00947f
C3057 a_7808_7485# _39_.X 0
C3058 a_6927_5487# a_7443_5487# 0.10748f
C3059 a_3044_9411# a_3859_8511# 0
C3060 a_5691_3829# a_4351_4175# 0
C3061 _55_.CLK u_loop.u_gh.C 0.02349f
C3062 a_4097_2767# VPWR 0.27248f
C3063 a_7732_4233# a_6651_3861# 0.10236f
C3064 a_5691_3829# u_loop.u_gl.B1 0
C3065 a_2877_6005# _20_.Y 0
C3066 a_3478_4943# u_loop.u_gh.C 0
C3067 a_3348_7235# _41_.C1 0
C3068 _35_.A_N a_3196_6733# 0
C3069 _23_.A a_2563_6575# 0
C3070 a_3070_6549# _35_.A_N 0.00256f
C3071 _22_.Y VPWR 0.47055f
C3072 _20_.Y a_2309_6037# 0
C3073 _55_.RESET_B _25_.A 0.52787f
C3074 a_7443_5487# _56_.CLK 0
C3075 a_7907_4159# a_6651_3861# 0.04359f
C3076 a_5293_5487# _25_.A 0
C3077 a_3031_4373# VPWR 0.43274f
C3078 _45_.A a_7553_7125# 0
C3079 _48_.Y _62_.D 0
C3080 a_6817_3861# a_7385_3829# 0.18639f
C3081 a_6927_5487# a_7661_5729# 0.07009f
C3082 en a_2277_7663# 0
C3083 _41_.C1 _34_.X 0.02247f
C3084 _41_.C1 a_4160_6575# 0.01984f
C3085 a_6927_5487# a_7093_5487# 0.88232f
C3086 a_5293_7439# _39_.B2 0.01482f
C3087 _56_.Q _55_.RESET_B 0.17672f
C3088 a_5607_9599# _39_.B2 0.14137f
C3089 _23_.A a_3227_8207# 0.02097f
C3090 a_2143_7119# _63_.Q 0
C3091 _45_.A a_7715_6575# 0
C3092 _41_.C1 a_3436_6549# 0
C3093 a_5293_5487# _56_.Q 0.01376f
C3094 a_7017_7905# a_7061_7663# 0
C3095 a_3430_7235# a_3388_7351# 0.00657f
C3096 a_7167_4233# a_6651_3861# 0.10821f
C3097 _56_.CLK a_7661_5729# 0
C3098 _39_.X _31_.Y 0
C3099 _55_.D a_7072_4221# 0.17139f
C3100 _55_.CLK _32_.A 0
C3101 _56_.CLK a_7093_5487# 0
C3102 _35_.A_N a_3992_7235# 0.12588f
C3103 _41_.X a_7093_5487# 0.00179f
C3104 a_5989_8751# a_6799_7663# 0
C3105 a_2401_4949# _23_.Y 0
C3106 a_6891_6409# a_6987_6409# 0.01379f
C3107 a_6904_8751# a_7066_9117# 0.00645f
C3108 _35_.A_N a_2563_6575# 0.06109f
C3109 _56_.D u_loop.u_gh.C 0.02308f
C3110 _55_.RESET_B a_7526_8029# 0
C3111 _41_.C1 a_3196_6733# 0
C3112 _32_.A a_6799_7663# 0
C3113 _55_.RESET_B _67__13.LO 0.00134f
C3114 _55_.D output6.A 0
C3115 a_3597_2767# u_loop.u_d0.A 0
C3116 _23_.A VPWR 2.72664f
C3117 a_6397_2767# a_6633_2767# 0.22264f
C3118 _22_.Y a_7017_7905# 0
C3119 u_loop.u_q.Y u_loop.u_d0.A 0.15016f
C3120 _45_.A a_7604_6575# 0
C3121 _45_.A a_7387_6575# 0.0011f
C3122 a_2143_7119# a_1665_7663# 0
C3123 _23_.A _30_.A 0
C3124 a_8170_5853# _67_.Q 0
C3125 VPWR a_3024_8573# 0.07768f
C3126 a_3388_7351# _38_.X 0.16097f
C3127 _25_.A a_7348_5487# 0.02231f
C3128 u_loop.u_gh.B u_loop.u_gh.C 0.15696f
C3129 _23_.Y _28_.Y 0
C3130 _41_.C1 a_3992_7235# 0.11636f
C3131 a_2291_4399# VPWR 0.2085f
C3132 a_6435_8751# a_5823_8751# 0
C3133 a_5649_5737# a_7093_5487# 0
C3134 u_loop.u_qb.A u_loop.u_d6.X 0
C3135 _23_.A a_2235_6575# 0
C3136 a_6927_5487# _56_.CLK 0
C3137 _23_.Y a_2235_4949# 0
C3138 _41_.X a_6927_5487# 0.24679f
C3139 a_8008_5487# _25_.A 0.02144f
C3140 _35_.A_N VPWR 1.76188f
C3141 a_3670_5309# u_loop.u_gh.C 0.00231f
C3142 a_3388_7351# _35_.B 0.17579f
C3143 a_4867_9673# _21_.Y 0.03732f
C3144 a_6907_8029# a_7079_8725# 0
C3145 _20_.Y a_2143_6037# 0.00255f
C3146 _62_.D a_3083_9537# 0.0016f
C3147 a_3239_9269# u_loop.u_gh.C 0.18634f
C3148 _35_.A_N a_2452_6575# 0.05423f
C3149 a_4833_2767# output7.A 0.00394f
C3150 a_1407_7119# _35_.B 0.00422f
C3151 a_3239_9269# a_2766_9427# 0
C3152 a_3859_8511# u_loop.u_gh.C 0.27755f
C3153 _40_.B a_4158_7235# 0
C3154 a_5784_4399# u_loop.u_cmp.Y 0
C3155 a_6541_6037# a_7539_7637# 0
C3156 a_7385_3829# a_6651_3861# 0.07009f
C3157 VPWR a_4910_2197# 0.22847f
C3158 a_2603_8213# _63_.Q 0.16266f
C3159 _55_.D a_7167_4233# 0.00101f
C3160 a_5879_4399# u_loop.u_q.B 0
C3161 a_7109_6005# a_6987_6409# 0
C3162 _41_.X _56_.CLK 0.07639f
C3163 a_3430_7235# _38_.X 0
C3164 _23_.A a_2580_7663# 0.00334f
C3165 a_3425_5321# u_loop.u_gh.C 0
C3166 a_3170_9295# _62_.D 0
C3167 a_7631_6335# a_7903_5321# 0
C3168 _35_.A_N _30_.A 0
C3169 a_8183_5461# _25_.A 0.00277f
C3170 a_3337_8181# a_3388_7351# 0
C3171 u_loop.u_q.Y _41_.B1 0
C3172 _53_.Y _23_.Y 0.00183f
C3173 prenl u_loop.u_d0.A 0
C3174 a_1920_7663# a_2111_7663# 0
C3175 a_6244_8751# _31_.Y 0.16059f
C3176 a_3013_5309# u_loop.u_gh.C 0.0022f
C3177 a_7456_6409# a_7387_4949# 0
C3178 a_3430_7235# _35_.B 0.00191f
C3179 a_7456_6409# _25_.Y 0
C3180 _55_.RESET_B a_8911_6031# 0
C3181 a_2580_7663# a_3024_8573# 0
C3182 _20_.Y _52_.Y 0.0013f
C3183 a_7631_6335# a_8121_4917# 0
C3184 a_5190_5487# a_7093_5487# 0
C3185 _35_.A_N a_2235_6575# 0.06259f
C3186 a_8008_5487# _67__13.LO 0.00388f
C3187 _20_.Y a_1735_6031# 0.00963f
C3188 a_1624_6031# _20_.Y 0.01771f
C3189 _41_.C1 VPWR 0.74405f
C3190 _45_.A _34_.X 0.14347f
C3191 _45_.A a_4160_6575# 0
C3192 a_8800_6031# _55_.RESET_B 0
C3193 a_2603_8213# a_1665_7663# 0.00461f
C3194 a_4518_6575# _35_.B 0.05448f
C3195 _55_.RESET_B _67_.Q 0.02354f
C3196 _55_.RESET_B a_8583_6031# 0.00222f
C3197 a_7443_5487# _25_.A 0.03386f
C3198 _20_.A a_1735_7119# 0
C3199 _55_.RESET_B xb 0
C3200 a_7631_6335# a_7553_4949# 0
C3201 a_8183_5461# _67__13.LO 0.00187f
C3202 _41_.X a_5649_5737# 0
C3203 u_loop.u_d1.X prenh 0
C3204 a_2767_6031# a_2969_4917# 0
C3205 _41_.C1 _30_.A 0
C3206 a_8577_7497# a_7553_7125# 0
C3207 a_6283_7663# _67_.D 0
C3208 a_7079_8725# _31_.Y 0
C3209 a_4510_3311# u_loop.u_gl.A2 0.13437f
C3210 _40_.B _49_.Y 0.27911f
C3211 a_1407_6031# _20_.Y 0.03531f
C3212 a_2233_7905# _35_.B 0
C3213 a_6449_7663# _39_.X 0.00103f
C3214 _25_.A a_7661_5729# 0.02607f
C3215 a_7631_6335# a_7387_4949# 0
C3216 a_2689_7663# a_2233_7905# 0
C3217 _38_.X _35_.B 0.09221f
C3218 _25_.A a_7093_5487# 0.02413f
C3219 a_7631_6335# _25_.Y 0
C3220 _55_.D a_7385_3829# 0.00136f
C3221 a_6891_6409# a_7387_4949# 0
C3222 a_5190_7439# _36_.A 0.11744f
C3223 _56_.Q a_7093_5487# 0
C3224 en src[0] 0.07787f
C3225 a_6283_7663# a_6907_8029# 0
C3226 pre _20_.A 0
C3227 u_loop.u_d3.X a_4333_2767# 0.00315f
C3228 a_2123_8029# _63_.Q 0.00287f
C3229 a_2509_4641# VPWR 0.21171f
C3230 a_6817_3861# a_6651_3861# 0.90082f
C3231 a_6375_6037# a_6987_6409# 0
C3232 a_7631_6335# _42_.Y 0
C3233 _55_.RESET_B _67_.D 0.4379f
C3234 u_loop.u_q.B u_loop.u_gl.A2 0
C3235 a_6891_6409# _42_.Y 0
C3236 a_2847_5321# u_loop.u_gh.C 0
C3237 a_7387_7125# a_8011_7119# 0
C3238 a_5691_3829# a_6817_3861# 0
C3239 a_5190_5487# _56_.CLK 0.00676f
C3240 _55_.RESET_B a_6999_6031# 0.01548f
C3241 a_5190_5487# _41_.X 0.15438f
C3242 _49_.Y _39_.B2 0.00325f
C3243 _57_.CLK _46_.A 0
C3244 a_7348_5487# _67_.Q 0
C3245 a_5691_3829# a_5805_2767# 0
C3246 a_3337_8181# _35_.B 0
C3247 u_loop.u_d6.X input5.X 0.00294f
C3248 _55_.RESET_B a_8468_7497# 0.23159f
C3249 a_6907_8029# _55_.RESET_B 0.02003f
C3250 _20_.A a_1624_7119# 0
C3251 _46_.A a_6704_7663# 0.00168f
C3252 a_6447_9117# VPWR 0.14325f
C3253 a_1941_4399# VPWR 0.6258f
C3254 a_6927_5487# _25_.A 0.10174f
C3255 a_8008_5487# _67_.Q 0.00278f
C3256 a_2123_8029# a_1665_7663# 0.03462f
C3257 a_4510_3311# prenh 0
C3258 a_5377_7439# VPWR 0.00688f
C3259 a_7810_6397# _55_.RESET_B 0.00276f
C3260 a_2143_7119# a_3388_7351# 0
C3261 a_2231_2767# a_2399_4765# 0
C3262 a_5764_2223# prenh 0
C3263 _56_.CLK _25_.A 0.24592f
C3264 _56_.Q a_6927_5487# 0
C3265 a_5879_4399# u_loop.u_qb.A 0.00178f
C3266 _41_.X _25_.A 0.30166f
C3267 a_2656_5309# u_loop.u_gh.C 0.00137f
C3268 _55_.RESET_B a_7565_6409# 0
C3269 a_2859_4943# VPWR 0.14237f
C3270 a_8183_5461# _67_.Q 0.11216f
C3271 a_5190_5487# a_5649_5737# 0.01157f
C3272 a_8183_5461# a_8583_6031# 0.00261f
C3273 a_1499_6575# _23_.A 0
C3274 _55_.Q a_7275_3855# 0
C3275 a_6283_7663# _31_.Y 0
C3276 a_3348_7235# _41_.B1 0
C3277 a_7808_7485# _55_.RESET_B 0.02345f
C3278 _45_.A VPWR 1.00667f
C3279 _56_.Q _56_.CLK 0.21873f
C3280 _56_.Q _41_.X 0.00247f
C3281 a_7109_6005# _42_.Y 0
C3282 a_2196_4399# a_2125_2767# 0
C3283 a_5764_2223# a_5547_2223# 0.11296f
C3284 a_4351_9301# a_5607_9599# 0.04359f
C3285 _67_.D a_7348_5487# 0.15794f
C3286 _55_.D a_6817_3861# 0.22243f
C3287 a_8086_4221# _55_.Q 0
C3288 a_3044_9411# _40_.B 0.00328f
C3289 a_5190_5487# a_5389_5737# 0.0129f
C3290 u_loop.u_q.B prenh 0
C3291 _20_.Y a_1654_6575# 0.0041f
C3292 a_7631_6335# a_8011_7119# 0
C3293 a_6435_8751# _22_.Y 0
C3294 a_6097_4641# u_loop.u_qb.A 0
C3295 _41_.B1 _34_.X 0.21983f
C3296 a_4160_6575# _41_.B1 0.20229f
C3297 u_loop.u_qb.A a_5529_4399# 0
C3298 a_8468_5321# u_loop.u_gh.C 0.2274f
C3299 _55_.RESET_B a_7153_6397# 0.00211f
C3300 _41_.B1 a_3436_6549# 0
C3301 a_1775_4399# VPWR 0.52525f
C3302 a_1499_7663# _63_.Q 0.00804f
C3303 _40_.B a_3846_8207# 0
C3304 _67_.D a_8008_5487# 0
C3305 a_7841_4233# _55_.Q 0
C3306 _23_.A _34_.B1 0
C3307 a_2742_8029# VPWR 0
C3308 a_7443_5487# _67_.Q 0
C3309 u_loop.u_q.B a_5547_2223# 0.00209f
C3310 a_5691_3829# a_6651_3861# 0
C3311 _55_.RESET_B _31_.Y 0.01078f
C3312 a_5129_9661# a_5085_9269# 0
C3313 u_loop.u_d1.X a_4097_2767# 0
C3314 _63_.D _62_.D 0
C3315 a_1499_6575# _35_.A_N 0.17535f
C3316 a_3119_8585# _49_.Y 0
C3317 _28_.Y a_2564_6397# 0
C3318 a_4963_9673# a_5085_9269# 0
C3319 a_3215_8585# a_3119_8585# 0.01379f
C3320 a_2479_9269# _62_.D 0
C3321 a_6449_7663# a_7079_8725# 0
C3322 _48_.Y _35_.A_N 0
C3323 _67_.D a_8183_5461# 0
C3324 VPWR a_2967_2767# 0.19373f
C3325 _56_.Q a_5649_5737# 0.00122f
C3326 a_6375_6037# a_7553_4949# 0
C3327 _45_.A a_7017_7905# 0.02203f
C3328 a_3031_4373# u_loop.u_d1.X 0
C3329 a_7661_5729# _67_.Q 0
C3330 _32_.A a_6987_6409# 0.00474f
C3331 a_7093_5487# _67_.Q 0
C3332 _30_.Y _21_.Y 0.00114f
C3333 a_2233_7905# a_2143_7119# 0.00146f
C3334 _63_.CLK u_loop.u_gh.C 0
C3335 a_2143_7119# _38_.X 0
C3336 _55_.RESET_B xa 0
C3337 a_2603_8213# a_3388_7351# 0
C3338 output7.A u_loop.u_gl.A2 0.10285f
C3339 u_loop.u_q.Y a_6397_2767# 0.02815f
C3340 _56_.Q a_5389_5737# 0
C3341 a_1499_7663# a_1665_7663# 0.83169f
C3342 u_loop.u_q.B a_5276_2197# 0
C3343 a_6375_6037# a_7387_4949# 0
C3344 a_8183_5461# a_8468_7497# 0
C3345 a_8643_5247# u_loop.u_gh.C 0.27721f
C3346 a_4076_3561# u_loop.u_gl.A2 0.36758f
C3347 _34_.B1 _35_.A_N 0.10367f
C3348 _35_.B _28_.A 0
C3349 prenl a_4403_2223# 0.12652f
C3350 VPWR u_loop.u_d0.A 2.44244f
C3351 _41_.B1 a_3992_7235# 0
C3352 _27_.Y VPWR 0.52825f
C3353 u_loop.u_qb.A u_loop.u_gl.A2 0
C3354 u_loop.u_qb.A a_5363_4399# 0
C3355 _67_.D a_7443_5487# 0
C3356 a_2143_7119# _35_.B 0.20237f
C3357 a_2742_8029# a_2580_7663# 0.00645f
C3358 _23_.A a_3083_9537# 0
C3359 a_7903_5321# u_loop.u_gh.C 0.17382f
C3360 a_5190_5487# _25_.A 0.15307f
C3361 _48_.Y _41_.C1 0.00162f
C3362 a_6375_6037# _42_.Y 0
C3363 _55_.D a_6651_3861# 0.22215f
C3364 a_3793_8585# a_2769_8213# 0
C3365 a_5190_5487# _56_.Q 0.10504f
C3366 _23_.A a_3170_9295# 0
C3367 a_7429_4221# _55_.Q 0
C3368 u_loop.u_q.Y a_5175_2767# 0.00121f
C3369 a_7387_7125# _39_.X 0.24822f
C3370 _67_.D a_7661_5729# 0
C3371 _67_.D a_7093_5487# 0.2753f
C3372 a_6283_7663# a_6796_6397# 0
C3373 u_loop.u_s1.Y a_5529_4399# 0
C3374 _53_.A VPWR 0.86548f
C3375 a_5691_3829# _55_.D 0
C3376 a_8121_4917# u_loop.u_gh.C 0.16649f
C3377 a_2625_2767# a_2291_4399# 0
C3378 x prenh 0.1987f
C3379 a_4439_2767# u_loop.u_gh.C 0
C3380 a_6927_5487# _67_.Q 0
C3381 _40_.B u_loop.u_gh.C 0.27467f
C3382 _55_.Q a_7263_4233# 0
C3383 _55_.D a_6798_4399# 0
C3384 a_2766_9427# _40_.B 0
C3385 a_3684_8585# _63_.Q 0
C3386 u_loop.u_d1.X a_2291_4399# 0
C3387 a_6553_4399# _55_.D 0
C3388 a_7072_4221# _55_.Q 0
C3389 a_2231_2767# a_2291_4399# 0
C3390 a_7553_4949# u_loop.u_gh.C 0.05241f
C3391 a_8630_4943# VPWR 0
C3392 x a_5547_2223# 0.20339f
C3393 a_6799_7663# a_6704_7663# 0.04983f
C3394 u_loop.u_cmp.Y a_5529_4399# 0
C3395 _41_.B1 VPWR 0.51699f
C3396 a_6449_7663# a_6283_7663# 0.90036f
C3397 a_3044_9411# a_3119_8585# 0
C3398 a_3000_9295# VPWR 0
C3399 output7.A prenh 0.00215f
C3400 a_7808_7485# a_7443_5487# 0
C3401 _56_.Q _25_.A 0.05212f
C3402 a_2603_8213# _38_.X 0
C3403 _55_.RESET_B a_6796_6397# 0
C3404 VPWR a_8011_4943# 0.14211f
C3405 a_4076_3561# prenh 0
C3406 a_7364_7663# a_7526_8029# 0.00645f
C3407 a_7387_4949# u_loop.u_gh.C 0.66419f
C3408 a_6339_8751# _46_.Y 0
C3409 input5.X a_5529_4399# 0
C3410 _25_.Y u_loop.u_gh.C 0.02708f
C3411 _62_.D a_2755_7637# 0
C3412 _47_.Y _31_.Y 0.00252f
C3413 _39_.B2 u_loop.u_gh.C 0.05339f
C3414 a_3000_9295# _30_.A 0
C3415 _50_.Y a_2015_7663# 0
C3416 a_4963_9673# a_4517_9301# 0
C3417 a_7732_4233# _55_.Q 0.00278f
C3418 x a_5276_2197# 0.01007f
C3419 a_2603_8213# _35_.B 0
C3420 _67_.D a_6927_5487# 0.16538f
C3421 _67__13.LO _25_.A 0
C3422 _55_.Q a_7907_4159# 0.10428f
C3423 a_6927_5487# a_6999_6031# 0
C3424 a_6557_8993# VPWR 0.21492f
C3425 a_4833_2767# output6.A 0.00737f
C3426 u_loop.u_s1.Y u_loop.u_gl.A2 0
C3427 a_5363_4399# u_loop.u_s1.Y 0
C3428 _42_.Y u_loop.u_gh.C 0.03813f
C3429 a_6449_7663# _55_.RESET_B 0.06187f
C3430 _20_.Y a_1582_6575# 0
C3431 a_6891_6409# _39_.X 0
C3432 a_5989_8751# _39_.B2 0.00305f
C3433 _67_.D _56_.CLK 0
C3434 _67_.D _41_.X 0.00931f
C3435 a_6141_4399# _55_.D 0
C3436 a_1735_7119# u_loop.u_gh.C 0
C3437 a_3337_8181# a_2603_8213# 0.07009f
C3438 a_2471_7119# a_1665_7663# 0
C3439 _32_.A _25_.Y 0
C3440 output7.A a_5276_2197# 0
C3441 _55_.Q a_7167_4233# 0.0064f
C3442 a_4351_9301# _49_.Y 0.00464f
C3443 _55_.D a_5975_4399# 0
C3444 a_3044_9411# a_3384_9295# 0.02761f
C3445 u_loop.u_cmp.Y u_loop.u_gl.A2 0.0061f
C3446 a_5363_4399# u_loop.u_cmp.Y 0
C3447 _56_.CLK a_5569_2767# 0
C3448 _32_.A _42_.Y 0
C3449 a_3316_5321# u_loop.u_gh.C 0.25255f
C3450 a_5363_4399# input5.X 0
C3451 input5.X u_loop.u_gl.A2 0.01249f
C3452 pre u_loop.u_gh.C 0
C3453 a_4510_3311# a_4910_2197# 0
C3454 a_2509_4641# a_2625_2767# 0
C3455 _67_.D a_5649_5737# 0
C3456 a_2233_7905# a_2123_8029# 0.09774f
C3457 u_loop.u_d5.X a_5069_2767# 0.01908f
C3458 a_4075_6825# a_3859_8511# 0
C3459 a_7109_6005# _39_.X 0
C3460 a_3119_8585# u_loop.u_gh.C 0.16527f
C3461 a_1499_7663# a_1407_7119# 0.00296f
C3462 a_3491_5247# u_loop.u_gh.C 0.34561f
C3463 a_8911_6031# _25_.A 0
C3464 a_2751_5321# u_loop.u_gh.C 0.15976f
C3465 a_1624_7119# u_loop.u_gh.C 0
C3466 a_7072_4221# a_6619_4373# 0
C3467 a_8800_6031# _25_.A 0
C3468 a_2533_2223# a_2875_2223# 0.00188f
C3469 _55_.Q a_7385_3829# 0.00493f
C3470 a_6339_8751# _21_.Y 0
C3471 _25_.A a_8583_6031# 0
C3472 _25_.A _67_.Q 0
C3473 a_3316_5321# a_3224_6409# 0
C3474 u_loop.u_d5.X a_5569_2767# 0.37578f
C3475 a_5190_5487# _67_.D 0
C3476 output7.A a_4097_2767# 0.03113f
C3477 a_1407_6031# src[1] 0
C3478 a_2231_2767# a_1941_4399# 0
C3479 u_loop.u_gh.C a_2969_4917# 0.16781f
C3480 _45_.A a_6541_6037# 0
C3481 input5.X prenh 0
C3482 _63_.D _23_.A 0.1958f
C3483 a_2861_2767# VPWR 0.28583f
C3484 a_3044_9411# a_4351_9301# 0.00133f
C3485 u_loop.u_cmp.Y a_5547_2223# 0
C3486 _23_.A a_2479_9269# 0
C3487 a_8911_6031# _67__13.LO 0
C3488 a_4403_2223# VPWR 0.22735f
C3489 _55_.CLK u_loop.u_q.Y 0.0839f
C3490 a_8643_7423# _68_.D 0
C3491 a_3316_5321# a_3399_6335# 0
C3492 a_3384_9295# u_loop.u_gh.C 0.01836f
C3493 a_8800_6031# _67__13.LO 0.00107f
C3494 _46_.A _34_.X 0
C3495 input5.X a_5547_2223# 0.0396f
C3496 _67__13.LO _67_.Q 0.05398f
C3497 a_2401_4949# u_loop.u_gh.C 0.04003f
C3498 _67__13.LO a_8583_6031# 0.10034f
C3499 a_3224_6409# a_3491_5247# 0
C3500 _39_.X _32_.Y 0
C3501 a_2751_5321# a_3224_6409# 0
C3502 xb _67__13.LO 0.00131f
C3503 a_2479_9269# a_3024_8573# 0
C3504 a_1775_4399# a_2625_2767# 0
C3505 _20_.Y _34_.X 0.00122f
C3506 a_1499_7663# a_2233_7905# 0.07009f
C3507 _67_.D _25_.A 0.00967f
C3508 _63_.Q a_2360_7119# 0
C3509 a_5594_9295# VPWR 0
C3510 _39_.X a_6375_6037# 0
C3511 _63_.D _35_.A_N 0.00103f
C3512 a_7387_7125# a_6283_7663# 0.00108f
C3513 a_2231_2767# a_1775_4399# 0
C3514 a_4292_2223# a_4439_2767# 0.00146f
C3515 _56_.Q _67_.D 0
C3516 a_6619_4373# a_7167_4233# 0
C3517 a_3399_6335# a_3491_5247# 0
C3518 _63_.CLK a_1735_6031# 0
C3519 a_4075_2223# a_4097_2767# 0.01966f
C3520 a_1624_6031# _63_.CLK 0
C3521 a_2625_2767# a_2967_2767# 0.00188f
C3522 a_7808_5309# a_7604_6575# 0
C3523 input5.X a_5276_2197# 0.00625f
C3524 a_8911_8207# xa 0.09305f
C3525 a_6397_2767# VPWR 0.346f
C3526 _56_.D u_loop.u_q.Y 0
C3527 a_2125_2767# a_1775_4399# 0
C3528 a_1499_7663# _35_.B 0.00154f
C3529 u_loop.u_d1.X a_2967_2767# 0.07541f
C3530 a_1499_7663# a_2689_7663# 0
C3531 _50_.Y VPWR 0.35959f
C3532 _28_.Y u_loop.u_gh.C 0.00889f
C3533 _55_.RESET_B a_8583_8207# 0
C3534 a_6283_7663# a_7456_6409# 0
C3535 _50_.Y a_2452_6575# 0
C3536 _55_.Q a_6817_3861# 0.0119f
C3537 u_loop.u_d2.X u_loop.u_d0.X 0
C3538 x a_4910_2197# 0.00209f
C3539 a_7364_7663# a_7808_7485# 0
C3540 a_3316_5321# a_2309_6037# 0
C3541 _67_.D _67__13.LO 0.07165f
C3542 a_5691_3829# a_5784_4399# 0
C3543 a_3388_7351# a_2471_7119# 0
C3544 u_loop.u_gh.C a_2235_4949# 0.30807f
C3545 a_7387_7125# _55_.RESET_B 0.3964f
C3546 a_2625_2767# u_loop.u_d0.A 0.00131f
C3547 a_2360_7119# a_1665_7663# 0.01049f
C3548 a_2401_4949# a_3224_6409# 0
C3549 u_loop.u_q.Y u_loop.u_gh.B 0.0398f
C3550 u_loop.u_d6.X a_5805_2767# 0.01693f
C3551 u_loop.u_d1.X u_loop.u_d0.A 0
C3552 _57_.CLK a_6987_6409# 0
C3553 a_2934_7663# u_loop.u_gh.C 0.00351f
C3554 a_2231_2767# u_loop.u_d0.A 0.00303f
C3555 a_5175_2767# VPWR 0.19121f
C3556 a_8800_6031# a_8911_6031# 0.34134f
C3557 output7.A a_4910_2197# 0.00147f
C3558 _50_.Y a_2235_6575# 0
C3559 a_8911_6031# _67_.Q 0.00816f
C3560 a_7456_6409# _55_.RESET_B 0.22899f
C3561 a_8911_6031# a_8583_6031# 0
C3562 a_1775_4399# a_1889_2767# 0
C3563 _53_.Y u_loop.u_gh.C 0.03468f
C3564 a_5432_9673# VPWR 0.29861f
C3565 a_8911_6031# xb 0.09239f
C3566 a_2125_2767# u_loop.u_d0.A 0.00803f
C3567 _27_.Y a_2125_2767# 0
C3568 a_5607_9599# _47_.Y 0.00219f
C3569 a_3703_2767# u_loop.u_d2.X 0
C3570 a_4351_9301# u_loop.u_gh.C 0.66432f
C3571 a_2143_7119# a_2123_8029# 0
C3572 _53_.A a_2625_2767# 0
C3573 output6.A u_loop.u_gl.A2 0.09104f
C3574 a_5363_4399# output6.A 0.00206f
C3575 a_2751_5321# a_2309_6037# 0
C3576 a_8800_6031# _67_.Q 0.01418f
C3577 _23_.A a_2755_7637# 0.01387f
C3578 a_8800_6031# a_8583_6031# 0.11296f
C3579 a_6891_6409# a_6283_7663# 0
C3580 _53_.A u_loop.u_d1.X 0
C3581 a_5085_9269# VPWR 0.21125f
C3582 a_4769_4175# u_loop.u_gl.A2 0.014f
C3583 a_5363_4399# a_4769_4175# 0
C3584 a_4351_4175# u_loop.u_gl.A2 0.0081f
C3585 a_8800_6031# xb 0.00485f
C3586 a_2969_4917# a_2659_6409# 0
C3587 _50_.Y a_2580_7663# 0
C3588 _67_.Q a_8583_6031# 0.23686f
C3589 a_4074_7235# a_3992_7235# 0
C3590 u_loop.u_gl.B1 u_loop.u_gl.A2 0.05672f
C3591 xb _67_.Q 0.01237f
C3592 xb a_8583_6031# 0.00168f
C3593 a_2231_2767# _53_.A 0.00111f
C3594 a_4369_6351# _35_.B 0.14684f
C3595 a_6541_6037# _41_.B1 0
C3596 a_7364_7663# xa 0
C3597 _55_.D a_5784_4399# 0
C3598 a_2877_6005# a_2969_4917# 0
C3599 a_5085_9269# _30_.A 0
C3600 _23_.Y _35_.B 0
C3601 _46_.A VPWR 0.99442f
C3602 _53_.A a_2125_2767# 0
C3603 a_3388_7351# a_4032_7351# 0.00534f
C3604 a_2769_8213# _62_.D 0.23012f
C3605 a_2309_6037# a_2969_4917# 0
C3606 a_2401_4949# a_2659_6409# 0
C3607 _30_.Y _62_.D 0
C3608 a_4772_9661# u_loop.u_gh.C 0.01783f
C3609 a_7631_6335# _55_.RESET_B 0.29387f
C3610 a_3684_8585# _35_.B 0
C3611 _20_.Y VPWR 0.80749f
C3612 a_6891_6409# _55_.RESET_B 0.16045f
C3613 a_6435_8751# a_6557_8993# 0
C3614 _55_.Q a_6651_3861# 0.00133f
C3615 _67_.D a_8911_6031# 0
C3616 _38_.X a_2471_7119# 0
C3617 a_3239_9269# a_3802_9295# 0.04983f
C3618 a_5784_4399# a_5975_4399# 0
C3619 a_1889_2767# u_loop.u_d0.A 0.29823f
C3620 _35_.A_N a_2755_7637# 0.00323f
C3621 _32_.A _39_.X 0
C3622 a_3000_9295# a_3170_9295# 0
C3623 a_3802_9295# a_3859_8511# 0
C3624 a_3316_5321# a_2143_6037# 0
C3625 a_8800_6031# _67_.D 0
C3626 a_2401_4949# a_2309_6037# 0
C3627 a_3514_7235# _40_.B 0
C3628 a_3337_8181# a_3684_8585# 0.05116f
C3629 a_4510_3311# u_loop.u_d0.A 0.06909f
C3630 pre a_2143_6037# 0.00253f
C3631 _67_.D _67_.Q 0.00468f
C3632 _67_.D a_8583_6031# 0.00566f
C3633 a_1735_7119# a_1735_6031# 0
C3634 a_1624_6031# a_1735_7119# 0
C3635 _67_.D xb 0
C3636 a_2471_7119# _35_.B 0.04825f
C3637 a_6799_7663# _34_.X 0
C3638 output6.A prenh 0.00288f
C3639 a_1654_6575# _63_.CLK 0
C3640 a_7017_7905# _46_.A 0
C3641 _20_.Y a_2235_6575# 0
C3642 a_8800_6031# a_8468_7497# 0
C3643 a_8468_7497# _67_.Q 0
C3644 a_8468_7497# a_8583_6031# 0
C3645 a_2235_4949# a_2659_6409# 0
C3646 a_2751_5321# a_2143_6037# 0
C3647 a_1499_7663# a_2143_7119# 0
C3648 output6.A a_5547_2223# 0.00983f
C3649 pre _52_.Y 0
C3650 a_6619_4373# a_6817_3861# 0
C3651 a_6817_3861# a_6444_4399# 0
C3652 pre a_1735_6031# 0.00233f
C3653 pre a_1624_6031# 0.00327f
C3654 a_7109_6005# _55_.RESET_B 0.1729f
C3655 a_4075_6825# _40_.B 0
C3656 _38_.X a_4032_7351# 0.04869f
C3657 a_6891_6409# a_7348_5487# 0
C3658 a_7387_7125# a_7443_5487# 0
C3659 a_2309_6037# a_2235_4949# 0
C3660 _55_.D _55_.Q 0.10107f
C3661 _67_.D a_6999_6031# 0.00842f
C3662 a_2967_2767# a_2769_2223# 0.00232f
C3663 a_2143_6037# a_2969_4917# 0
C3664 a_7631_6335# a_8008_5487# 0.0015f
C3665 a_4517_9301# VPWR 0.51783f
C3666 a_5989_8751# a_6244_8751# 0.06418f
C3667 a_5569_2767# a_5069_2767# 0
C3668 output6.A a_5276_2197# 0.20936f
C3669 a_5879_4399# a_5805_2767# 0
C3670 a_4032_7351# _35_.B 0.10422f
C3671 a_6283_7663# _68_.Q 0
C3672 a_3044_9411# _63_.Q 0
C3673 u_loop.u_gh.B _34_.X 0
C3674 a_1407_6031# pre 0.19784f
C3675 a_7387_7125# a_7661_5729# 0
C3676 a_7387_7125# a_7093_5487# 0
C3677 a_7456_6409# a_7443_5487# 0.00268f
C3678 a_7364_7663# a_6449_7663# 0.12532f
C3679 _36_.A a_5529_4399# 0
C3680 a_6704_7663# _39_.B2 0
C3681 input5.X a_4910_2197# 0
C3682 a_6283_7663# _32_.Y 0
C3683 _53_.Y a_2309_6037# 0
C3684 a_1624_7119# a_1735_6031# 0
C3685 a_6904_8751# VPWR 0.3066f
C3686 a_1624_6031# a_1624_7119# 0
C3687 a_5293_7439# _38_.X 0.00255f
C3688 a_4517_9301# _30_.A 0.00117f
C3689 a_7631_6335# a_8183_5461# 0
C3690 a_7808_5309# VPWR 0.08228f
C3691 a_3388_7351# a_2360_7119# 0
C3692 a_2401_4949# a_2143_6037# 0.00112f
C3693 a_5389_7119# _39_.B2 0
C3694 a_3031_4373# a_3361_2767# 0
C3695 u_loop.u_d0.A a_2769_2223# 0
C3696 a_6283_7663# a_6375_6037# 0
C3697 a_7456_6409# a_7661_5729# 0
C3698 a_4160_6575# a_3859_8511# 0
C3699 a_7456_6409# a_7093_5487# 0
C3700 _23_.Y _28_.A 0.0332f
C3701 _55_.RESET_B a_7013_8751# 0
C3702 u_loop.u_d4.X VPWR 0.24642f
C3703 a_5805_2767# a_5529_4399# 0
C3704 _68_.Q a_8165_7485# 0
C3705 a_5989_8751# a_7079_8725# 0.04251f
C3706 _68_.D a_8121_7093# 0.00206f
C3707 _68_.Q _55_.RESET_B 0.20107f
C3708 _23_.Y a_2143_7119# 0
C3709 a_1499_7663# a_2603_8213# 0
C3710 _55_.CLK VPWR 0.73704f
C3711 _55_.RESET_B _32_.Y 0
C3712 a_3478_4943# VPWR 0
C3713 a_7631_6335# a_7443_5487# 0.00129f
C3714 a_2625_2767# a_2861_2767# 0.22264f
C3715 a_2401_4949# _52_.Y 0
C3716 a_6619_4373# a_6651_3861# 0.01027f
C3717 a_6444_4399# a_6651_3861# 0
C3718 _47_.Y _49_.Y 0
C3719 xb xa 0
C3720 u_loop.u_d1.X a_2861_2767# 0.10305f
C3721 a_6799_7663# VPWR 0.20275f
C3722 output7.A a_2967_2767# 0.00124f
C3723 x u_loop.u_d0.A 0
C3724 a_4403_2223# u_loop.u_d1.X 0
C3725 _55_.RESET_B a_6375_6037# 0.33129f
C3726 a_7387_7125# a_6927_5487# 0
C3727 a_6449_7663# a_7526_8029# 0
C3728 _36_.A a_5363_4399# 0
C3729 _36_.A u_loop.u_gl.A2 0
C3730 a_7631_6335# a_7661_5729# 0.00902f
C3731 a_7631_6335# a_7093_5487# 0.00585f
C3732 a_2143_6037# a_2235_4949# 0
C3733 _35_.A_N a_4518_6825# 0.04391f
C3734 a_6619_4373# a_6798_4399# 0.0074f
C3735 a_6891_6409# a_7093_5487# 0.00564f
C3736 a_6553_4399# a_6444_4399# 0.00742f
C3737 a_2143_7119# a_2471_7119# 0
C3738 output6.A a_4097_2767# 0.0012f
C3739 output7.A u_loop.u_d0.A 0.30215f
C3740 _48_.Y a_5085_9269# 0
C3741 a_7456_6409# a_6927_5487# 0
C3742 a_3992_7235# a_3859_8511# 0.00151f
C3743 _55_.RESET_B a_8800_8207# 0
C3744 a_2233_7905# a_2360_7119# 0
C3745 _52_.Y _28_.Y 0.00129f
C3746 u_loop.u_gl.B1 a_4097_2767# 0.02267f
C3747 _56_.D VPWR 0.66311f
C3748 _38_.X a_2360_7119# 0
C3749 a_4076_3561# u_loop.u_d0.A 0.08619f
C3750 a_5363_4399# a_5805_2767# 0
C3751 _53_.Y a_2143_6037# 0
C3752 a_8911_8207# a_8583_8207# 0
C3753 a_6799_7663# a_7017_7905# 0.20964f
C3754 _63_.Q u_loop.u_gh.C 0.14167f
C3755 _63_.CLK a_1845_6825# 0
C3756 a_4292_2223# a_5036_2381# 0.00104f
C3757 a_1499_6575# _20_.Y 0.14481f
C3758 _52_.Y a_2235_4949# 0
C3759 _63_.Q a_2766_9427# 0
C3760 a_3227_8207# a_3239_9269# 0
C3761 _41_.C1 a_4518_6825# 0
C3762 a_2360_7119# _35_.B 0.05104f
C3763 a_6339_8751# a_5823_8751# 0.11053f
C3764 u_loop.u_gh.B VPWR 0.74832f
C3765 a_5691_3829# a_5529_4399# 0.00161f
C3766 a_5989_8751# a_6283_7663# 0.00184f
C3767 _55_.D a_6619_4373# 0.02359f
C3768 a_6097_4641# a_6553_4399# 0
C3769 a_7631_6335# a_6927_5487# 0.00513f
C3770 a_1499_7663# a_2123_8029# 0
C3771 _55_.D a_6444_4399# 0.00224f
C3772 a_7618_6031# VPWR 0
C3773 a_6553_4399# a_5529_4399# 0
C3774 _20_.A _35_.B 0
C3775 a_3684_8585# a_2603_8213# 0.10236f
C3776 _53_.Y _52_.Y 0
C3777 a_6891_6409# a_6927_5487# 0.001f
C3778 a_7109_6005# a_7093_5487# 0.00231f
C3779 a_6283_7663# _32_.A 0
C3780 _55_.RESET_B u_loop.u_gh.C 0.03113f
C3781 _34_.B1 _20_.Y 0.08232f
C3782 a_1654_6575# a_1624_7119# 0
C3783 a_4510_3311# a_4403_2223# 0
C3784 a_3239_9269# VPWR 0.19944f
C3785 a_4075_2223# u_loop.u_d0.A 0
C3786 _23_.A a_2769_8213# 0.35484f
C3787 u_loop.u_gh.C a_1665_7663# 0.02739f
C3788 a_3859_8511# VPWR 0.41009f
C3789 a_7999_7497# a_8121_7093# 0
C3790 a_6891_6409# _41_.X 0
C3791 a_5879_4399# _55_.D 0
C3792 a_7903_7497# a_8121_7093# 0.20964f
C3793 a_4158_7235# _35_.B 0.00367f
C3794 a_3239_9269# _30_.A 0.02993f
C3795 a_6435_8751# _46_.A 0.00546f
C3796 a_5989_8751# _55_.RESET_B 0.02678f
C3797 a_5879_4399# a_6141_4399# 0.00171f
C3798 a_3859_8511# _30_.A 0.00481f
C3799 a_2769_8213# a_3024_8573# 0.05936f
C3800 a_6606_4765# a_6444_4399# 0.00645f
C3801 a_5879_4399# a_5975_4399# 0.01379f
C3802 _63_.CLK a_2015_7663# 0.00542f
C3803 a_6601_8751# VPWR 0
C3804 _32_.A _55_.RESET_B 0.45335f
C3805 a_6097_4641# _55_.D 0
C3806 _55_.D a_5529_4399# 0
C3807 a_5691_3829# u_loop.u_gl.A2 0.00123f
C3808 a_5691_3829# a_5363_4399# 0
C3809 _67_.D a_6796_6397# 0.0016f
C3810 _35_.A_N a_2769_8213# 0
C3811 output6.A a_4910_2197# 0.00652f
C3812 a_3802_9295# _40_.B 0
C3813 a_6097_4641# a_6141_4399# 0
C3814 a_6553_4399# u_loop.u_gl.A2 0
C3815 a_7387_7125# a_7364_7663# 0
C3816 a_6553_4399# a_5363_4399# 0
C3817 a_7109_6005# a_6927_5487# 0
C3818 prenl a_4439_2767# 0.00254f
C3819 u_loop.u_d2.X a_3597_2767# 0.00315f
C3820 a_6097_4641# a_5975_4399# 0
C3821 a_6375_6037# a_7443_5487# 0
C3822 _48_.Y a_4517_9301# 0.00848f
C3823 a_5975_4399# a_5529_4399# 0
C3824 a_6097_4641# a_6606_4765# 0
C3825 u_loop.u_cmp.Y u_loop.u_d0.A 0
C3826 a_7715_6575# _25_.Y 0
C3827 a_6606_4765# a_5529_4399# 0
C3828 _55_.RESET_B a_7066_9117# 0
C3829 a_8008_5487# u_loop.u_gh.C 0
C3830 a_6375_6037# a_7093_5487# 0
C3831 _63_.Q a_2659_6409# 0
C3832 a_6397_2767# u_loop.u_q.B 0.01517f
C3833 a_2861_2767# a_2769_2223# 0.0073f
C3834 _41_.C1 a_4351_4175# 0
C3835 a_4403_2223# a_2769_2223# 0
C3836 input5.X u_loop.u_d0.A 0.00703f
C3837 _39_.X _57_.CLK 0
C3838 _32_.A a_7348_5487# 0
C3839 a_6449_7663# a_6907_8029# 0.03462f
C3840 a_2877_6005# _63_.Q 0
C3841 a_8183_5461# u_loop.u_gh.C 0.006f
C3842 _55_.D a_5363_4399# 0
C3843 a_3337_8181# a_3215_8585# 0
C3844 a_7604_6575# a_7387_4949# 0
C3845 a_7604_6575# _25_.Y 0
C3846 a_2564_6397# _28_.A 0
C3847 a_6141_4399# u_loop.u_gl.A2 0
C3848 _47_.Y u_loop.u_gh.C 0
C3849 _36_.A a_5649_7119# 0.00124f
C3850 a_2143_7119# a_2360_7119# 0.11296f
C3851 a_7364_7663# a_7631_6335# 0
C3852 a_5975_4399# u_loop.u_gl.A2 0
C3853 a_5363_4399# a_5975_4399# 0.00188f
C3854 a_7364_7663# a_6891_6409# 0
C3855 _20_.A _28_.A 0.00801f
C3856 pre a_1845_6825# 0
C3857 x a_4403_2223# 0
C3858 VPWR src[1] 0.15248f
C3859 a_7275_3855# u_loop.u_d0.A 0
C3860 a_5691_3829# a_5547_2223# 0
C3861 a_3348_7235# _40_.B 0.00588f
C3862 _42_.Y a_7387_6575# 0
C3863 a_5989_8751# _47_.Y 0.00123f
C3864 _41_.X _32_.Y 0
C3865 a_7443_5487# u_loop.u_gh.C 0
C3866 a_7631_6335# _25_.A 0
C3867 a_4517_9301# a_3083_9537# 0.00133f
C3868 a_6375_6037# a_6927_5487# 0.0068f
C3869 a_6891_6409# _25_.A 0
C3870 _36_.A _22_.Y 0
C3871 a_2656_5309# VPWR 0.08233f
C3872 a_2309_6037# a_1665_7663# 0
C3873 output7.A a_2861_2767# 0.00121f
C3874 a_6375_6037# _41_.X 0.00906f
C3875 _40_.B _34_.X 0
C3876 a_1499_7663# _23_.Y 0
C3877 a_4160_6575# _40_.B 0
C3878 output7.A a_4403_2223# 0.00818f
C3879 a_7553_7125# a_8011_7119# 0.03462f
C3880 u_loop.u_gh.C a_7093_5487# 0
C3881 a_7551_5853# _25_.Y 0
C3882 _63_.D _50_.Y 0.00718f
C3883 u_loop.u_d3.X u_loop.u_gh.C 0
C3884 a_6339_8751# _22_.Y 0
C3885 a_8911_8207# _68_.Q 0.00656f
C3886 _32_.A a_7443_5487# 0
C3887 _50_.Y a_2479_9269# 0
C3888 a_3388_7351# u_loop.u_gh.C 0
C3889 a_8468_5321# VPWR 0.29679f
C3890 a_7631_6335# _67__13.LO 0
C3891 u_loop.u_gh.C a_1407_7119# 0
C3892 _32_.Y _35_.B 0
C3893 u_loop.u_d1.X u_loop.u_d4.X 0
C3894 a_3846_8207# _35_.B 0
C3895 a_3227_8207# _63_.CLK 0
C3896 _23_.A _36_.A 0.00483f
C3897 a_6541_6037# a_6799_7663# 0
C3898 _34_.X _39_.B2 0
C3899 _32_.A a_7661_5729# 0
C3900 a_3361_2767# u_loop.u_d0.A 0
C3901 a_5879_4399# a_5987_4765# 0.05722f
C3902 a_1499_7663# a_2471_7119# 0.00345f
C3903 _32_.A a_7093_5487# 0.00177f
C3904 a_7109_6005# _25_.A 0
C3905 a_3337_8181# a_3846_8207# 0
C3906 _48_.Y a_3859_8511# 0.00174f
C3907 a_3992_7235# _40_.B 0.06378f
C3908 _42_.Y _34_.X 0
C3909 a_4403_2223# a_4075_2223# 0
C3910 _63_.CLK VPWR 0.58036f
C3911 a_6927_5487# u_loop.u_gh.C 0
C3912 a_8911_8207# a_8800_8207# 0.34134f
C3913 a_5190_7439# a_5649_7119# 0.01157f
C3914 en _23_.A 0
C3915 _53_.A a_3361_2767# 0
C3916 a_6097_4641# a_5987_4765# 0.09774f
C3917 _41_.B1 a_4518_6825# 0.12827f
C3918 a_5987_4765# a_5529_4399# 0.03462f
C3919 a_4518_6575# u_loop.u_gh.C 0
C3920 a_6739_2767# a_6651_3861# 0
C3921 a_4772_9661# a_4963_9673# 0
C3922 a_8643_5247# VPWR 0.43831f
C3923 _36_.A _35_.A_N 0.03288f
C3924 a_7456_6409# _67_.Q 0.00128f
C3925 _41_.X u_loop.u_gh.C 0
C3926 _56_.CLK u_loop.u_gh.C 0.02242f
C3927 a_3388_7351# a_3224_6409# 0
C3928 a_7456_6409# xb 0
C3929 a_3227_8207# _40_.B 0
C3930 a_7903_5321# VPWR 0.20739f
C3931 a_5175_2767# output7.A 0.00188f
C3932 a_7364_7663# _68_.Q 0.00155f
C3933 a_5190_7439# _22_.Y 0
C3934 a_3316_5321# _34_.X 0
C3935 a_7072_4221# u_loop.u_d0.A 0
C3936 a_3992_7235# _39_.B2 0
C3937 a_2233_7905# u_loop.u_gh.C 0.16686f
C3938 _32_.A a_6927_5487# 0.00454f
C3939 a_5879_4399# a_5784_4399# 0.04983f
C3940 _38_.X u_loop.u_gh.C 0
C3941 a_5541_9673# u_loop.u_gh.C 0
C3942 a_5823_8751# _46_.Y 0.00158f
C3943 a_7387_7125# _67_.D 0
C3944 pre _34_.X 0
C3945 a_3388_7351# a_3399_6335# 0
C3946 a_3348_7235# a_3119_8585# 0
C3947 a_4510_3311# u_loop.u_d4.X 0.00125f
C3948 a_4439_2767# VPWR 0.1871f
C3949 a_7539_7637# _46_.Y 0
C3950 a_8121_4917# VPWR 0.21152f
C3951 en _35_.A_N 0.06873f
C3952 a_5607_9599# _31_.Y 0.00386f
C3953 a_6541_6037# a_7618_6031# 0
C3954 _32_.A _56_.CLK 0.1019f
C3955 src[0] _23_.A 0
C3956 _32_.A _41_.X 0.13347f
C3957 a_8468_7497# a_8583_8207# 0
C3958 _40_.B VPWR 1.24169f
C3959 output6.A u_loop.u_d0.A 0.26009f
C3960 _23_.Y a_2471_7119# 0
C3961 a_2580_7663# _63_.CLK 0
C3962 _25_.A _32_.Y 0
C3963 _36_.A _41_.C1 0.0864f
C3964 a_7631_6335# _67_.Q 0.00336f
C3965 u_loop.u_gh.C _35_.B 0.03215f
C3966 a_2689_7663# u_loop.u_gh.C 0
C3967 a_4769_4175# u_loop.u_d0.A 0.00578f
C3968 a_4351_4175# u_loop.u_d0.A 0.00333f
C3969 a_7631_6335# xb 0
C3970 _55_.RESET_B a_6633_2767# 0
C3971 a_3119_8585# _34_.X 0
C3972 u_loop.u_gl.B1 u_loop.u_d0.A 0.12928f
C3973 a_6891_6409# _67_.Q 0
C3974 a_7456_6409# _67_.D 0.05995f
C3975 a_5784_4399# a_5529_4399# 0.06418f
C3976 a_7387_7125# a_8468_7497# 0.10236f
C3977 a_4167_6147# a_4518_6575# 0
C3978 a_3119_8585# a_3436_6549# 0
C3979 a_7553_4949# VPWR 0.57822f
C3980 _40_.B _30_.A 0.0321f
C3981 a_3239_9269# a_3083_9537# 0.10748f
C3982 _56_.Q _32_.Y 0
C3983 a_5363_4399# a_5987_4765# 0
C3984 a_3491_5247# _34_.X 0
C3985 a_6375_6037# _25_.A 0
C3986 a_3859_8511# a_3083_9537# 0
C3987 _55_.RESET_B a_8822_7485# 0.00197f
C3988 a_3491_5247# a_3436_6549# 0
C3989 a_3337_8181# u_loop.u_gh.C 0.18754f
C3990 a_2603_8213# _49_.Y 0
C3991 a_4038_8573# a_3859_8511# 0.0074f
C3992 a_3239_9269# a_3170_9295# 0.20964f
C3993 a_4403_2223# input5.X 0
C3994 _56_.Q a_6375_6037# 0.00126f
C3995 a_3215_8585# a_2603_8213# 0.00188f
C3996 a_7387_4949# VPWR 0.45015f
C3997 VPWR _25_.Y 0.76428f
C3998 _68_.Q a_7526_8029# 0
C3999 src[0] _35_.A_N 0.00467f
C4000 VPWR _39_.B2 1.63799f
C4001 _55_.CLK u_loop.u_q.B 0
C4002 a_4167_6147# _38_.X 0
C4003 _32_.A _35_.B 0.00139f
C4004 _32_.A a_5649_5737# 0
C4005 a_6283_7663# _57_.CLK 0
C4006 a_7387_7125# a_7808_7485# 0.08638f
C4007 a_2751_5321# a_3196_6733# 0
C4008 a_7553_7125# _39_.X 0.00196f
C4009 a_3388_7351# a_2309_6037# 0
C4010 a_4351_9301# a_3802_9295# 0
C4011 a_7167_4233# u_loop.u_d0.A 0
C4012 a_6619_4373# _55_.Q 0.0177f
C4013 a_4975_9295# u_loop.u_gh.C 0.0122f
C4014 _55_.Q a_6444_4399# 0
C4015 _68_.D a_7999_7497# 0.00146f
C4016 a_1499_6575# src[1] 0
C4017 a_7631_6335# _67_.D 0.08177f
C4018 _30_.A _39_.B2 0.01177f
C4019 _68_.D a_7903_7497# 0.00832f
C4020 _42_.Y VPWR 0.57013f
C4021 a_5190_5487# u_loop.u_gh.C 0
C4022 output6.A _41_.B1 0
C4023 a_7456_6409# a_7565_6409# 0.00742f
C4024 u_loop.u_d5.X u_loop.u_d7.X 0
C4025 u_loop.u_d2.X VPWR 0.25824f
C4026 a_6283_7663# a_6704_7663# 0.08968f
C4027 a_6891_6409# _67_.D 0.02006f
C4028 a_3224_6409# _35_.B 0
C4029 a_4167_6147# _35_.B 0.05689f
C4030 a_5190_7439# _35_.A_N 0.00161f
C4031 a_1735_7119# VPWR 0.23381f
C4032 a_6891_6409# a_6999_6031# 0.05722f
C4033 _41_.B1 a_4769_4175# 0
C4034 a_7456_6409# a_7808_7485# 0
C4035 a_7109_6005# _67_.Q 0
C4036 u_loop.u_d3.X u_loop.u_d0.X 0
C4037 a_3196_6733# a_2969_4917# 0
C4038 a_3684_8585# a_4032_7351# 0
C4039 a_5784_4399# u_loop.u_gl.A2 0
C4040 a_5784_4399# a_5363_4399# 0.09313f
C4041 a_4510_3311# u_loop.u_gh.B 0
C4042 _55_.RESET_B _57_.CLK 0.01613f
C4043 prenl a_5036_2381# 0
C4044 a_5879_4399# u_loop.u_d6.X 0
C4045 a_2533_2223# u_loop.u_d0.X 0.29952f
C4046 a_7017_7905# _39_.B2 0
C4047 a_2751_5321# a_2563_6575# 0
C4048 a_3399_6335# _35_.B 0
C4049 a_8583_8207# xa 0.00138f
C4050 a_5190_5487# _32_.A 0.02147f
C4051 _39_.X a_7387_6575# 0
C4052 a_7810_6397# a_7631_6335# 0.0074f
C4053 a_3316_5321# VPWR 0.30445f
C4054 _36_.A a_5377_7439# 0.05679f
C4055 a_3227_8207# a_3119_8585# 0.05722f
C4056 _25_.A u_loop.u_gh.C 0.14631f
C4057 _55_.RESET_B a_6704_7663# 0.00242f
C4058 a_5823_8751# _21_.Y 0
C4059 a_1499_7663# a_2360_7119# 0
C4060 a_2767_6031# _23_.Y 0
C4061 _55_.Q a_5529_4399# 0
C4062 pre VPWR 0.24447f
C4063 a_4333_2767# u_loop.u_gh.C 0.00114f
C4064 a_5190_7439# _41_.C1 0.00121f
C4065 a_4867_9673# a_5432_9673# 0
C4066 a_3703_2767# u_loop.u_d3.X 0.1513f
C4067 _56_.Q u_loop.u_gh.C 0.58572f
C4068 a_6339_8751# a_6447_9117# 0.05722f
C4069 _68_.Q a_8911_6031# 0
C4070 a_5175_2767# input5.X 0
C4071 a_7109_6005# _67_.D 0.04191f
C4072 a_4867_9673# a_5085_9269# 0.20964f
C4073 _45_.A _36_.A 0.11906f
C4074 a_3044_9411# a_2603_8213# 0.00221f
C4075 a_3119_8585# VPWR 0.19889f
C4076 _35_.B a_2659_6409# 0
C4077 a_7109_6005# a_6999_6031# 0.09774f
C4078 _34_.X a_2235_4949# 0
C4079 a_8800_6031# _68_.Q 0
C4080 a_3361_2767# a_2861_2767# 0
C4081 a_8011_7119# VPWR 0.1421f
C4082 a_3491_5247# VPWR 0.44036f
C4083 _68_.Q _67_.Q 0
C4084 _68_.Q a_8583_6031# 0
C4085 _32_.A _25_.A 0.10342f
C4086 a_2751_5321# VPWR 0.21732f
C4087 u_loop.u_gh.C _28_.A 0.62178f
C4088 _67__13.LO u_loop.u_gh.C 0
C4089 a_2401_4949# a_2563_6575# 0
C4090 a_6891_6409# a_7153_6397# 0.00171f
C4091 a_3119_8585# _30_.A 0
C4092 a_1624_7119# VPWR 0.23689f
C4093 pre a_2235_6575# 0
C4094 a_1499_6575# _63_.CLK 0
C4095 _45_.A a_6339_8751# 0
C4096 output7.A u_loop.u_d4.X 0.00542f
C4097 a_6895_7663# _22_.Y 0
C4098 _56_.Q _32_.A 0.006f
C4099 a_2309_6037# _35_.B 0
C4100 a_2143_7119# u_loop.u_gh.C 0.01475f
C4101 a_4076_3561# u_loop.u_d4.X 0
C4102 a_3196_6733# a_2235_4949# 0
C4103 _53_.Y _34_.X 0
C4104 a_6375_6037# _67_.Q 0
C4105 VPWR a_2969_4917# 0.20949f
C4106 a_5363_4399# _55_.Q 0
C4107 _39_.X _34_.X 0.01101f
C4108 a_7999_7497# a_7903_7497# 0.01379f
C4109 a_7109_6005# a_7565_6409# 0
C4110 a_2965_4399# a_2856_4399# 0.00742f
C4111 _22_.Y _46_.Y 0.00312f
C4112 _23_.Y a_2564_6397# 0.15983f
C4113 _23_.Y a_2360_7119# 0.00219f
C4114 _34_.B1 _63_.CLK 0
C4115 a_6541_6037# a_6987_6409# 0
C4116 a_3384_9295# VPWR 0.1325f
C4117 a_2401_4949# VPWR 0.59624f
C4118 a_3210_4399# a_3031_4373# 0.0074f
C4119 _67_.D _32_.Y 0.00559f
C4120 a_6619_4373# a_6444_4399# 0.23366f
C4121 _20_.A _23_.Y 0.02313f
C4122 _36_.A u_loop.u_d0.A 0
C4123 a_2563_6575# a_2235_4949# 0
C4124 _68__14.LO _68_.D 0.06914f
C4125 a_3224_6409# _28_.A 0
C4126 a_7109_6005# a_7153_6397# 0
C4127 a_3384_9295# _30_.A 0.02652f
C4128 a_4833_2767# u_loop.u_gl.A2 0.01728f
C4129 a_5190_7439# a_5377_7439# 0.03258f
C4130 _48_.Y _40_.B 0.00257f
C4131 a_1920_7663# _23_.A 0
C4132 _67_.D a_6375_6037# 0.21857f
C4133 _68_.Q a_8468_7497# 0.03675f
C4134 a_6817_3861# u_loop.u_d0.A 0
C4135 a_2233_7905# a_2143_6037# 0
C4136 a_4403_2223# output6.A 0.00122f
C4137 a_6907_8029# _68_.Q 0
C4138 a_1407_6031# a_1407_7119# 0.00115f
C4139 a_6375_6037# a_6999_6031# 0
C4140 a_5879_4399# a_6444_4399# 0
C4141 a_7539_7637# _68_.D 0.04307f
C4142 a_7387_7125# a_6449_7663# 0.00174f
C4143 a_2360_7119# a_2471_7119# 0.34134f
C4144 u_loop.u_gl.B1 a_4403_2223# 0
C4145 a_2603_8213# u_loop.u_gh.C 0.33168f
C4146 _45_.A a_5190_7439# 0.1612f
C4147 a_2401_4949# a_2235_6575# 0
C4148 a_8800_6031# u_loop.u_gh.C 0
C4149 _28_.Y VPWR 0.50694f
C4150 a_2603_8213# a_2766_9427# 0
C4151 u_loop.u_gh.C a_8583_6031# 0
C4152 u_loop.u_gh.C _67_.Q 0
C4153 a_4867_9673# a_4517_9301# 0.21971f
C4154 a_2143_6037# _35_.B 0
C4155 a_3514_7235# a_3388_7351# 0.00462f
C4156 a_4076_3561# u_loop.u_gh.B 0
C4157 a_6097_4641# a_6444_4399# 0.05116f
C4158 a_6619_4373# a_5529_4399# 0.04251f
C4159 VPWR a_2235_4949# 0.50315f
C4160 a_6444_4399# a_5529_4399# 0.12532f
C4161 _48_.Y _39_.B2 0.00131f
C4162 a_1920_7663# _35_.A_N 0
C4163 _32_.A a_8911_6031# 0
C4164 _36_.A _41_.B1 0.47105f
C4165 a_8800_8207# a_8468_7497# 0
C4166 a_6375_6037# a_7565_6409# 0
C4167 _28_.A a_2659_6409# 0
C4168 a_6891_6409# a_6796_6397# 0.04983f
C4169 a_5879_4399# a_6097_4641# 0.20964f
C4170 a_1499_6575# a_1735_7119# 0
C4171 a_8800_6031# _32_.A 0
C4172 a_5879_4399# a_5529_4399# 0.2298f
C4173 _28_.Y a_2235_6575# 0
C4174 _32_.A _67_.Q 0.00165f
C4175 u_loop.u_q.Y _55_.RESET_B 0
C4176 _52_.Y _35_.B 0
C4177 _32_.A a_8583_6031# 0
C4178 a_4833_2767# prenh 0.00239f
C4179 _53_.Y VPWR 0.59488f
C4180 u_loop.u_q.Y a_5293_5487# 0
C4181 _32_.A xb 0
C4182 _50_.Y a_2769_8213# 0.00197f
C4183 a_1735_6031# _35_.B 0.00156f
C4184 a_4351_9301# VPWR 0.45948f
C4185 a_1624_6031# _35_.B 0.01473f
C4186 a_2309_6037# _28_.A 0.00993f
C4187 a_2235_6575# a_2235_4949# 0
C4188 u_loop.u_d1.X a_4439_2767# 0
C4189 _40_.B a_3083_9537# 0.00547f
C4190 _67_.D u_loop.u_gh.C 0
C4191 _39_.X VPWR 1.04625f
C4192 a_6449_7663# a_6891_6409# 0
C4193 a_6541_6037# a_7553_4949# 0
C4194 a_2143_7119# a_2309_6037# 0
C4195 a_5036_2381# VPWR 0.24203f
C4196 a_4351_9301# _30_.A 0.01079f
C4197 a_6097_4641# a_5529_4399# 0.18639f
C4198 a_4038_8573# _40_.B 0
C4199 a_6651_3861# u_loop.u_d0.A 0
C4200 a_3381_8573# _62_.D 0
C4201 _34_.B1 a_1735_7119# 0
C4202 a_5175_2767# output6.A 0.02704f
C4203 a_7553_7125# _55_.RESET_B 0.07442f
C4204 a_3170_9295# _40_.B 0.00154f
C4205 a_1499_6575# pre 0.00207f
C4206 _68_.Q xa 0.03536f
C4207 a_6619_4373# a_5363_4399# 0.04359f
C4208 _57_.CLK a_4518_6575# 0
C4209 a_5691_3829# u_loop.u_d0.A 0.17418f
C4210 a_5363_4399# a_6444_4399# 0.10236f
C4211 a_6444_4399# u_loop.u_gl.A2 0
C4212 a_6541_6037# a_7387_4949# 0
C4213 _53_.Y a_2235_6575# 0
C4214 a_6339_8751# a_6557_8993# 0.20964f
C4215 a_2123_8029# u_loop.u_gh.C 0.0122f
C4216 a_4772_9661# VPWR 0.08426f
C4217 _41_.X _57_.CLK 0
C4218 a_6283_7663# a_7387_6575# 0
C4219 _55_.RESET_B a_7715_6575# 0.13437f
C4220 _68__14.LO a_7903_7497# 0
C4221 a_3514_7235# _38_.X 0
C4222 a_4158_7235# a_4032_7351# 0.00462f
C4223 _32_.A _67_.D 0.14108f
C4224 _63_.Q a_2015_7663# 0.00578f
C4225 a_3239_9269# a_2755_7637# 0
C4226 a_4292_2223# a_4333_2767# 0.00983f
C4227 _39_.B2 a_3083_9537# 0
C4228 a_5879_4399# u_loop.u_gl.A2 0
C4229 _32_.A a_6999_6031# 0
C4230 a_5879_4399# a_5363_4399# 0.11535f
C4231 a_4772_9661# _30_.A 0
C4232 a_7539_7637# a_7903_7497# 0.00145f
C4233 a_3044_9411# a_3549_9661# 0
C4234 a_4038_8573# _39_.B2 0
C4235 a_6541_6037# _42_.Y 0
C4236 _39_.X a_7017_7905# 0
C4237 pre _34_.B1 0
C4238 _56_.D u_loop.u_cmp.Y 0
C4239 a_3514_7235# _35_.B 0.00439f
C4240 a_1499_6575# a_1624_7119# 0.00164f
C4241 a_7604_6575# _55_.RESET_B 0.03897f
C4242 a_7109_6005# a_6449_7663# 0
C4243 _55_.RESET_B a_7387_6575# 0.01111f
C4244 u_loop.u_d2.X u_loop.u_d1.X 0.03682f
C4245 a_5569_2767# u_loop.u_d7.X 0
C4246 a_8800_8207# xa 0.00542f
C4247 a_6097_4641# a_5363_4399# 0.07009f
C4248 a_6097_4641# u_loop.u_gl.A2 0
C4249 a_5190_7439# _41_.B1 0.09653f
C4250 u_loop.u_gl.A2 a_5529_4399# 0
C4251 a_5363_4399# a_5529_4399# 0.88768f
C4252 a_7810_6397# _32_.A 0.002f
C4253 a_2015_7663# a_1665_7663# 0.2298f
C4254 a_4510_3311# a_4439_2767# 0
C4255 _55_.D u_loop.u_d0.A 0
C4256 a_2143_6037# _28_.A 0.0022f
C4257 _32_.A a_7565_6409# 0
C4258 u_loop.u_d6.X a_6739_2767# 0
C4259 _34_.B1 a_1624_7119# 0.00181f
C4260 a_6244_8751# VPWR 0.09656f
C4261 a_2143_7119# a_2143_6037# 0
C4262 prenh VGND 0.78549f
C4263 prenl VGND 1.06645f
C4264 x VGND 0.92178f
C4265 xb VGND 0.85734f
C4266 pre VGND 0.74268f
C4267 en VGND 1.48125f
C4268 src[0] VGND 0.61322f
C4269 src[1] VGND 0.76044f
C4270 xa VGND 0.91601f
C4271 VPWR VGND 0.25393p
C4272 a_6457_2473# VGND 0.00114f
C4273 a_5875_2223# VGND 0.29173f
C4274 a_5764_2223# VGND 0.28958f
C4275 a_5547_2223# VGND 0.29042f
C4276 a_5276_2197# VGND 0.2911f
C4277 a_5036_2381# VGND 0.29141f
C4278 a_4910_2197# VGND 0.2799f
C4279 a_4403_2223# VGND 0.27319f
C4280 a_4292_2223# VGND 0.28535f
C4281 a_4075_2223# VGND 0.34501f
C4282 a_2875_2223# VGND 0.27019f
C4283 a_2769_2223# VGND 0.44804f
C4284 a_2533_2223# VGND 0.46549f
C4285 u_loop.u_d7.X VGND 0.75596f
C4286 u_loop.u_d0.X VGND 0.37873f
C4287 a_6739_2767# VGND 0.29027f
C4288 a_6633_2767# VGND 0.4918f
C4289 a_6397_2767# VGND 0.42219f
C4290 u_loop.u_d6.X VGND 0.34072f
C4291 a_5911_2767# VGND 0.23837f
C4292 a_5805_2767# VGND 0.38755f
C4293 a_5569_2767# VGND 0.37733f
C4294 u_loop.u_d5.X VGND 0.26224f
C4295 a_5175_2767# VGND 0.23527f
C4296 a_5069_2767# VGND 0.38546f
C4297 a_4833_2767# VGND 0.37262f
C4298 u_loop.u_d4.X VGND 0.26159f
C4299 a_4439_2767# VGND 0.23153f
C4300 a_4333_2767# VGND 0.3795f
C4301 a_4097_2767# VGND 0.37308f
C4302 u_loop.u_d3.X VGND 0.26241f
C4303 a_3703_2767# VGND 0.24654f
C4304 a_3597_2767# VGND 0.40416f
C4305 a_3361_2767# VGND 0.38905f
C4306 u_loop.u_d2.X VGND 0.26659f
C4307 a_2967_2767# VGND 0.23324f
C4308 a_2861_2767# VGND 0.42386f
C4309 a_2625_2767# VGND 0.43798f
C4310 u_loop.u_d1.X VGND 0.53321f
C4311 a_2231_2767# VGND 0.24453f
C4312 a_2125_2767# VGND 0.412f
C4313 a_1889_2767# VGND 0.41995f
C4314 a_4510_3311# VGND 0.44765f
C4315 u_loop.u_q.B VGND 0.53645f
C4316 a_6381_3561# VGND 0
C4317 output7.A VGND 0.68976f
C4318 a_4076_3561# VGND 0.01597f
C4319 u_loop.u_qb.A VGND 0.36128f
C4320 u_loop.u_s1.Y VGND 0.37193f
C4321 u_loop.u_cmp.Y VGND 0.35256f
C4322 input5.X VGND 0.61529f
C4323 a_7894_3855# VGND 0
C4324 a_7275_3855# VGND 0.00766f
C4325 a_8086_4221# VGND 0.00236f
C4326 a_7841_4233# VGND 0.00105f
C4327 a_7429_4221# VGND 0.0061f
C4328 a_7263_4233# VGND 0.00932f
C4329 a_7072_4221# VGND 0.08072f
C4330 output6.A VGND 0.3908f
C4331 a_4769_4175# VGND 0.45591f
C4332 a_4351_4175# VGND 0.29997f
C4333 u_loop.u_gl.B1 VGND 0.63947f
C4334 a_7732_4233# VGND 0.28262f
C4335 a_7907_4159# VGND 0.6303f
C4336 a_7167_4233# VGND 0.2744f
C4337 a_7385_3829# VGND 0.19193f
C4338 a_6817_3861# VGND 0.34379f
C4339 a_6651_3861# VGND 0.71291f
C4340 a_5691_3829# VGND 0.39984f
C4341 u_loop.u_q.Y VGND 1.62506f
C4342 a_6798_4399# VGND 0.00448f
C4343 a_6553_4399# VGND 0.00118f
C4344 _55_.D VGND 0.83674f
C4345 a_6141_4399# VGND 0.00579f
C4346 a_5975_4399# VGND 0.00863f
C4347 a_6606_4765# VGND 0
C4348 a_3210_4399# VGND 0.00141f
C4349 a_2965_4399# VGND 0
C4350 a_5987_4765# VGND 0.00576f
C4351 a_5784_4399# VGND 0.08f
C4352 _55_.Q VGND 1.33056f
C4353 a_6444_4399# VGND 0.32033f
C4354 a_6619_4373# VGND 0.64072f
C4355 a_5879_4399# VGND 0.27366f
C4356 a_6097_4641# VGND 0.18384f
C4357 a_5529_4399# VGND 0.30992f
C4358 a_5363_4399# VGND 0.70345f
C4359 u_loop.u_gl.A2 VGND 0.82474f
C4360 a_2553_4399# VGND 0.00525f
C4361 a_2387_4399# VGND 0.0076f
C4362 a_3018_4765# VGND 0
C4363 a_2399_4765# VGND 0.01122f
C4364 a_2196_4399# VGND 0.08005f
C4365 a_2856_4399# VGND 0.27326f
C4366 a_3031_4373# VGND 0.59233f
C4367 a_2291_4399# VGND 0.27824f
C4368 a_2509_4641# VGND 0.21191f
C4369 a_1941_4399# VGND 0.32749f
C4370 a_1775_4399# VGND 0.64379f
C4371 u_loop.u_d0.A VGND 2.95291f
C4372 _27_.Y VGND 0.54086f
C4373 _53_.A VGND 2.04619f
C4374 a_8011_4943# VGND 0.00673f
C4375 a_8822_5309# VGND 0.00221f
C4376 a_8577_5321# VGND 0
C4377 a_8165_5309# VGND 0.00595f
C4378 a_7999_5321# VGND 0.00896f
C4379 a_7808_5309# VGND 0.08003f
C4380 _55_.CLK VGND 0.66629f
C4381 a_3478_4943# VGND 0
C4382 _56_.D VGND 0.38317f
C4383 u_loop.u_gh.B VGND 0.90725f
C4384 a_2859_4943# VGND 0.00838f
C4385 a_3670_5309# VGND 0.00137f
C4386 a_3425_5321# VGND 0
C4387 a_3013_5309# VGND 0.00525f
C4388 a_2847_5321# VGND 0.00845f
C4389 a_2656_5309# VGND 0.0941f
C4390 a_8468_5321# VGND 0.27857f
C4391 a_8643_5247# VGND 0.60962f
C4392 a_7903_5321# VGND 0.26386f
C4393 a_8121_4917# VGND 0.19007f
C4394 a_7553_4949# VGND 0.30672f
C4395 _25_.Y VGND 0.38026f
C4396 a_7387_4949# VGND 0.55433f
C4397 _42_.Y VGND 0.35701f
C4398 a_3316_5321# VGND 0.26898f
C4399 a_3491_5247# VGND 0.60154f
C4400 a_2751_5321# VGND 0.27848f
C4401 a_2969_4917# VGND 0.18514f
C4402 a_2401_4949# VGND 0.33603f
C4403 _28_.Y VGND 0.37316f
C4404 a_2235_4949# VGND 0.57898f
C4405 _53_.Y VGND 0.53294f
C4406 a_8362_5487# VGND 0.00232f
C4407 a_8117_5487# VGND 0.00103f
C4408 a_7705_5487# VGND 0.00516f
C4409 a_7539_5487# VGND 0.0073f
C4410 a_8170_5853# VGND 0
C4411 a_5377_5487# VGND 0.17765f
C4412 a_5293_5487# VGND 0.13298f
C4413 a_7551_5853# VGND 0.00588f
C4414 a_7348_5487# VGND 0.07553f
C4415 a_8008_5487# VGND 0.2706f
C4416 a_8183_5461# VGND 0.60964f
C4417 a_7443_5487# VGND 0.25707f
C4418 a_7661_5729# VGND 0.18213f
C4419 a_7093_5487# VGND 0.29752f
C4420 a_6927_5487# VGND 0.54364f
C4421 _56_.CLK VGND 0.74704f
C4422 _41_.X VGND 0.39436f
C4423 a_5649_5737# VGND 0
C4424 a_5389_5737# VGND 0
C4425 a_5190_5487# VGND 0.31844f
C4426 _25_.A VGND 1.92364f
C4427 _56_.Q VGND 1.16493f
C4428 _28_.A VGND 2.22561f
C4429 _67__13.LO VGND 0.10594f
C4430 a_8911_6031# VGND 0.29381f
C4431 a_8800_6031# VGND 0.29733f
C4432 a_8583_6031# VGND 0.32423f
C4433 _67_.Q VGND 0.41398f
C4434 a_7618_6031# VGND 0
C4435 _67_.D VGND 0.70857f
C4436 a_6999_6031# VGND 0.00653f
C4437 a_7810_6397# VGND 0.00133f
C4438 a_7565_6409# VGND 0
C4439 a_7153_6397# VGND 0.00524f
C4440 a_3386_6031# VGND 0
C4441 a_6987_6409# VGND 0.00744f
C4442 a_6796_6397# VGND 0.10085f
C4443 a_4369_6351# VGND 0.37653f
C4444 a_2767_6031# VGND 0.01417f
C4445 a_3578_6397# VGND 0.00244f
C4446 a_3333_6409# VGND 0.00103f
C4447 a_2921_6397# VGND 0.00623f
C4448 a_2755_6409# VGND 0.01432f
C4449 a_2564_6397# VGND 0.08472f
C4450 _20_.A VGND 0.48828f
C4451 a_7456_6409# VGND 0.26291f
C4452 a_7631_6335# VGND 0.57626f
C4453 a_6891_6409# VGND 0.26559f
C4454 a_7109_6005# VGND 0.17822f
C4455 a_6541_6037# VGND 0.32883f
C4456 _32_.Y VGND 0.4162f
C4457 a_6375_6037# VGND 0.58372f
C4458 _32_.A VGND 1.75676f
C4459 a_4167_6147# VGND 0.32388f
C4460 a_3224_6409# VGND 0.28067f
C4461 a_3399_6335# VGND 0.63659f
C4462 a_2659_6409# VGND 0.3154f
C4463 a_2877_6005# VGND 0.21415f
C4464 a_2309_6037# VGND 0.3481f
C4465 _23_.Y VGND 0.3994f
C4466 a_2143_6037# VGND 0.66594f
C4467 _52_.Y VGND 0.38291f
C4468 a_1735_6031# VGND 0.2636f
C4469 a_1624_6031# VGND 0.26121f
C4470 a_1407_6031# VGND 0.32294f
C4471 a_4518_6575# VGND 0.30445f
C4472 _57_.CLK VGND 0.61902f
C4473 a_4518_6825# VGND 0.00704f
C4474 a_4075_6825# VGND 0.00259f
C4475 a_1654_6575# VGND 0.09554f
C4476 a_1582_6575# VGND 0.0023f
C4477 a_7715_6575# VGND 0.29113f
C4478 a_7604_6575# VGND 0.28461f
C4479 a_7387_6575# VGND 0.32022f
C4480 a_4160_6575# VGND 0.51094f
C4481 _34_.X VGND 2.8176f
C4482 a_3436_6549# VGND 0.33208f
C4483 a_3196_6733# VGND 0.27652f
C4484 a_3070_6549# VGND 0.27656f
C4485 a_2563_6575# VGND 0.29088f
C4486 a_2452_6575# VGND 0.28118f
C4487 a_2235_6575# VGND 0.28999f
C4488 a_1499_6575# VGND 0.34417f
C4489 _34_.B1 VGND 1.00601f
C4490 _20_.Y VGND 0.57593f
C4491 a_8011_7119# VGND 0.00684f
C4492 a_8822_7485# VGND 0.00127f
C4493 a_8577_7497# VGND 0
C4494 a_8165_7485# VGND 0.00595f
C4495 a_5649_7119# VGND 0
C4496 a_5389_7119# VGND 0
C4497 a_7999_7497# VGND 0.00829f
C4498 a_7808_7485# VGND 0.07802f
C4499 a_4158_7235# VGND 0
C4500 a_4074_7235# VGND 0
C4501 a_5377_7439# VGND 0.17786f
C4502 a_5293_7439# VGND 0.13304f
C4503 _41_.C1 VGND 0.79332f
C4504 a_3514_7235# VGND 0
C4505 a_3430_7235# VGND 0
C4506 a_8468_7497# VGND 0.2696f
C4507 a_8643_7423# VGND 0.59168f
C4508 a_7903_7497# VGND 0.27196f
C4509 a_8121_7093# VGND 0.19548f
C4510 a_7553_7125# VGND 0.31277f
C4511 a_7387_7125# VGND 0.59948f
C4512 _39_.X VGND 0.61411f
C4513 a_5190_7439# VGND 0.32934f
C4514 _36_.A VGND 1.13753f
C4515 _41_.B1 VGND 0.65086f
C4516 a_3992_7235# VGND 0.40764f
C4517 a_4032_7351# VGND 0.27776f
C4518 _38_.X VGND 0.70961f
C4519 a_3348_7235# VGND 0.44268f
C4520 a_3388_7351# VGND 0.2376f
C4521 _35_.A_N VGND 1.78714f
C4522 _35_.B VGND 1.47096f
C4523 a_2471_7119# VGND 0.32273f
C4524 a_2360_7119# VGND 0.28643f
C4525 a_2143_7119# VGND 0.28411f
C4526 a_1735_7119# VGND 0.27778f
C4527 a_1624_7119# VGND 0.28273f
C4528 a_1407_7119# VGND 0.33728f
C4529 _68__14.LO VGND 0.19713f
C4530 _68_.D VGND 0.87643f
C4531 a_7718_7663# VGND 0.00137f
C4532 a_7473_7663# VGND 0
C4533 _45_.A VGND 2.32662f
C4534 a_7061_7663# VGND 0.00525f
C4535 a_6895_7663# VGND 0.00779f
C4536 a_7526_8029# VGND 0
C4537 a_2934_7663# VGND 0.00253f
C4538 a_2689_7663# VGND 0.00205f
C4539 a_6907_8029# VGND 0.00788f
C4540 a_6704_7663# VGND 0.09595f
C4541 a_7364_7663# VGND 0.26278f
C4542 a_7539_7637# VGND 0.59739f
C4543 a_6799_7663# VGND 0.29489f
C4544 a_7017_7905# VGND 0.20165f
C4545 a_6449_7663# VGND 0.34554f
C4546 _22_.Y VGND 0.63779f
C4547 a_6283_7663# VGND 0.59562f
C4548 _46_.Y VGND 0.34085f
C4549 a_2277_7663# VGND 0.00615f
C4550 a_2111_7663# VGND 0.00863f
C4551 a_2742_8029# VGND 0
C4552 a_2123_8029# VGND 0.00561f
C4553 a_1920_7663# VGND 0.08f
C4554 a_2580_7663# VGND 0.30537f
C4555 a_2755_7637# VGND 0.62488f
C4556 a_2015_7663# VGND 0.26741f
C4557 a_2233_7905# VGND 0.19214f
C4558 a_1665_7663# VGND 0.32379f
C4559 a_1499_7663# VGND 0.69431f
C4560 a_3846_8207# VGND 0
C4561 a_3227_8207# VGND 0.00684f
C4562 a_4038_8573# VGND 0.00236f
C4563 a_3793_8585# VGND 0.00106f
C4564 a_3381_8573# VGND 0.00612f
C4565 a_3215_8585# VGND 0.00934f
C4566 a_3024_8573# VGND 0.08133f
C4567 _63_.D VGND 0.50669f
C4568 _63_.CLK VGND 0.3887f
C4569 a_8911_8207# VGND 0.29405f
C4570 a_8800_8207# VGND 0.29721f
C4571 a_8583_8207# VGND 0.34641f
C4572 _68_.Q VGND 0.87959f
C4573 a_3684_8585# VGND 0.27883f
C4574 a_3859_8511# VGND 0.64264f
C4575 a_3119_8585# VGND 0.27662f
C4576 a_3337_8181# VGND 0.19202f
C4577 a_2769_8213# VGND 0.32228f
C4578 a_2603_8213# VGND 0.63561f
C4579 _50_.Y VGND 0.32134f
C4580 _63_.Q VGND 0.98513f
C4581 _23_.A VGND 1.55547f
C4582 a_7258_8751# VGND 0.00141f
C4583 a_7013_8751# VGND 0
C4584 _46_.A VGND 1.74782f
C4585 a_6601_8751# VGND 0.0066f
C4586 a_6435_8751# VGND 0.00745f
C4587 a_7066_9117# VGND 0
C4588 a_6447_9117# VGND 0.01379f
C4589 a_6244_8751# VGND 0.07894f
C4590 a_6904_8751# VGND 0.27965f
C4591 a_7079_8725# VGND 0.61574f
C4592 a_6339_8751# VGND 0.27847f
C4593 _55_.RESET_B VGND 4.5537f
C4594 a_6557_8993# VGND 0.20982f
C4595 a_5989_8751# VGND 0.34692f
C4596 _31_.Y VGND 0.82588f
C4597 a_5823_8751# VGND 0.65234f
C4598 _47_.Y VGND 0.36877f
C4599 _62_.D VGND 0.68259f
C4600 _40_.B VGND 1.33569f
C4601 _39_.B2 VGND 1.37605f
C4602 a_4975_9295# VGND 0.00473f
C4603 a_5786_9661# VGND 0.00221f
C4604 a_5541_9673# VGND 0
C4605 a_3384_9295# VGND 0.00575f
C4606 a_5129_9661# VGND 0.00579f
C4607 a_4963_9673# VGND 0.00863f
C4608 a_4772_9661# VGND 0.08015f
C4609 a_3000_9295# VGND 0
C4610 a_3802_9295# VGND 0.07994f
C4611 a_3549_9661# VGND 0.0092f
C4612 a_3477_9661# VGND 0.00609f
C4613 a_3041_9661# VGND 0.00112f
C4614 a_2801_9661# VGND 0.00448f
C4615 _30_.A VGND 0.87709f
C4616 a_5432_9673# VGND 0.26793f
C4617 a_5607_9599# VGND 0.60257f
C4618 a_4867_9673# VGND 0.25753f
C4619 a_5085_9269# VGND 0.18951f
C4620 a_4517_9301# VGND 0.31794f
C4621 _21_.Y VGND 0.41129f
C4622 a_4351_9301# VGND 0.51334f
C4623 _48_.Y VGND 0.34626f
C4624 _49_.Y VGND 0.36443f
C4625 _30_.Y VGND 0.38362f
C4626 a_3170_9295# VGND 0.19197f
C4627 a_3239_9269# VGND 0.2717f
C4628 a_3044_9411# VGND 0.312f
C4629 a_3083_9537# VGND 0.52126f
C4630 u_loop.u_gh.C VGND 8.72127f
C4631 a_2766_9427# VGND 0.29871f
C4632 a_2479_9269# VGND 0.67316f
.ends
