* NGSPICE file created from xc14fg.ext - technology: sky130A

.subckt xc14fg SEL0 SEL1 SEL2 SEL3 SEL4 SEL5 SEL6 SEL7 SEL8 SEL9 SEL10 X VB GND CP
X0 GND SEL6 a_4124_n392# GND sky130_fd_pr__nfet_01v8 ad=0.252 pd=2.28 as=0.252 ps=2.28 w=0.84 l=0.15
X1 X a_766_n26# a_706_n392# GND sky130_fd_pr__nfet_g5v0d10v5 ad=0.126 pd=1.44 as=0.126 ps=1.44 w=0.42 l=0.5
X2 X a_1586_n26# a_1526_n392# GND sky130_fd_pr__nfet_g5v0d10v5 ad=0.126 pd=1.44 as=0.126 ps=1.44 w=0.42 l=0.5
X3 X a_5942_n26# a_5882_n392# GND sky130_fd_pr__nfet_g5v0d10v5 ad=0.126 pd=1.44 as=0.126 ps=1.44 w=0.42 l=0.5
X4 GND SEL5 a_3304_n392# GND sky130_fd_pr__nfet_01v8 ad=0.252 pd=2.28 as=0.252 ps=2.28 w=0.84 l=0.15
X5 X a_4184_n26# a_4124_n392# GND sky130_fd_pr__nfet_g5v0d10v5 ad=0.126 pd=1.44 as=0.126 ps=1.44 w=0.42 l=0.5
X6 GND SEL9 a_7522_n392# GND sky130_fd_pr__nfet_01v8 ad=0.252 pd=2.28 as=0.252 ps=2.28 w=0.84 l=0.15
X7 X a_198_n26# a_138_n392# GND sky130_fd_pr__nfet_g5v0d10v5 ad=0.126 pd=1.44 as=0.126 ps=1.44 w=0.42 l=0.5
X8 GND SEL2 a_706_n392# GND sky130_fd_pr__nfet_01v8 ad=0.252 pd=2.28 as=0.252 ps=2.28 w=0.84 l=0.15
X9 GND SEL0 a_138_n392# GND sky130_fd_pr__nfet_01v8 ad=0.252 pd=2.28 as=0.252 ps=2.28 w=0.84 l=0.15
X10 GND SEL4 a_2484_n392# GND sky130_fd_pr__nfet_01v8 ad=0.252 pd=2.28 as=0.252 ps=2.28 w=0.84 l=0.15
X11 X a_8521_292# a_8480_n392# GND sky130_fd_pr__nfet_01v8 ad=0.126 pd=1.44 as=0.126 ps=1.44 w=0.42 l=0.15
X12 GND SEL8 a_6702_n392# GND sky130_fd_pr__nfet_01v8 ad=0.252 pd=2.28 as=0.252 ps=2.28 w=0.84 l=0.15
X13 GND a_5942_n26# sky130_fd_pr__diode_pw2nd_05v5 perim=1.8e+06 area=2.025e+11
X14 X a_6762_n26# a_6702_n392# GND sky130_fd_pr__nfet_g5v0d10v5 ad=0.126 pd=1.44 as=0.126 ps=1.44 w=0.42 l=0.5
X15 GND SEL1 a_422_n392# GND sky130_fd_pr__nfet_01v8 ad=0.252 pd=2.28 as=0.252 ps=2.28 w=0.84 l=0.15
X16 GND a_6762_n26# sky130_fd_pr__diode_pw2nd_05v5 perim=1.8e+06 area=2.025e+11
X17 X a_2544_n26# a_2484_n392# GND sky130_fd_pr__nfet_g5v0d10v5 ad=0.126 pd=1.44 as=0.126 ps=1.44 w=0.42 l=0.5
X18 GND SEL7 a_5882_n392# GND sky130_fd_pr__nfet_01v8 ad=0.252 pd=2.28 as=0.252 ps=2.28 w=0.84 l=0.15
X19 X a_482_n26# a_422_n392# GND sky130_fd_pr__nfet_g5v0d10v5 ad=0.126 pd=1.44 as=0.126 ps=1.44 w=0.42 l=0.5
X20 GND SEL3 a_1526_n392# GND sky130_fd_pr__nfet_01v8 ad=0.252 pd=2.28 as=0.252 ps=2.28 w=0.84 l=0.15
X21 X VB a_7522_n392# GND sky130_fd_pr__nfet_g5v0d10v5 ad=0.126 pd=1.44 as=0.126 ps=1.44 w=0.42 l=0.5
X22 GND SEL10 a_8480_n392# GND sky130_fd_pr__nfet_01v8 ad=0.252 pd=2.28 as=0.252 ps=2.28 w=0.84 l=0.15
X23 X a_3364_n26# a_3304_n392# GND sky130_fd_pr__nfet_g5v0d10v5 ad=0.126 pd=1.44 as=0.126 ps=1.44 w=0.42 l=0.5
C0 VB a_706_n392# 0.03757f
C1 a_198_n26# VB 0.0097f
C2 a_482_n26# SEL1 0.0073f
C3 SEL4 SEL3 0.01821f
C4 a_706_n392# CP 0.00331f
C5 a_198_n26# CP 0.13033f
C6 VB SEL5 0.00233f
C7 VB a_4184_n26# 0.0097f
C8 X SEL9 0
C9 X a_2484_n392# 0.0242f
C10 SEL0 a_138_n392# 0.0031f
C11 SEL5 CP 0.00519f
C12 a_4184_n26# CP 5.57426f
C13 VB a_3304_n392# 0.03902f
C14 VB a_766_n26# 0.0097f
C15 X SEL10 0.00115f
C16 a_422_n392# SEL1 0.0031f
C17 a_3304_n392# CP 0.00297f
C18 SEL9 SEL10 0.01821f
C19 a_766_n26# CP 1.64927f
C20 VB a_1586_n26# 0.0097f
C21 SEL3 X 0
C22 SEL3 a_2484_n392# 0
C23 a_1586_n26# CP 1.62859f
C24 VB a_1526_n392# 0.03913f
C25 a_5942_n26# a_5882_n392# 0.00801f
C26 X SEL1 0
C27 a_198_n26# SEL0 0.0073f
C28 VB a_8480_n392# 0.04134f
C29 a_482_n26# a_706_n392# 0.00116f
C30 CP a_1526_n392# 0.00331f
C31 a_422_n392# a_138_n392# 0.01981f
C32 VB a_4124_n392# 0.03938f
C33 VB a_8521_292# 0.22569f
C34 a_8480_n392# CP 0.00297f
C35 a_198_n26# a_482_n26# 0.05701f
C36 VB SEL6 0.00233f
C37 a_4124_n392# CP 0.00297f
C38 a_8521_292# CP 3.01945f
C39 a_6762_n26# SEL8 0.00738f
C40 VB a_3364_n26# 0.0097f
C41 SEL6 CP 0.00519f
C42 a_3364_n26# CP 2.76394f
C43 X a_138_n392# 0.02118f
C44 a_422_n392# a_706_n392# 0.01981f
C45 a_482_n26# a_766_n26# 0.05701f
C46 a_198_n26# a_422_n392# 0.00116f
C47 SEL4 SEL5 0.02137f
C48 SEL4 a_3304_n392# 0
C49 a_6762_n26# a_5942_n26# 0.64397f
C50 X a_706_n392# 0.04316f
C51 a_198_n26# X 0.10844f
C52 a_6702_n392# SEL8 0.0031f
C53 X SEL5 0
C54 X a_4184_n26# 0.69293f
C55 X a_3304_n392# 0.02485f
C56 X a_766_n26# 0.37379f
C57 SEL7 SEL8 0.02137f
C58 a_7522_n392# a_8480_n392# 0.00402f
C59 a_3304_n392# a_2484_n392# 0.00677f
C60 VB SEL8 0.00233f
C61 X a_1586_n26# 0.37221f
C62 a_706_n392# SEL1 0
C63 a_1586_n26# a_2484_n392# 0
C64 SEL8 CP 0.00519f
C65 a_6702_n392# a_5942_n26# 0
C66 a_6702_n392# a_5882_n392# 0.00677f
C67 X a_1526_n392# 0.02485f
C68 a_2484_n392# a_1526_n392# 0.00579f
C69 X a_8480_n392# 0.03501f
C70 SEL3 a_1586_n26# 0.00736f
C71 SEL9 a_8480_n392# 0
C72 X a_4124_n392# 0.02485f
C73 X a_8521_292# 0.34957f
C74 SEL7 a_5942_n26# 0.00738f
C75 SEL7 a_5882_n392# 0.0031f
C76 VB a_5942_n26# 0.01003f
C77 X SEL6 0
C78 VB a_5882_n392# 0.03938f
C79 a_198_n26# a_138_n392# 0.00715f
C80 SEL10 a_8480_n392# 0.0031f
C81 SEL3 a_1526_n392# 0.0031f
C82 a_3364_n26# X 0.3723f
C83 a_5942_n26# CP 2.89868f
C84 a_5882_n392# CP 0.00297f
C85 SEL10 a_8521_292# 0.00546f
C86 a_2544_n26# VB 0.0097f
C87 a_2544_n26# CP 2.92894f
C88 VB SEL2 0.00233f
C89 a_6702_n392# a_6762_n26# 0.00801f
C90 SEL2 CP 0.00524f
C91 a_7522_n392# SEL8 0
C92 a_766_n26# a_706_n392# 0.00781f
C93 VB a_6762_n26# 0.654f
C94 a_6762_n26# CP 2.76398f
C95 SEL5 a_3304_n392# 0.0031f
C96 X SEL8 0
C97 a_706_n392# a_1526_n392# 0.00677f
C98 SEL9 SEL8 0.02137f
C99 a_1586_n26# a_766_n26# 0.32912f
C100 a_2544_n26# SEL4 0.00738f
C101 SEL7 a_6702_n392# 0
C102 a_4124_n392# SEL5 0
C103 a_4124_n392# a_4184_n26# 0.00801f
C104 a_766_n26# a_1526_n392# 0
C105 VB a_6702_n392# 0.03906f
C106 X a_5942_n26# 0.38096f
C107 SEL6 SEL5 0.02137f
C108 SEL6 a_4184_n26# 0.00738f
C109 a_4124_n392# a_3304_n392# 0.00677f
C110 X a_5882_n392# 0.02267f
C111 a_1586_n26# a_1526_n392# 0.00781f
C112 a_6702_n392# CP 0.00297f
C113 a_3364_n26# SEL5 0.00738f
C114 a_3364_n26# a_4184_n26# 0.6434f
C115 SEL7 VB 0.00233f
C116 a_2544_n26# X 0.37238f
C117 a_3364_n26# a_3304_n392# 0.00801f
C118 a_2544_n26# a_2484_n392# 0.00801f
C119 SEL7 CP 0.00519f
C120 VB CP 2.9564f
C121 a_7522_n392# a_6762_n26# 0
C122 X SEL2 0
C123 a_8521_292# a_8480_n392# 0.00443f
C124 a_4124_n392# SEL6 0.0031f
C125 a_3364_n26# a_4124_n392# 0
C126 SEL3 SEL2 0.02137f
C127 X a_6762_n26# 0.38065f
C128 VB SEL0 0.00233f
C129 SEL1 SEL2 0.06585f
C130 SEL0 CP 0.00535f
C131 VB a_482_n26# 0.0097f
C132 a_7522_n392# a_6702_n392# 0.00677f
C133 a_482_n26# CP 0.12954f
C134 VB SEL4 0.00233f
C135 VB a_7522_n392# 0.07496f
C136 SEL4 CP 0.00519f
C137 VB a_422_n392# 0.03612f
C138 a_6702_n392# X 0.02485f
C139 a_7522_n392# CP 0.00297f
C140 a_5942_n26# a_4184_n26# 0.21533f
C141 a_422_n392# CP 0.00424f
C142 a_706_n392# SEL2 0.0031f
C143 SEL7 X 0
C144 VB X 1.97918f
C145 VB SEL9 0.01633f
C146 VB a_2484_n392# 0.03913f
C147 a_2544_n26# a_3304_n392# 0
C148 X CP 0.9439f
C149 SEL9 CP 0.00519f
C150 a_2484_n392# CP 0.00297f
C151 VB SEL10 0.00233f
C152 a_2544_n26# a_1586_n26# 0.11645f
C153 VB SEL3 0.00233f
C154 a_766_n26# SEL2 0.00736f
C155 SEL10 CP 0.00519f
C156 a_422_n392# SEL0 0
C157 SEL3 CP 0.00524f
C158 a_422_n392# a_482_n26# 0.00715f
C159 VB SEL1 0.00233f
C160 SEL1 CP 0.00535f
C161 SEL2 a_1526_n392# 0
C162 SEL0 X 0
C163 a_2544_n26# a_3364_n26# 0.6434f
C164 X a_482_n26# 0.11266f
C165 VB a_138_n392# 0.03482f
C166 a_138_n392# CP 0.00424f
C167 SEL4 X 0
C168 SEL4 a_2484_n392# 0.0031f
C169 a_7522_n392# X 0.02485f
C170 a_7522_n392# SEL9 0.0031f
C171 a_422_n392# X 0.04316f
C172 SEL0 SEL1 0.06585f
C173 CP GND 4.47477f
C174 SEL10 GND 0.35937f
C175 SEL9 GND 0.32687f
C176 SEL8 GND 0.32762f
C177 SEL7 GND 0.35396f
C178 SEL6 GND 0.35396f
C179 SEL5 GND 0.32762f
C180 SEL4 GND 0.33107f
C181 SEL3 GND 0.33107f
C182 SEL2 GND 0.29683f
C183 SEL1 GND 0.26598f
C184 SEL0 GND 0.32312f
C185 X GND 2.02001f
C186 VB GND 4.71953f
C187 a_8480_n392# GND 0.22988f
C188 a_7522_n392# GND 0.20256f
C189 a_6702_n392# GND 0.21311f
C190 a_5882_n392# GND 0.23326f
C191 a_4124_n392# GND 0.22238f
C192 a_3304_n392# GND 0.21311f
C193 a_2484_n392# GND 0.22218f
C194 a_1526_n392# GND 0.21441f
C195 a_706_n392# GND 0.19145f
C196 a_422_n392# GND 0.17765f
C197 a_138_n392# GND 0.22151f
C198 a_8521_292# GND 1.21686f
C199 a_6762_n26# GND 1.1203f
C200 a_5942_n26# GND 1.17457f
C201 a_4184_n26# GND 1.816f
C202 a_3364_n26# GND 1.06865f
C203 a_2544_n26# GND 1.18997f
C204 a_1586_n26# GND 0.82737f
C205 a_766_n26# GND 0.86483f
C206 a_482_n26# GND 0.36805f
C207 a_198_n26# GND 0.41578f
.ends
