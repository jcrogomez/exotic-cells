* NGSPICE file created from xc14fg.ext - technology: sky130A

.subckt xc14fg SEL0 SEL1 SEL2 SEL3 SEL4 SEL5 SEL6 SEL7 SEL8 SEL9 SEL10 X VB GND CP
X0 X a_3484_n26# a_3424_n392# GND sky130_fd_pr__nfet_g5v0d10v5 ad=0.126 pd=1.44 as=0.126 ps=1.44 w=0.42 l=0.5
X1 X a_766_n26# a_706_n392# GND sky130_fd_pr__nfet_g5v0d10v5 ad=0.126 pd=1.44 as=0.126 ps=1.44 w=0.42 l=0.5
X2 GND SEL9 a_7802_n392# GND sky130_fd_pr__nfet_01v8 ad=0.252 pd=2.28 as=0.252 ps=2.28 w=0.84 l=0.15
X3 X a_7002_n26# a_6942_n392# GND sky130_fd_pr__nfet_g5v0d10v5 ad=0.126 pd=1.44 as=0.126 ps=1.44 w=0.42 l=0.5
X4 X a_198_n26# a_138_n392# GND sky130_fd_pr__nfet_g5v0d10v5 ad=0.126 pd=1.44 as=0.126 ps=1.44 w=0.42 l=0.5
X5 GND SEL3 a_1566_n392# GND sky130_fd_pr__nfet_01v8 ad=0.252 pd=2.28 as=0.252 ps=2.28 w=0.84 l=0.15
X6 GND SEL2 a_706_n392# GND sky130_fd_pr__nfet_01v8 ad=0.252 pd=2.28 as=0.252 ps=2.28 w=0.84 l=0.15
X7 GND SEL5 a_3424_n392# GND sky130_fd_pr__nfet_01v8 ad=0.252 pd=2.28 as=0.252 ps=2.28 w=0.84 l=0.15
X8 GND SEL0 a_138_n392# GND sky130_fd_pr__nfet_01v8 ad=0.252 pd=2.28 as=0.252 ps=2.28 w=0.84 l=0.15
X9 X VB a_7802_n392# GND sky130_fd_pr__nfet_g5v0d10v5 ad=0.126 pd=1.44 as=0.126 ps=1.44 w=0.42 l=0.5
X10 X a_1626_n26# a_1566_n392# GND sky130_fd_pr__nfet_g5v0d10v5 ad=0.126 pd=1.44 as=0.126 ps=1.44 w=0.42 l=0.5
X11 X a_6142_n26# a_6082_n392# GND sky130_fd_pr__nfet_g5v0d10v5 ad=0.126 pd=1.44 as=0.126 ps=1.44 w=0.42 l=0.5
X12 GND SEL1 a_422_n392# GND sky130_fd_pr__nfet_01v8 ad=0.252 pd=2.28 as=0.252 ps=2.28 w=0.84 l=0.15
X13 GND SEL7 a_6082_n392# GND sky130_fd_pr__nfet_01v8 ad=0.252 pd=2.28 as=0.252 ps=2.28 w=0.84 l=0.15
X14 GND SEL10 a_8800_n392# GND sky130_fd_pr__nfet_01v8 ad=0.252 pd=2.28 as=0.252 ps=2.28 w=0.84 l=0.15
X15 X a_482_n26# a_422_n392# GND sky130_fd_pr__nfet_g5v0d10v5 ad=0.126 pd=1.44 as=0.126 ps=1.44 w=0.42 l=0.5
X16 GND SEL6 a_4284_n392# GND sky130_fd_pr__nfet_01v8 ad=0.252 pd=2.28 as=0.252 ps=2.28 w=0.84 l=0.15
X17 GND a_7002_n26# sky130_fd_pr__diode_pw2nd_05v5 perim=1.8e+06 area=2.025e+11
X18 GND SEL4 a_2564_n392# GND sky130_fd_pr__nfet_01v8 ad=0.252 pd=2.28 as=0.252 ps=2.28 w=0.84 l=0.15
X19 X a_4344_n26# a_4284_n392# GND sky130_fd_pr__nfet_g5v0d10v5 ad=0.126 pd=1.44 as=0.126 ps=1.44 w=0.42 l=0.5
X20 X a_8841_292# a_8800_n392# GND sky130_fd_pr__nfet_01v8 ad=0.126 pd=1.44 as=0.126 ps=1.44 w=0.42 l=0.15
X21 GND SEL8 a_6942_n392# GND sky130_fd_pr__nfet_01v8 ad=0.252 pd=2.28 as=0.252 ps=2.28 w=0.84 l=0.15
X22 X a_2624_n26# a_2564_n392# GND sky130_fd_pr__nfet_g5v0d10v5 ad=0.126 pd=1.44 as=0.126 ps=1.44 w=0.42 l=0.5
X23 GND a_6142_n26# sky130_fd_pr__diode_pw2nd_05v5 perim=1.8e+06 area=2.025e+11
C0 VB SEL6 0.00233f
C1 VB a_6142_n26# 0.01003f
C2 a_8800_n392# SEL9 0
C3 a_766_n26# SEL2 0.00736f
C4 VB a_4284_n392# 0.03941f
C5 a_482_n26# VB 0.0097f
C6 X a_8841_292# 0.34961f
C7 a_138_n392# a_422_n392# 0.01981f
C8 a_1626_n26# a_1566_n392# 0.00781f
C9 a_4344_n26# VB 0.0097f
C10 SEL6 a_4284_n392# 0.0031f
C11 a_1626_n26# VB 0.0097f
C12 a_1566_n392# a_2564_n392# 0.00555f
C13 a_4344_n26# SEL6 0.00738f
C14 a_4344_n26# a_6142_n26# 0.1807f
C15 SEL10 SEL9 0.01746f
C16 VB a_2564_n392# 0.03918f
C17 a_4344_n26# a_4284_n392# 0.00801f
C18 a_6082_n392# VB 0.03941f
C19 CP SEL9 0.00519f
C20 VB a_138_n392# 0.03482f
C21 VB SEL7 0.00233f
C22 SEL8 a_7802_n392# 0
C23 a_6082_n392# a_6142_n26# 0.00801f
C24 a_3484_n26# VB 0.0097f
C25 X a_7802_n392# 0.02463f
C26 a_1566_n392# a_766_n26# 0
C27 SEL7 a_6142_n26# 0.00738f
C28 VB a_766_n26# 0.0097f
C29 a_1626_n26# a_2564_n392# 0
C30 SEL8 X 0
C31 a_3484_n26# a_4284_n392# 0
C32 a_7002_n26# CP 2.89203f
C33 CP a_6942_n392# 0.00297f
C34 a_2624_n26# a_3424_n392# 0
C35 a_482_n26# a_766_n26# 0.05701f
C36 a_3484_n26# a_4344_n26# 0.41332f
C37 a_8800_n392# a_8841_292# 0.00443f
C38 a_2624_n26# CP 2.9993f
C39 a_2624_n26# SEL4 0.00738f
C40 a_1626_n26# a_766_n26# 0.21332f
C41 a_6082_n392# SEL7 0.0031f
C42 CP SEL3 0.00524f
C43 SEL4 SEL3 0.01746f
C44 a_8841_292# SEL10 0.00546f
C45 VB SEL9 0.01633f
C46 X SEL1 0
C47 SEL2 SEL3 0.02034f
C48 a_8841_292# CP 3.03497f
C49 X a_198_n26# 0.10844f
C50 a_8800_n392# a_7802_n392# 0.00386f
C51 X SEL5 0
C52 a_7002_n26# VB 0.42385f
C53 X a_8800_n392# 0.03486f
C54 VB a_6942_n392# 0.03912f
C55 X a_706_n392# 0.04316f
C56 a_7002_n26# a_6142_n26# 0.41382f
C57 a_6942_n392# a_6142_n26# 0
C58 a_2624_n26# VB 0.0097f
C59 a_1566_n392# SEL3 0.0031f
C60 a_7802_n392# CP 0.00297f
C61 X SEL0 0
C62 VB SEL3 0.00233f
C63 X SEL10 0.00115f
C64 X a_3424_n392# 0.02463f
C65 SEL8 CP 0.00519f
C66 X CP 1.01191f
C67 a_2624_n26# a_1626_n26# 0.09861f
C68 X SEL4 0
C69 a_706_n392# SEL1 0
C70 a_8841_292# VB 0.19072f
C71 a_6082_n392# a_6942_n392# 0.00645f
C72 a_2624_n26# a_2564_n392# 0.00801f
C73 a_1626_n26# SEL3 0.00736f
C74 SEL7 a_6942_n392# 0
C75 X SEL2 0
C76 SEL3 a_2564_n392# 0
C77 SEL1 SEL0 0.06585f
C78 a_2624_n26# a_3484_n26# 0.41332f
C79 SEL0 a_198_n26# 0.0073f
C80 SEL1 CP 0.00535f
C81 X a_422_n392# 0.04316f
C82 a_198_n26# CP 0.13033f
C83 a_7802_n392# VB 0.07499f
C84 SEL5 a_3424_n392# 0.0031f
C85 a_8800_n392# SEL10 0.0031f
C86 SEL1 SEL2 0.06585f
C87 SEL5 CP 0.00519f
C88 X a_1566_n392# 0.02463f
C89 SEL8 VB 0.00233f
C90 a_8800_n392# CP 0.00297f
C91 X VB 2.03277f
C92 SEL5 SEL4 0.02034f
C93 a_706_n392# CP 0.00331f
C94 X SEL6 0
C95 X a_6142_n26# 0.38102f
C96 SEL1 a_422_n392# 0.0031f
C97 X a_4284_n392# 0.02463f
C98 X a_482_n26# 0.11266f
C99 a_706_n392# SEL2 0.0031f
C100 SEL0 CP 0.00535f
C101 a_198_n26# a_422_n392# 0.00116f
C102 SEL10 CP 0.00519f
C103 X a_4344_n26# 0.69296f
C104 CP a_3424_n392# 0.00297f
C105 X a_1626_n26# 0.37228f
C106 SEL4 a_3424_n392# 0
C107 X a_2564_n392# 0.02405f
C108 a_7002_n26# a_6942_n392# 0.00801f
C109 SEL1 VB 0.00233f
C110 SEL4 CP 0.00519f
C111 a_706_n392# a_422_n392# 0.01981f
C112 X a_6082_n392# 0.02263f
C113 X a_138_n392# 0.02118f
C114 SEL8 SEL7 0.02034f
C115 a_198_n26# VB 0.0097f
C116 X SEL7 0
C117 CP SEL2 0.00524f
C118 X a_3484_n26# 0.37238f
C119 SEL1 a_482_n26# 0.0073f
C120 SEL5 VB 0.00233f
C121 X a_766_n26# 0.37385f
C122 SEL0 a_422_n392# 0
C123 a_706_n392# a_1566_n392# 0.00645f
C124 a_8800_n392# VB 0.04127f
C125 a_198_n26# a_482_n26# 0.05701f
C126 a_706_n392# VB 0.03761f
C127 SEL5 SEL6 0.02034f
C128 CP a_422_n392# 0.00424f
C129 SEL5 a_4284_n392# 0
C130 a_706_n392# a_482_n26# 0.00116f
C131 SEL0 VB 0.00233f
C132 SEL10 VB 0.00233f
C133 VB a_3424_n392# 0.03909f
C134 a_198_n26# a_138_n392# 0.00715f
C135 a_7802_n392# SEL9 0.0031f
C136 a_1566_n392# CP 0.00331f
C137 VB CP 3.0351f
C138 SEL4 VB 0.00233f
C139 a_4284_n392# a_3424_n392# 0.00645f
C140 SEL8 SEL9 0.02034f
C141 SEL6 CP 0.00519f
C142 CP a_6142_n26# 2.97531f
C143 X SEL9 0
C144 a_1566_n392# SEL2 0
C145 CP a_4284_n392# 0.00297f
C146 SEL5 a_3484_n26# 0.00738f
C147 a_482_n26# CP 0.12954f
C148 VB SEL2 0.00233f
C149 a_7802_n392# a_7002_n26# 0
C150 a_7802_n392# a_6942_n392# 0.00645f
C151 a_4344_n26# CP 5.65086f
C152 a_3424_n392# a_2564_n392# 0.00645f
C153 a_1626_n26# CP 1.66724f
C154 a_706_n392# a_766_n26# 0.00781f
C155 SEL0 a_138_n392# 0.0031f
C156 SEL8 a_7002_n26# 0.00738f
C157 SEL8 a_6942_n392# 0.0031f
C158 CP a_2564_n392# 0.00297f
C159 X a_7002_n26# 0.38073f
C160 X a_6942_n392# 0.02463f
C161 VB a_422_n392# 0.03612f
C162 SEL4 a_2564_n392# 0.0031f
C163 a_6082_n392# CP 0.00297f
C164 CP a_138_n392# 0.00424f
C165 a_3484_n26# a_3424_n392# 0.00801f
C166 a_2624_n26# X 0.37246f
C167 SEL7 CP 0.00519f
C168 a_3484_n26# CP 2.89192f
C169 a_482_n26# a_422_n392# 0.00715f
C170 VB a_1566_n392# 0.03918f
C171 CP a_766_n26# 1.68122f
C172 X SEL3 0
C173 CP GND 4.73134f
C174 SEL10 GND 0.36022f
C175 SEL9 GND 0.32881f
C176 SEL8 GND 0.32981f
C177 SEL7 GND 0.35505f
C178 SEL6 GND 0.35506f
C179 SEL5 GND 0.32981f
C180 SEL4 GND 0.33301f
C181 SEL3 GND 0.33301f
C182 SEL2 GND 0.29792f
C183 SEL1 GND 0.26598f
C184 SEL0 GND 0.32312f
C185 X GND 2.1287f
C186 VB GND 4.86982f
C187 a_8800_n392# GND 0.23047f
C188 a_7802_n392# GND 0.20358f
C189 a_6942_n392# GND 0.21433f
C190 a_6082_n392# GND 0.23373f
C191 a_4284_n392# GND 0.22318f
C192 a_3424_n392# GND 0.21433f
C193 a_2564_n392# GND 0.22315f
C194 a_1566_n392# GND 0.21553f
C195 a_706_n392# GND 0.19187f
C196 a_422_n392# GND 0.17765f
C197 a_138_n392# GND 0.22151f
C198 a_8841_292# GND 1.22824f
C199 a_7002_n26# GND 1.14773f
C200 a_6142_n26# GND 1.19927f
C201 a_4344_n26# GND 1.84067f
C202 a_3484_n26# GND 1.096f
C203 a_2624_n26# GND 1.20951f
C204 a_1626_n26# GND 0.84033f
C205 a_766_n26# GND 0.87192f
C206 a_482_n26# GND 0.36805f
C207 a_198_n26# GND 0.41578f
.ends
