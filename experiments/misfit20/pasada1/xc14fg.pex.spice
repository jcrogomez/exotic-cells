* NGSPICE file created from xc14fg.ext - technology: sky130A

.subckt xc14fg SEL0 SEL1 SEL2 SEL3 SEL4 SEL5 SEL6 SEL7 SEL8 SEL9 SEL10 X VB GND CP
X0 X a_8773_282# a_8732_n392# GND sky130_fd_pr__nfet_01v8 ad=0.126 pd=1.44 as=0.126 ps=1.44 w=0.42 l=0.15
X1 GND SEL5 a_3386_n392# GND sky130_fd_pr__nfet_01v8 ad=0.252 pd=2.28 as=0.252 ps=2.28 w=0.84 l=0.15
X2 X a_2592_n26# a_2532_n392# GND sky130_fd_pr__nfet_g5v0d10v5 ad=0.126 pd=1.44 as=0.126 ps=1.44 w=0.42 l=0.5
X3 X a_4300_n26# a_4240_n392# GND sky130_fd_pr__nfet_g5v0d10v5 ad=0.126 pd=1.44 as=0.126 ps=1.44 w=0.42 l=0.5
X4 X a_6092_n26# a_6032_n392# GND sky130_fd_pr__nfet_g5v0d10v5 ad=0.126 pd=1.44 as=0.126 ps=1.44 w=0.42 l=0.5
X5 X a_746_n26# a_686_n392# GND sky130_fd_pr__nfet_g5v0d10v5 ad=0.126 pd=1.44 as=0.126 ps=1.44 w=0.42 l=0.5
X6 GND a_6092_n26# sky130_fd_pr__diode_pw2nd_05v5 perim=1.8e+06 area=2.025e+11
X7 X VB a_7740_n392# GND sky130_fd_pr__nfet_g5v0d10v5 ad=0.126 pd=1.44 as=0.126 ps=1.44 w=0.42 l=0.5
X8 GND SEL7 a_6032_n392# GND sky130_fd_pr__nfet_01v8 ad=0.252 pd=2.28 as=0.252 ps=2.28 w=0.84 l=0.15
X9 GND a_6946_n26# sky130_fd_pr__diode_pw2nd_05v5 perim=1.8e+06 area=2.025e+11
X10 X a_198_n26# a_138_n392# GND sky130_fd_pr__nfet_g5v0d10v5 ad=0.126 pd=1.44 as=0.126 ps=1.44 w=0.42 l=0.5
X11 GND SEL0 a_138_n392# GND sky130_fd_pr__nfet_01v8 ad=0.252 pd=2.28 as=0.252 ps=2.28 w=0.84 l=0.15
X12 GND SEL10 a_8732_n392# GND sky130_fd_pr__nfet_01v8 ad=0.252 pd=2.28 as=0.252 ps=2.28 w=0.84 l=0.15
X13 GND SEL4 a_2532_n392# GND sky130_fd_pr__nfet_01v8 ad=0.252 pd=2.28 as=0.252 ps=2.28 w=0.84 l=0.15
X14 GND SEL9 a_7740_n392# GND sky130_fd_pr__nfet_01v8 ad=0.252 pd=2.28 as=0.252 ps=2.28 w=0.84 l=0.15
X15 X a_1600_n26# a_1540_n392# GND sky130_fd_pr__nfet_g5v0d10v5 ad=0.126 pd=1.44 as=0.126 ps=1.44 w=0.42 l=0.5
X16 GND SEL3 a_1540_n392# GND sky130_fd_pr__nfet_01v8 ad=0.252 pd=2.28 as=0.252 ps=2.28 w=0.84 l=0.15
X17 GND SEL8 a_6886_n392# GND sky130_fd_pr__nfet_01v8 ad=0.252 pd=2.28 as=0.252 ps=2.28 w=0.84 l=0.15
X18 X a_3446_n26# a_3386_n392# GND sky130_fd_pr__nfet_g5v0d10v5 ad=0.126 pd=1.44 as=0.126 ps=1.44 w=0.42 l=0.5
X19 X a_6946_n26# a_6886_n392# GND sky130_fd_pr__nfet_g5v0d10v5 ad=0.126 pd=1.44 as=0.126 ps=1.44 w=0.42 l=0.5
X20 X a_472_n26# a_412_n392# GND sky130_fd_pr__nfet_g5v0d10v5 ad=0.126 pd=1.44 as=0.126 ps=1.44 w=0.42 l=0.5
X21 GND SEL1 a_412_n392# GND sky130_fd_pr__nfet_01v8 ad=0.252 pd=2.28 as=0.252 ps=2.28 w=0.84 l=0.15
X22 GND SEL6 a_4240_n392# GND sky130_fd_pr__nfet_01v8 ad=0.252 pd=2.28 as=0.252 ps=2.28 w=0.84 l=0.15
X23 GND SEL2 a_686_n392# GND sky130_fd_pr__nfet_01v8 ad=0.252 pd=2.28 as=0.252 ps=2.28 w=0.84 l=0.15
C0 SEL10 CP 0.00527f
C1 a_746_n26# a_1600_n26# 0.22485f
C2 SEL1 a_472_n26# 0.00724f
C3 SEL1 VB 0.00233f
C4 a_6886_n392# a_6092_n26# 0
C5 a_3446_n26# a_4240_n392# 0
C6 a_4240_n392# VB 0.03941f
C7 SEL6 X 0
C8 a_2532_n392# a_1600_n26# 0
C9 a_4300_n26# a_6092_n26# 0.18517f
C10 a_412_n392# a_198_n26# 0.00127f
C11 SEL2 CP 0.00532f
C12 a_2592_n26# a_1600_n26# 0.10074f
C13 SEL3 a_1600_n26# 0.0073f
C14 SEL6 a_4240_n392# 0.0031f
C15 a_198_n26# SEL0 0.00724f
C16 a_7740_n392# CP 0.00306f
C17 CP X 1.12505f
C18 a_2532_n392# a_3386_n392# 0.0065f
C19 CP SEL1 0.00542f
C20 a_1540_n392# a_1600_n26# 0.00788f
C21 a_746_n26# a_1540_n392# 0
C22 a_6032_n392# VB 0.03941f
C23 a_746_n26# a_472_n26# 0.05935f
C24 a_1600_n26# VB 0.00971f
C25 a_746_n26# VB 0.00971f
C26 a_2592_n26# a_2532_n392# 0.00808f
C27 a_412_n392# SEL0 0
C28 a_2532_n392# SEL3 0
C29 a_2592_n26# a_3386_n392# 0
C30 a_198_n26# a_472_n26# 0.05935f
C31 a_198_n26# VB 0.00971f
C32 a_4240_n392# CP 0.00306f
C33 a_2532_n392# SEL4 0.0031f
C34 SEL7 X 0
C35 a_3446_n26# a_3386_n392# 0.00808f
C36 a_3386_n392# SEL4 0
C37 SEL10 a_8773_282# 0.00547f
C38 a_6946_n26# a_6886_n392# 0.00808f
C39 a_1540_n392# a_2532_n392# 0.00559f
C40 a_2532_n392# VB 0.03918f
C41 a_412_n392# a_472_n26# 0.00718f
C42 a_412_n392# VB 0.03596f
C43 a_3386_n392# VB 0.03908f
C44 a_3446_n26# a_2592_n26# 0.43639f
C45 a_2592_n26# SEL4 0.00733f
C46 SEL3 SEL4 0.01756f
C47 SEL0 VB 0.00233f
C48 a_2592_n26# VB 0.00971f
C49 a_1540_n392# SEL3 0.0031f
C50 a_8732_n392# VB 0.04127f
C51 SEL3 VB 0.00233f
C52 a_6092_n26# X 0.41362f
C53 SEL8 VB 0.00233f
C54 a_3446_n26# VB 0.00971f
C55 a_6032_n392# CP 0.00306f
C56 a_1600_n26# CP 1.66224f
C57 a_746_n26# CP 1.67625f
C58 SEL4 VB 0.00233f
C59 a_1540_n392# VB 0.03918f
C60 a_472_n26# VB 0.00971f
C61 CP a_198_n26# 0.12945f
C62 SEL10 SEL9 0.01756f
C63 a_8773_282# X 0.38187f
C64 a_2532_n392# CP 0.00306f
C65 a_412_n392# CP 0.00437f
C66 a_686_n392# SEL2 0.0031f
C67 a_3386_n392# CP 0.00306f
C68 a_6032_n392# SEL7 0.0031f
C69 SEL6 VB 0.00233f
C70 CP SEL0 0.00542f
C71 a_686_n392# X 0.04538f
C72 a_2592_n26# CP 2.99042f
C73 CP a_8732_n392# 0.00306f
C74 SEL3 CP 0.00532f
C75 a_686_n392# SEL1 0
C76 CP SEL8 0.00527f
C77 a_3446_n26# CP 2.87602f
C78 SEL4 CP 0.00527f
C79 a_6032_n392# a_6092_n26# 0.00808f
C80 SEL5 X 0
C81 a_1540_n392# CP 0.00341f
C82 CP a_472_n26# 0.12803f
C83 CP VB 3.02813f
C84 SEL9 a_7740_n392# 0.0031f
C85 a_6946_n26# a_7740_n392# 0
C86 SEL9 X 0
C87 a_6946_n26# X 0.41333f
C88 a_4240_n392# SEL5 0
C89 SEL7 SEL8 0.02049f
C90 SEL6 CP 0.00527f
C91 SEL7 VB 0.00233f
C92 a_686_n392# a_746_n26# 0.00788f
C93 a_138_n392# X 0.02118f
C94 a_6886_n392# a_7740_n392# 0.0065f
C95 a_6886_n392# X 0.02466f
C96 a_6092_n26# VB 0.01005f
C97 a_8773_282# a_8732_n392# 0.00452f
C98 a_686_n392# a_412_n392# 0.02055f
C99 a_4300_n26# X 0.75675f
C100 a_8773_282# VB 0.19507f
C101 SEL7 CP 0.00527f
C102 a_3386_n392# SEL5 0.0031f
C103 SEL10 X 0.00115f
C104 a_4300_n26# a_4240_n392# 0.00808f
C105 a_686_n392# a_1540_n392# 0.0065f
C106 a_686_n392# a_472_n26# 0.00127f
C107 a_686_n392# VB 0.03752f
C108 CP a_6092_n26# 2.96563f
C109 SEL9 a_8732_n392# 0
C110 a_6032_n392# a_6886_n392# 0.0065f
C111 a_3446_n26# SEL5 0.00733f
C112 SEL4 SEL5 0.02049f
C113 a_138_n392# a_198_n26# 0.00718f
C114 SEL9 SEL8 0.02049f
C115 a_6946_n26# SEL8 0.00733f
C116 SEL5 VB 0.00233f
C117 SEL9 VB 0.01628f
C118 a_6946_n26# VB 0.44695f
C119 SEL2 X 0
C120 a_412_n392# a_138_n392# 0.02055f
C121 CP a_8773_282# 3.03055f
C122 SEL7 a_6092_n26# 0.00733f
C123 SEL2 SEL1 0.06851f
C124 a_7740_n392# X 0.02466f
C125 SEL6 SEL5 0.02049f
C126 a_138_n392# SEL0 0.0031f
C127 SEL1 X 0
C128 a_686_n392# CP 0.00341f
C129 a_6886_n392# SEL8 0.0031f
C130 a_4240_n392# X 0.02466f
C131 a_138_n392# VB 0.03474f
C132 a_6886_n392# VB 0.03911f
C133 CP SEL5 0.00527f
C134 SEL9 CP 0.00527f
C135 a_6946_n26# CP 2.87612f
C136 a_3446_n26# a_4300_n26# 0.43639f
C137 a_746_n26# SEL2 0.0073f
C138 SEL10 a_8732_n392# 0.0031f
C139 a_4300_n26# VB 0.00971f
C140 a_6032_n392# X 0.02264f
C141 a_1600_n26# X 0.40406f
C142 a_746_n26# X 0.40593f
C143 a_198_n26# X 0.11425f
C144 SEL10 VB 0.00233f
C145 CP a_138_n392# 0.00437f
C146 SEL6 a_4300_n26# 0.00733f
C147 a_6886_n392# CP 0.00306f
C148 a_2532_n392# X 0.02407f
C149 a_412_n392# X 0.04538f
C150 a_3386_n392# X 0.02466f
C151 SEL3 SEL2 0.02049f
C152 a_6946_n26# a_6092_n26# 0.4369f
C153 a_412_n392# SEL1 0.0031f
C154 SEL0 X 0
C155 a_2592_n26# X 0.40425f
C156 a_7740_n392# a_8732_n392# 0.00388f
C157 a_8732_n392# X 0.03489f
C158 SEL3 X 0
C159 SEL1 SEL0 0.06851f
C160 a_4300_n26# CP 5.64119f
C161 SEL7 a_6886_n392# 0
C162 a_1540_n392# SEL2 0
C163 a_7740_n392# SEL8 0
C164 SEL2 VB 0.00233f
C165 SEL8 X 0
C166 a_3386_n392# a_4240_n392# 0.0065f
C167 a_3446_n26# X 0.40417f
C168 SEL4 X 0
C169 a_7740_n392# VB 0.07506f
C170 a_1540_n392# X 0.02466f
C171 a_472_n26# X 0.11877f
C172 X VB 2.05241f
C173 CP GND 4.67141f
C174 SEL10 GND 0.36005f
C175 SEL9 GND 0.32853f
C176 SEL8 GND 0.3295f
C177 SEL7 GND 0.3549f
C178 SEL6 GND 0.35491f
C179 SEL5 GND 0.3295f
C180 SEL4 GND 0.33273f
C181 SEL3 GND 0.33273f
C182 SEL2 GND 0.29659f
C183 SEL1 GND 0.26364f
C184 SEL0 GND 0.32195f
C185 X GND 2.07813f
C186 VB GND 4.8277f
C187 a_8732_n392# GND 0.23038f
C188 a_7740_n392# GND 0.20343f
C189 a_6886_n392# GND 0.21415f
C190 a_6032_n392# GND 0.23366f
C191 a_4240_n392# GND 0.22307f
C192 a_3386_n392# GND 0.21415f
C193 a_2532_n392# GND 0.22301f
C194 a_1540_n392# GND 0.21537f
C195 a_686_n392# GND 0.19165f
C196 a_412_n392# GND 0.17692f
C197 a_138_n392# GND 0.22094f
C198 a_8773_282# GND 1.21797f
C199 a_6946_n26# GND 1.13357f
C200 a_6092_n26# GND 1.18533f
C201 a_4300_n26# GND 1.82423f
C202 a_3446_n26# GND 1.08196f
C203 a_2592_n26# GND 1.19662f
C204 a_1600_n26# GND 0.82841f
C205 a_746_n26# GND 0.85988f
C206 a_472_n26# GND 0.35813f
C207 a_198_n26# GND 0.40665f
.ends
