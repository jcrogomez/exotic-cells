* XC-19 full stage, K = 3, VDD = 1.8, 27 C. Generated by gen_stage.py
.lib /pdk/libs.tech/ngspice/sky130.lib.spice tt
.include /pdk/libs.ref/sky130_fd_sc_hd/spice/sky130_fd_sc_hd.spice
.options gmin=1e-18 abstol=1e-18 reltol=1e-5
.temp 27
Vdd vdd 0 1.8
Vpre pre 0 pulse(0 1.8 100n 1n 1n 1 2)
Vstep vbs vb 0.305m
Xc0 vdd vdd c1 0 sky130_fd_pr__nfet_01v8 w=1 l=1
Xc1 c1 c1 vb 0 sky130_fd_pr__nfet_01v8 w=1 l=1
Xc2 vb vb 0 0 sky130_fd_pr__nfet_01v8 w=0.42 l=0.15 m=16
Cf vb 0 1p
Xpa xa pre vdd vdd sky130_fd_pr__pfet_01v8 w=0.42 l=0.15
Xda xa vb 0 0 sky130_fd_pr__nfet_01v8 w=0.42 l=0.15
Xia xa 0 0 vdd vdd ya sky130_fd_sc_hd__inv_1
Xpb xb pre vdd vdd sky130_fd_pr__pfet_01v8 w=0.42 l=0.15
Xdb xb vbs 0 0 sky130_fd_pr__nfet_01v8 w=0.42 l=0.15
Xib xb 0 0 vdd vdd yb sky130_fd_sc_hd__inv_1
Xpw xw pre vdd vdd sky130_fd_pr__pfet_01v8 w=0.42 l=0.15
Xdw xw vb 0 0 sky130_fd_pr__nfet_01v8 w=4.2 l=1.5
Xiw xw 0 0 vdd vdd yw sky130_fd_sc_hd__inv_1
.control
tran 0.2n 5u
meas tran ta when v(ya)=0.9 rise=1
meas tran tb when v(yb)=0.9 rise=1
meas tran tw when v(yw)=0.9 rise=1
meas tran xa find v(xa) when v(ya)=0.9 rise=1
let vb0 = v(vb)[0]
meas tran vbmin min v(vb)
meas tran vbmax max v(vb)
echo STAGE 3 1.8 27 $&ta $&tb $&tw $&xa $&vb0 $&vbmin $&vbmax
quit
.endc
.end
