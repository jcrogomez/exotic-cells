* XC-19 bias chain. corner tt, 85 C. Generated by gen_bias.py
.lib /pdk/libs.tech/ngspice/sky130.lib.spice tt
.temp 85
Vdd vdd 0 1.8
Vdd2 vdd2 0 1.81
.options gmin=1e-18 abstol=1e-18 reltol=1e-6
Xv1k3m0 vdd vdd v1k3n1 0 sky130_fd_pr__nfet_01v8 w=1 l=1
Xv1k3m1 v1k3n1 v1k3n1 v1k3n2 0 sky130_fd_pr__nfet_01v8 w=1 l=1
Xv1k3m2 v1k3n2 v1k3n2 0 0 sky130_fd_pr__nfet_01v8 w=1 l=1
Vdv1k3 dv1k3 0 0.9
Xdutv1k3 dv1k3 v1k3n2 0 0 sky130_fd_pr__nfet_01v8 w=0.42 l=0.15
Xv1k3hm0 vdd2 vdd2 v1k3hn1 0 sky130_fd_pr__nfet_01v8 w=1 l=1
Xv1k3hm1 v1k3hn1 v1k3hn1 v1k3hn2 0 sky130_fd_pr__nfet_01v8 w=1 l=1
Xv1k3hm2 v1k3hn2 v1k3hn2 0 0 sky130_fd_pr__nfet_01v8 w=1 l=1
Vdv1k3h dv1k3h 0 0.9
Xdutv1k3h dv1k3h v1k3hn2 0 0 sky130_fd_pr__nfet_01v8 w=0.42 l=0.15
Xv1k4m0 vdd vdd v1k4n1 0 sky130_fd_pr__nfet_01v8 w=1 l=1
Xv1k4m1 v1k4n1 v1k4n1 v1k4n2 0 sky130_fd_pr__nfet_01v8 w=1 l=1
Xv1k4m2 v1k4n2 v1k4n2 v1k4n3 0 sky130_fd_pr__nfet_01v8 w=1 l=1
Xv1k4m3 v1k4n3 v1k4n3 0 0 sky130_fd_pr__nfet_01v8 w=1 l=1
Vdv1k4 dv1k4 0 0.9
Xdutv1k4 dv1k4 v1k4n3 0 0 sky130_fd_pr__nfet_01v8 w=0.42 l=0.15
Xv1k4hm0 vdd2 vdd2 v1k4hn1 0 sky130_fd_pr__nfet_01v8 w=1 l=1
Xv1k4hm1 v1k4hn1 v1k4hn1 v1k4hn2 0 sky130_fd_pr__nfet_01v8 w=1 l=1
Xv1k4hm2 v1k4hn2 v1k4hn2 v1k4hn3 0 sky130_fd_pr__nfet_01v8 w=1 l=1
Xv1k4hm3 v1k4hn3 v1k4hn3 0 0 sky130_fd_pr__nfet_01v8 w=1 l=1
Vdv1k4h dv1k4h 0 0.9
Xdutv1k4h dv1k4h v1k4hn3 0 0 sky130_fd_pr__nfet_01v8 w=0.42 l=0.15
Xv1k5m0 vdd vdd v1k5n1 0 sky130_fd_pr__nfet_01v8 w=1 l=1
Xv1k5m1 v1k5n1 v1k5n1 v1k5n2 0 sky130_fd_pr__nfet_01v8 w=1 l=1
Xv1k5m2 v1k5n2 v1k5n2 v1k5n3 0 sky130_fd_pr__nfet_01v8 w=1 l=1
Xv1k5m3 v1k5n3 v1k5n3 v1k5n4 0 sky130_fd_pr__nfet_01v8 w=1 l=1
Xv1k5m4 v1k5n4 v1k5n4 0 0 sky130_fd_pr__nfet_01v8 w=1 l=1
Vdv1k5 dv1k5 0 0.9
Xdutv1k5 dv1k5 v1k5n4 0 0 sky130_fd_pr__nfet_01v8 w=0.42 l=0.15
Xv1k5hm0 vdd2 vdd2 v1k5hn1 0 sky130_fd_pr__nfet_01v8 w=1 l=1
Xv1k5hm1 v1k5hn1 v1k5hn1 v1k5hn2 0 sky130_fd_pr__nfet_01v8 w=1 l=1
Xv1k5hm2 v1k5hn2 v1k5hn2 v1k5hn3 0 sky130_fd_pr__nfet_01v8 w=1 l=1
Xv1k5hm3 v1k5hn3 v1k5hn3 v1k5hn4 0 sky130_fd_pr__nfet_01v8 w=1 l=1
Xv1k5hm4 v1k5hn4 v1k5hn4 0 0 sky130_fd_pr__nfet_01v8 w=1 l=1
Vdv1k5h dv1k5h 0 0.9
Xdutv1k5h dv1k5h v1k5hn4 0 0 sky130_fd_pr__nfet_01v8 w=0.42 l=0.15
Xv1k6m0 vdd vdd v1k6n1 0 sky130_fd_pr__nfet_01v8 w=1 l=1
Xv1k6m1 v1k6n1 v1k6n1 v1k6n2 0 sky130_fd_pr__nfet_01v8 w=1 l=1
Xv1k6m2 v1k6n2 v1k6n2 v1k6n3 0 sky130_fd_pr__nfet_01v8 w=1 l=1
Xv1k6m3 v1k6n3 v1k6n3 v1k6n4 0 sky130_fd_pr__nfet_01v8 w=1 l=1
Xv1k6m4 v1k6n4 v1k6n4 v1k6n5 0 sky130_fd_pr__nfet_01v8 w=1 l=1
Xv1k6m5 v1k6n5 v1k6n5 0 0 sky130_fd_pr__nfet_01v8 w=1 l=1
Vdv1k6 dv1k6 0 0.9
Xdutv1k6 dv1k6 v1k6n5 0 0 sky130_fd_pr__nfet_01v8 w=0.42 l=0.15
Xv1k6hm0 vdd2 vdd2 v1k6hn1 0 sky130_fd_pr__nfet_01v8 w=1 l=1
Xv1k6hm1 v1k6hn1 v1k6hn1 v1k6hn2 0 sky130_fd_pr__nfet_01v8 w=1 l=1
Xv1k6hm2 v1k6hn2 v1k6hn2 v1k6hn3 0 sky130_fd_pr__nfet_01v8 w=1 l=1
Xv1k6hm3 v1k6hn3 v1k6hn3 v1k6hn4 0 sky130_fd_pr__nfet_01v8 w=1 l=1
Xv1k6hm4 v1k6hn4 v1k6hn4 v1k6hn5 0 sky130_fd_pr__nfet_01v8 w=1 l=1
Xv1k6hm5 v1k6hn5 v1k6hn5 0 0 sky130_fd_pr__nfet_01v8 w=1 l=1
Vdv1k6h dv1k6h 0 0.9
Xdutv1k6h dv1k6h v1k6hn5 0 0 sky130_fd_pr__nfet_01v8 w=0.42 l=0.15
Xv1k7m0 vdd vdd v1k7n1 0 sky130_fd_pr__nfet_01v8 w=1 l=1
Xv1k7m1 v1k7n1 v1k7n1 v1k7n2 0 sky130_fd_pr__nfet_01v8 w=1 l=1
Xv1k7m2 v1k7n2 v1k7n2 v1k7n3 0 sky130_fd_pr__nfet_01v8 w=1 l=1
Xv1k7m3 v1k7n3 v1k7n3 v1k7n4 0 sky130_fd_pr__nfet_01v8 w=1 l=1
Xv1k7m4 v1k7n4 v1k7n4 v1k7n5 0 sky130_fd_pr__nfet_01v8 w=1 l=1
Xv1k7m5 v1k7n5 v1k7n5 v1k7n6 0 sky130_fd_pr__nfet_01v8 w=1 l=1
Xv1k7m6 v1k7n6 v1k7n6 0 0 sky130_fd_pr__nfet_01v8 w=1 l=1
Vdv1k7 dv1k7 0 0.9
Xdutv1k7 dv1k7 v1k7n6 0 0 sky130_fd_pr__nfet_01v8 w=0.42 l=0.15
Xv1k7hm0 vdd2 vdd2 v1k7hn1 0 sky130_fd_pr__nfet_01v8 w=1 l=1
Xv1k7hm1 v1k7hn1 v1k7hn1 v1k7hn2 0 sky130_fd_pr__nfet_01v8 w=1 l=1
Xv1k7hm2 v1k7hn2 v1k7hn2 v1k7hn3 0 sky130_fd_pr__nfet_01v8 w=1 l=1
Xv1k7hm3 v1k7hn3 v1k7hn3 v1k7hn4 0 sky130_fd_pr__nfet_01v8 w=1 l=1
Xv1k7hm4 v1k7hn4 v1k7hn4 v1k7hn5 0 sky130_fd_pr__nfet_01v8 w=1 l=1
Xv1k7hm5 v1k7hn5 v1k7hn5 v1k7hn6 0 sky130_fd_pr__nfet_01v8 w=1 l=1
Xv1k7hm6 v1k7hn6 v1k7hn6 0 0 sky130_fd_pr__nfet_01v8 w=1 l=1
Vdv1k7h dv1k7h 0 0.9
Xdutv1k7h dv1k7h v1k7hn6 0 0 sky130_fd_pr__nfet_01v8 w=0.42 l=0.15
Xv1k8m0 vdd vdd v1k8n1 0 sky130_fd_pr__nfet_01v8 w=1 l=1
Xv1k8m1 v1k8n1 v1k8n1 v1k8n2 0 sky130_fd_pr__nfet_01v8 w=1 l=1
Xv1k8m2 v1k8n2 v1k8n2 v1k8n3 0 sky130_fd_pr__nfet_01v8 w=1 l=1
Xv1k8m3 v1k8n3 v1k8n3 v1k8n4 0 sky130_fd_pr__nfet_01v8 w=1 l=1
Xv1k8m4 v1k8n4 v1k8n4 v1k8n5 0 sky130_fd_pr__nfet_01v8 w=1 l=1
Xv1k8m5 v1k8n5 v1k8n5 v1k8n6 0 sky130_fd_pr__nfet_01v8 w=1 l=1
Xv1k8m6 v1k8n6 v1k8n6 v1k8n7 0 sky130_fd_pr__nfet_01v8 w=1 l=1
Xv1k8m7 v1k8n7 v1k8n7 0 0 sky130_fd_pr__nfet_01v8 w=1 l=1
Vdv1k8 dv1k8 0 0.9
Xdutv1k8 dv1k8 v1k8n7 0 0 sky130_fd_pr__nfet_01v8 w=0.42 l=0.15
Xv1k8hm0 vdd2 vdd2 v1k8hn1 0 sky130_fd_pr__nfet_01v8 w=1 l=1
Xv1k8hm1 v1k8hn1 v1k8hn1 v1k8hn2 0 sky130_fd_pr__nfet_01v8 w=1 l=1
Xv1k8hm2 v1k8hn2 v1k8hn2 v1k8hn3 0 sky130_fd_pr__nfet_01v8 w=1 l=1
Xv1k8hm3 v1k8hn3 v1k8hn3 v1k8hn4 0 sky130_fd_pr__nfet_01v8 w=1 l=1
Xv1k8hm4 v1k8hn4 v1k8hn4 v1k8hn5 0 sky130_fd_pr__nfet_01v8 w=1 l=1
Xv1k8hm5 v1k8hn5 v1k8hn5 v1k8hn6 0 sky130_fd_pr__nfet_01v8 w=1 l=1
Xv1k8hm6 v1k8hn6 v1k8hn6 v1k8hn7 0 sky130_fd_pr__nfet_01v8 w=1 l=1
Xv1k8hm7 v1k8hn7 v1k8hn7 0 0 sky130_fd_pr__nfet_01v8 w=1 l=1
Vdv1k8h dv1k8h 0 0.9
Xdutv1k8h dv1k8h v1k8hn7 0 0 sky130_fd_pr__nfet_01v8 w=0.42 l=0.15
Xv2k3m0 vdd vdd v2k3n1 0 sky130_fd_pr__nfet_01v8 w=1 l=1
Xv2k3m1 v2k3n1 v2k3n1 v2k3n2 0 sky130_fd_pr__nfet_01v8 w=1 l=1
Xv2k3m2 v2k3n2 v2k3n2 0 0 sky130_fd_pr__nfet_01v8 w=0.42 l=0.15 m=16
Vdv2k3 dv2k3 0 0.9
Xdutv2k3 dv2k3 v2k3n2 0 0 sky130_fd_pr__nfet_01v8 w=0.42 l=0.15
Xv2k3hm0 vdd2 vdd2 v2k3hn1 0 sky130_fd_pr__nfet_01v8 w=1 l=1
Xv2k3hm1 v2k3hn1 v2k3hn1 v2k3hn2 0 sky130_fd_pr__nfet_01v8 w=1 l=1
Xv2k3hm2 v2k3hn2 v2k3hn2 0 0 sky130_fd_pr__nfet_01v8 w=0.42 l=0.15 m=16
Vdv2k3h dv2k3h 0 0.9
Xdutv2k3h dv2k3h v2k3hn2 0 0 sky130_fd_pr__nfet_01v8 w=0.42 l=0.15
Xv2k4m0 vdd vdd v2k4n1 0 sky130_fd_pr__nfet_01v8 w=1 l=1
Xv2k4m1 v2k4n1 v2k4n1 v2k4n2 0 sky130_fd_pr__nfet_01v8 w=1 l=1
Xv2k4m2 v2k4n2 v2k4n2 v2k4n3 0 sky130_fd_pr__nfet_01v8 w=1 l=1
Xv2k4m3 v2k4n3 v2k4n3 0 0 sky130_fd_pr__nfet_01v8 w=0.42 l=0.15 m=16
Vdv2k4 dv2k4 0 0.9
Xdutv2k4 dv2k4 v2k4n3 0 0 sky130_fd_pr__nfet_01v8 w=0.42 l=0.15
Xv2k4hm0 vdd2 vdd2 v2k4hn1 0 sky130_fd_pr__nfet_01v8 w=1 l=1
Xv2k4hm1 v2k4hn1 v2k4hn1 v2k4hn2 0 sky130_fd_pr__nfet_01v8 w=1 l=1
Xv2k4hm2 v2k4hn2 v2k4hn2 v2k4hn3 0 sky130_fd_pr__nfet_01v8 w=1 l=1
Xv2k4hm3 v2k4hn3 v2k4hn3 0 0 sky130_fd_pr__nfet_01v8 w=0.42 l=0.15 m=16
Vdv2k4h dv2k4h 0 0.9
Xdutv2k4h dv2k4h v2k4hn3 0 0 sky130_fd_pr__nfet_01v8 w=0.42 l=0.15
Xv2k5m0 vdd vdd v2k5n1 0 sky130_fd_pr__nfet_01v8 w=1 l=1
Xv2k5m1 v2k5n1 v2k5n1 v2k5n2 0 sky130_fd_pr__nfet_01v8 w=1 l=1
Xv2k5m2 v2k5n2 v2k5n2 v2k5n3 0 sky130_fd_pr__nfet_01v8 w=1 l=1
Xv2k5m3 v2k5n3 v2k5n3 v2k5n4 0 sky130_fd_pr__nfet_01v8 w=1 l=1
Xv2k5m4 v2k5n4 v2k5n4 0 0 sky130_fd_pr__nfet_01v8 w=0.42 l=0.15 m=16
Vdv2k5 dv2k5 0 0.9
Xdutv2k5 dv2k5 v2k5n4 0 0 sky130_fd_pr__nfet_01v8 w=0.42 l=0.15
Xv2k5hm0 vdd2 vdd2 v2k5hn1 0 sky130_fd_pr__nfet_01v8 w=1 l=1
Xv2k5hm1 v2k5hn1 v2k5hn1 v2k5hn2 0 sky130_fd_pr__nfet_01v8 w=1 l=1
Xv2k5hm2 v2k5hn2 v2k5hn2 v2k5hn3 0 sky130_fd_pr__nfet_01v8 w=1 l=1
Xv2k5hm3 v2k5hn3 v2k5hn3 v2k5hn4 0 sky130_fd_pr__nfet_01v8 w=1 l=1
Xv2k5hm4 v2k5hn4 v2k5hn4 0 0 sky130_fd_pr__nfet_01v8 w=0.42 l=0.15 m=16
Vdv2k5h dv2k5h 0 0.9
Xdutv2k5h dv2k5h v2k5hn4 0 0 sky130_fd_pr__nfet_01v8 w=0.42 l=0.15
Xv2k6m0 vdd vdd v2k6n1 0 sky130_fd_pr__nfet_01v8 w=1 l=1
Xv2k6m1 v2k6n1 v2k6n1 v2k6n2 0 sky130_fd_pr__nfet_01v8 w=1 l=1
Xv2k6m2 v2k6n2 v2k6n2 v2k6n3 0 sky130_fd_pr__nfet_01v8 w=1 l=1
Xv2k6m3 v2k6n3 v2k6n3 v2k6n4 0 sky130_fd_pr__nfet_01v8 w=1 l=1
Xv2k6m4 v2k6n4 v2k6n4 v2k6n5 0 sky130_fd_pr__nfet_01v8 w=1 l=1
Xv2k6m5 v2k6n5 v2k6n5 0 0 sky130_fd_pr__nfet_01v8 w=0.42 l=0.15 m=16
Vdv2k6 dv2k6 0 0.9
Xdutv2k6 dv2k6 v2k6n5 0 0 sky130_fd_pr__nfet_01v8 w=0.42 l=0.15
Xv2k6hm0 vdd2 vdd2 v2k6hn1 0 sky130_fd_pr__nfet_01v8 w=1 l=1
Xv2k6hm1 v2k6hn1 v2k6hn1 v2k6hn2 0 sky130_fd_pr__nfet_01v8 w=1 l=1
Xv2k6hm2 v2k6hn2 v2k6hn2 v2k6hn3 0 sky130_fd_pr__nfet_01v8 w=1 l=1
Xv2k6hm3 v2k6hn3 v2k6hn3 v2k6hn4 0 sky130_fd_pr__nfet_01v8 w=1 l=1
Xv2k6hm4 v2k6hn4 v2k6hn4 v2k6hn5 0 sky130_fd_pr__nfet_01v8 w=1 l=1
Xv2k6hm5 v2k6hn5 v2k6hn5 0 0 sky130_fd_pr__nfet_01v8 w=0.42 l=0.15 m=16
Vdv2k6h dv2k6h 0 0.9
Xdutv2k6h dv2k6h v2k6hn5 0 0 sky130_fd_pr__nfet_01v8 w=0.42 l=0.15
Xv2k7m0 vdd vdd v2k7n1 0 sky130_fd_pr__nfet_01v8 w=1 l=1
Xv2k7m1 v2k7n1 v2k7n1 v2k7n2 0 sky130_fd_pr__nfet_01v8 w=1 l=1
Xv2k7m2 v2k7n2 v2k7n2 v2k7n3 0 sky130_fd_pr__nfet_01v8 w=1 l=1
Xv2k7m3 v2k7n3 v2k7n3 v2k7n4 0 sky130_fd_pr__nfet_01v8 w=1 l=1
Xv2k7m4 v2k7n4 v2k7n4 v2k7n5 0 sky130_fd_pr__nfet_01v8 w=1 l=1
Xv2k7m5 v2k7n5 v2k7n5 v2k7n6 0 sky130_fd_pr__nfet_01v8 w=1 l=1
Xv2k7m6 v2k7n6 v2k7n6 0 0 sky130_fd_pr__nfet_01v8 w=0.42 l=0.15 m=16
Vdv2k7 dv2k7 0 0.9
Xdutv2k7 dv2k7 v2k7n6 0 0 sky130_fd_pr__nfet_01v8 w=0.42 l=0.15
Xv2k7hm0 vdd2 vdd2 v2k7hn1 0 sky130_fd_pr__nfet_01v8 w=1 l=1
Xv2k7hm1 v2k7hn1 v2k7hn1 v2k7hn2 0 sky130_fd_pr__nfet_01v8 w=1 l=1
Xv2k7hm2 v2k7hn2 v2k7hn2 v2k7hn3 0 sky130_fd_pr__nfet_01v8 w=1 l=1
Xv2k7hm3 v2k7hn3 v2k7hn3 v2k7hn4 0 sky130_fd_pr__nfet_01v8 w=1 l=1
Xv2k7hm4 v2k7hn4 v2k7hn4 v2k7hn5 0 sky130_fd_pr__nfet_01v8 w=1 l=1
Xv2k7hm5 v2k7hn5 v2k7hn5 v2k7hn6 0 sky130_fd_pr__nfet_01v8 w=1 l=1
Xv2k7hm6 v2k7hn6 v2k7hn6 0 0 sky130_fd_pr__nfet_01v8 w=0.42 l=0.15 m=16
Vdv2k7h dv2k7h 0 0.9
Xdutv2k7h dv2k7h v2k7hn6 0 0 sky130_fd_pr__nfet_01v8 w=0.42 l=0.15
Xv2k8m0 vdd vdd v2k8n1 0 sky130_fd_pr__nfet_01v8 w=1 l=1
Xv2k8m1 v2k8n1 v2k8n1 v2k8n2 0 sky130_fd_pr__nfet_01v8 w=1 l=1
Xv2k8m2 v2k8n2 v2k8n2 v2k8n3 0 sky130_fd_pr__nfet_01v8 w=1 l=1
Xv2k8m3 v2k8n3 v2k8n3 v2k8n4 0 sky130_fd_pr__nfet_01v8 w=1 l=1
Xv2k8m4 v2k8n4 v2k8n4 v2k8n5 0 sky130_fd_pr__nfet_01v8 w=1 l=1
Xv2k8m5 v2k8n5 v2k8n5 v2k8n6 0 sky130_fd_pr__nfet_01v8 w=1 l=1
Xv2k8m6 v2k8n6 v2k8n6 v2k8n7 0 sky130_fd_pr__nfet_01v8 w=1 l=1
Xv2k8m7 v2k8n7 v2k8n7 0 0 sky130_fd_pr__nfet_01v8 w=0.42 l=0.15 m=16
Vdv2k8 dv2k8 0 0.9
Xdutv2k8 dv2k8 v2k8n7 0 0 sky130_fd_pr__nfet_01v8 w=0.42 l=0.15
Xv2k8hm0 vdd2 vdd2 v2k8hn1 0 sky130_fd_pr__nfet_01v8 w=1 l=1
Xv2k8hm1 v2k8hn1 v2k8hn1 v2k8hn2 0 sky130_fd_pr__nfet_01v8 w=1 l=1
Xv2k8hm2 v2k8hn2 v2k8hn2 v2k8hn3 0 sky130_fd_pr__nfet_01v8 w=1 l=1
Xv2k8hm3 v2k8hn3 v2k8hn3 v2k8hn4 0 sky130_fd_pr__nfet_01v8 w=1 l=1
Xv2k8hm4 v2k8hn4 v2k8hn4 v2k8hn5 0 sky130_fd_pr__nfet_01v8 w=1 l=1
Xv2k8hm5 v2k8hn5 v2k8hn5 v2k8hn6 0 sky130_fd_pr__nfet_01v8 w=1 l=1
Xv2k8hm6 v2k8hn6 v2k8hn6 v2k8hn7 0 sky130_fd_pr__nfet_01v8 w=1 l=1
Xv2k8hm7 v2k8hn7 v2k8hn7 0 0 sky130_fd_pr__nfet_01v8 w=0.42 l=0.15 m=16
Vdv2k8h dv2k8h 0 0.9
Xdutv2k8h dv2k8h v2k8hn7 0 0 sky130_fd_pr__nfet_01v8 w=0.42 l=0.15
.control
op
let vb = v(v1k3n2)
let idut = -i(Vdv1k3)
echo BIAS tt 85 v1 3 vdd $&vb $&idut
let vb = v(v1k3hn2)
let idut = -i(Vdv1k3h)
echo BIAS tt 85 v1 3 vdd2 $&vb $&idut
let vb = v(v1k4n3)
let idut = -i(Vdv1k4)
echo BIAS tt 85 v1 4 vdd $&vb $&idut
let vb = v(v1k4hn3)
let idut = -i(Vdv1k4h)
echo BIAS tt 85 v1 4 vdd2 $&vb $&idut
let vb = v(v1k5n4)
let idut = -i(Vdv1k5)
echo BIAS tt 85 v1 5 vdd $&vb $&idut
let vb = v(v1k5hn4)
let idut = -i(Vdv1k5h)
echo BIAS tt 85 v1 5 vdd2 $&vb $&idut
let vb = v(v1k6n5)
let idut = -i(Vdv1k6)
echo BIAS tt 85 v1 6 vdd $&vb $&idut
let vb = v(v1k6hn5)
let idut = -i(Vdv1k6h)
echo BIAS tt 85 v1 6 vdd2 $&vb $&idut
let vb = v(v1k7n6)
let idut = -i(Vdv1k7)
echo BIAS tt 85 v1 7 vdd $&vb $&idut
let vb = v(v1k7hn6)
let idut = -i(Vdv1k7h)
echo BIAS tt 85 v1 7 vdd2 $&vb $&idut
let vb = v(v1k8n7)
let idut = -i(Vdv1k8)
echo BIAS tt 85 v1 8 vdd $&vb $&idut
let vb = v(v1k8hn7)
let idut = -i(Vdv1k8h)
echo BIAS tt 85 v1 8 vdd2 $&vb $&idut
let vb = v(v2k3n2)
let idut = -i(Vdv2k3)
echo BIAS tt 85 v2 3 vdd $&vb $&idut
let vb = v(v2k3hn2)
let idut = -i(Vdv2k3h)
echo BIAS tt 85 v2 3 vdd2 $&vb $&idut
let vb = v(v2k4n3)
let idut = -i(Vdv2k4)
echo BIAS tt 85 v2 4 vdd $&vb $&idut
let vb = v(v2k4hn3)
let idut = -i(Vdv2k4h)
echo BIAS tt 85 v2 4 vdd2 $&vb $&idut
let vb = v(v2k5n4)
let idut = -i(Vdv2k5)
echo BIAS tt 85 v2 5 vdd $&vb $&idut
let vb = v(v2k5hn4)
let idut = -i(Vdv2k5h)
echo BIAS tt 85 v2 5 vdd2 $&vb $&idut
let vb = v(v2k6n5)
let idut = -i(Vdv2k6)
echo BIAS tt 85 v2 6 vdd $&vb $&idut
let vb = v(v2k6hn5)
let idut = -i(Vdv2k6h)
echo BIAS tt 85 v2 6 vdd2 $&vb $&idut
let vb = v(v2k7n6)
let idut = -i(Vdv2k7)
echo BIAS tt 85 v2 7 vdd $&vb $&idut
let vb = v(v2k7hn6)
let idut = -i(Vdv2k7h)
echo BIAS tt 85 v2 7 vdd2 $&vb $&idut
let vb = v(v2k8n7)
let idut = -i(Vdv2k8)
echo BIAS tt 85 v2 8 vdd $&vb $&idut
let vb = v(v2k8hn7)
let idut = -i(Vdv2k8h)
echo BIAS tt 85 v2 8 vdd2 $&vb $&idut
quit
.endc
.end
