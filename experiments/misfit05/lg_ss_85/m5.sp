* MISFIT-03 etapa a · MISFIT-05 todo abierto, 1,4 ms · esquina ss 85 C. Generado por gen_contrato.py (no editar a mano).
* Macro: cells/xc19_slot_core/xc19_slot_core_lod.inc (Magic, extraccion con capacidades, LOD anotado por Residual).
* Decodificador: celdas sky130_fd_sc_hd en SPICE (E7). El contador es aritmetico: cuentas = (t_xa - t_pre) * 50 MHz.
.lib /pdk/libs.tech/ngspice/sky130.lib.spice ss
.include /pdk/libs.ref/sky130_fd_sc_hd/spice/sky130_fd_sc_hd.spice
.options gmin=1e-18 abstol=1e-15 reltol=1e-5
.temp 85
.subckt core XB_OUT SB0B SB1B REFB XA_OUT SA0B SA1B SA2B REFA VDD GND VBIAS C1 PREA XA DUTA PREB XB DUTB VB CALA CALB
X0 GND VB GND GND sky130_fd_pr__nfet_01v8 ad=1.65 pd=6.1 as=118.482 ps=607.88 w=5.5 l=10
X3 GND VB GND GND sky130_fd_pr__nfet_01v8 ad=1.65 pd=6.1 as=0 ps=0 w=5.5 l=10
X6 GND a_7370_n924# GND GND sky130_fd_pr__nfet_01v8 ad=0.126 pd=1.44 as=0 ps=0 w=0.42 l=0.3
X8 GND XB GND GND sky130_fd_pr__nfet_01v8 ad=1.29 pd=9.2 as=0 ps=0 w=4.3 l=4
X9 GND VB GND GND sky130_fd_pr__nfet_01v8 ad=1.65 pd=11.6 as=0 ps=0 w=5.5 l=10
X11 GND VB GND GND sky130_fd_pr__nfet_01v8 ad=1.65 pd=6.1 as=0 ps=0 w=5.5 l=10
X15 GND VB GND GND sky130_fd_pr__nfet_01v8 ad=1.65 pd=6.1 as=0 ps=0 w=5.5 l=10
X16 GND VB GND GND sky130_fd_pr__nfet_01v8 ad=1.65 pd=11.6 as=0 ps=0 w=5.5 l=10
X19 GND VB GND GND sky130_fd_pr__nfet_01v8 ad=1.65 pd=6.1 as=0 ps=0 w=5.5 l=10
X23 GND XA GND GND sky130_fd_pr__nfet_01v8 ad=1.29 pd=9.2 as=0 ps=0 w=4.3 l=4
X24 GND VB GND GND sky130_fd_pr__nfet_01v8 ad=1.65 pd=11.6 as=0 ps=0 w=5.5 l=10
X25 GND VB GND GND sky130_fd_pr__nfet_01v8 ad=1.65 pd=6.1 as=0 ps=0 w=5.5 l=10
X28 GND VB GND GND sky130_fd_pr__nfet_01v8 ad=1.65 pd=6.1 as=0 ps=0 w=5.5 l=10
X33 GND VB GND GND sky130_fd_pr__nfet_01v8 ad=1.65 pd=6.1 as=0 ps=0 w=5.5 l=10
X34 GND VB GND GND sky130_fd_pr__nfet_01v8 ad=1.65 pd=11.6 as=0 ps=0 w=5.5 l=10
X37 GND a_n2233_n890# GND GND sky130_fd_pr__nfet_01v8 ad=0.126 pd=1.44 as=0 ps=0 w=0.42 l=0.3
X39 GND a_7650_n924# GND GND sky130_fd_pr__nfet_01v8 ad=0.126 pd=1.44 as=0 ps=0 w=0.42 l=0.3
X42 GND VB GND GND sky130_fd_pr__nfet_01v8 ad=1.65 pd=6.1 as=0 ps=0 w=5.5 l=10
X43 GND VB GND GND sky130_fd_pr__nfet_01v8 ad=1.65 pd=6.1 as=0 ps=0 w=5.5 l=10
X51 GND VB GND GND sky130_fd_pr__nfet_01v8 ad=1.65 pd=11.6 as=0 ps=0 w=5.5 l=10
X53 GND VB GND GND sky130_fd_pr__nfet_01v8 ad=1.65 pd=6.1 as=0 ps=0 w=5.5 l=10
X55 GND VB GND GND sky130_fd_pr__nfet_01v8 ad=1.65 pd=6.1 as=0 ps=0 w=5.5 l=10
X57 GND VB GND GND sky130_fd_pr__nfet_01v8 ad=1.65 pd=6.1 as=0 ps=0 w=5.5 l=10
X60 GND VB GND GND sky130_fd_pr__nfet_01v8 ad=1.65 pd=11.6 as=0 ps=0 w=5.5 l=10
X61 GND VB GND GND sky130_fd_pr__nfet_01v8 ad=1.65 pd=6.1 as=0 ps=0 w=5.5 l=10
X64 GND VB GND GND sky130_fd_pr__nfet_01v8 ad=1.65 pd=11.6 as=0 ps=0 w=5.5 l=10
X66 GND VB GND GND sky130_fd_pr__nfet_01v8 ad=1.65 pd=6.1 as=0 ps=0 w=5.5 l=10
X67 GND a_n2270_n1236# GND GND sky130_fd_pr__nfet_01v8 ad=0.126 pd=1.44 as=0 ps=0 w=0.42 l=0.3
X68 GND VB GND GND sky130_fd_pr__nfet_01v8 ad=1.65 pd=6.1 as=0 ps=0 w=5.5 l=10
X69 GND VB GND GND sky130_fd_pr__nfet_01v8 ad=1.65 pd=11.6 as=0 ps=0 w=5.5 l=10
X73 GND VB GND GND sky130_fd_pr__nfet_01v8 ad=1.65 pd=6.1 as=0 ps=0 w=5.5 l=10
X75 GND VB GND GND sky130_fd_pr__nfet_01v8 ad=1.65 pd=6.1 as=0 ps=0 w=5.5 l=10
X76 GND VB GND GND sky130_fd_pr__nfet_01v8 ad=1.65 pd=11.6 as=0 ps=0 w=5.5 l=10
X81 GND VB GND GND sky130_fd_pr__nfet_01v8 ad=1.65 pd=11.6 as=0 ps=0 w=5.5 l=10
X85 GND VB GND GND sky130_fd_pr__nfet_01v8 ad=1.65 pd=6.1 as=0 ps=0 w=5.5 l=10
X88 GND VB GND GND sky130_fd_pr__nfet_01v8 ad=1.65 pd=6.1 as=0 ps=0 w=5.5 l=10
X94 GND VB GND GND sky130_fd_pr__nfet_01v8 ad=1.65 pd=6.1 as=0 ps=0 w=5.5 l=10
X95 GND VB GND GND sky130_fd_pr__nfet_01v8 ad=1.65 pd=6.1 as=0 ps=0 w=5.5 l=10
X99 GND VB GND GND sky130_fd_pr__nfet_01v8 ad=1.65 pd=11.6 as=0 ps=0 w=5.5 l=10
X1 VB VB GND GND sky130_fd_pr__nfet_01v8 ad=0.126 pd=1.44 as=0.126 ps=1.44 w=0.42 l=0.15 sa=0.3 sb=0.3
X2 a_n2000_n1632# VB a_n2090_n1632# GND sky130_fd_pr__nfet_01v8 ad=0.126 pd=1.44 as=0.126 ps=1.44 w=0.42 l=0.15 sa=0.3 sb=0.3
X4 a_7130_n1632# VB a_7040_n2004# GND sky130_fd_pr__nfet_01v8 ad=0.126 pd=1.44 as=0.126 ps=1.44 w=0.42 l=0.15 sa=0.3 sb=0.3
X5 a_7130_n1632# VB a_7040_n2004# GND sky130_fd_pr__nfet_01v8 ad=0.126 pd=1.44 as=0.126 ps=1.44 w=0.42 l=0.15 sa=0.3 sb=0.3
X7 XB PREB VDD VDD sky130_fd_pr__pfet_01v8_hvt ad=0.126 pd=1.44 as=0.126 ps=1.44 w=0.42 l=0.5 sa=0.3 sb=0.3
X10 XA PREA VDD VDD sky130_fd_pr__pfet_01v8_hvt ad=0.126 pd=1.44 as=0.126 ps=1.44 w=0.42 l=0.5 sa=0.3 sb=0.3
X12 VB VB GND GND sky130_fd_pr__nfet_01v8 ad=0.126 pd=1.44 as=0.126 ps=1.44 w=0.42 l=0.15 sa=0.3 sb=0.3
X13 XA VB a_n2090_n1632# GND sky130_fd_pr__nfet_01v8 ad=0.126 pd=1.44 as=0.126 ps=1.44 w=0.42 l=0.15 sa=0.3 sb=0.3
X14 VB VB GND GND sky130_fd_pr__nfet_01v8 ad=0.126 pd=1.44 as=0.126 ps=1.44 w=0.42 l=0.15 sa=0.3 sb=0.3
X17 GND REFB a_7040_n2004# GND sky130_fd_pr__nfet_01v8 ad=0.252 pd=2.28 as=0.252 ps=2.28 w=0.84 l=0.15 sa=0.3 sb=0.3
X18 XA VB a_n2090_n1632# GND sky130_fd_pr__nfet_01v8 ad=0.126 pd=1.44 as=0.126 ps=1.44 w=0.42 l=0.15 sa=0.3 sb=0.3
X20 a_7130_n1632# VB XB GND sky130_fd_pr__nfet_01v8 ad=0.126 pd=1.44 as=0.126 ps=1.44 w=0.42 l=0.15 sa=0.3 sb=0.3
X21 a_7130_n1632# VB XB GND sky130_fd_pr__nfet_01v8 ad=0.126 pd=1.44 as=0.126 ps=1.44 w=0.42 l=0.15 sa=0.3 sb=0.3
X22 a_7650_n924# VDD XB VDD sky130_fd_pr__pfet_01v8 ad=0.126 pd=1.44 as=0.126 ps=1.44 w=0.42 l=0.15 sa=0.3 sb=0.3
X26 VB VB GND GND sky130_fd_pr__nfet_01v8 ad=0.126 pd=1.44 as=0.126 ps=1.44 w=0.42 l=0.15 sa=0.3 sb=0.3
X27 XB_OUT XB VDD VDD sky130_fd_pr__pfet_01v8_hvt ad=0.3 pd=2.6 as=0.3 ps=2.6 w=1 l=0.15 sa=0.3 sb=0.3
X29 XB_OUT XB GND GND sky130_fd_pr__nfet_01v8 ad=0.195 pd=1.9 as=0.195 ps=1.9 w=0.65 l=0.15 sa=0.3 sb=0.3
X30 VB VB GND GND sky130_fd_pr__nfet_01v8 ad=0.126 pd=1.44 as=0.126 ps=1.44 w=0.42 l=0.15 sa=0.3 sb=0.3
X31 XA SA2B a_n2233_n890# VDD sky130_fd_pr__pfet_01v8 ad=0.126 pd=1.44 as=0.126 ps=1.44 w=0.42 l=0.15 sa=0.3 sb=0.3
X32 a_7370_n924# SB1B XB VDD sky130_fd_pr__pfet_01v8 ad=0.126 pd=1.44 as=0.126 ps=1.44 w=0.42 l=0.15 sa=0.3 sb=0.3
X35 VB VB GND GND sky130_fd_pr__nfet_01v8 ad=0.126 pd=1.44 as=0.126 ps=1.44 w=0.42 l=0.15 sa=0.3 sb=0.3
X36 a_n2000_n1632# VB a_n2090_n1632# GND sky130_fd_pr__nfet_01v8 ad=0.126 pd=1.44 as=0.126 ps=1.44 w=0.42 l=0.15 sa=0.3 sb=0.3
X38 a_7130_n1632# VB a_7040_n2004# GND sky130_fd_pr__nfet_01v8 ad=0.126 pd=1.44 as=0.126 ps=1.44 w=0.42 l=0.15 sa=0.3 sb=0.3
X40 XA VB a_3900_n392# GND sky130_fd_pr__nfet_01v8 ad=0.126 pd=1.44 as=0.126 ps=1.44 w=0.42 l=0.15 sa=0.3 sb=0.3
X41 VB VB GND GND sky130_fd_pr__nfet_01v8 ad=0.126 pd=1.44 as=0.126 ps=1.44 w=0.42 l=0.15 sa=0.3 sb=0.3
X44 XA SA1B a_n2270_n1236# VDD sky130_fd_pr__pfet_01v8 ad=0.126 pd=1.44 as=0.126 ps=1.44 w=0.42 l=0.15 sa=0.3 sb=0.3
X45 a_7090_n924# SB0B XB VDD sky130_fd_pr__pfet_01v8 ad=0.126 pd=1.44 as=0.126 ps=1.44 w=0.42 l=0.15 sa=0.3 sb=0.3
X46 XB VB a_4500_n392# GND sky130_fd_pr__nfet_01v8 ad=0.126 pd=1.44 as=0.126 ps=1.44 w=0.42 l=0.15 sa=0.3 sb=0.3
X47 a_n2000_n1632# REFA GND GND sky130_fd_pr__nfet_01v8 ad=0.252 pd=2.28 as=0.252 ps=2.28 w=0.84 l=0.15 sa=0.3 sb=0.3
X48 XA VB a_n2090_n1632# GND sky130_fd_pr__nfet_01v8 ad=0.126 pd=1.44 as=0.126 ps=1.44 w=0.42 l=0.15 sa=0.3 sb=0.3
X49 VB VB GND GND sky130_fd_pr__nfet_01v8 ad=0.126 pd=1.44 as=0.126 ps=1.44 w=0.42 l=0.15 sa=0.3 sb=0.3
X50 XA SA0B a_n950_n924# VDD sky130_fd_pr__pfet_01v8 ad=0.126 pd=1.44 as=0.126 ps=1.44 w=0.42 l=0.15 sa=0.3 sb=0.3
X52 a_7130_n1632# VB XB GND sky130_fd_pr__nfet_01v8 ad=0.126 pd=1.44 as=0.126 ps=1.44 w=0.42 l=0.15 sa=0.3 sb=0.3
X54 VB VB GND GND sky130_fd_pr__nfet_01v8 ad=0.126 pd=1.44 as=0.126 ps=1.44 w=0.42 l=0.15 sa=0.3 sb=0.3
X56 VB VB GND GND sky130_fd_pr__nfet_01v8 ad=0.126 pd=1.44 as=0.126 ps=1.44 w=0.42 l=0.15 sa=0.3 sb=0.3
X58 VDD XA XA_OUT VDD sky130_fd_pr__pfet_01v8_hvt ad=0.3 pd=2.6 as=0.3 ps=2.6 w=1 l=0.15 sa=0.3 sb=0.3
X59 GND XA XA_OUT GND sky130_fd_pr__nfet_01v8 ad=0.195 pd=1.9 as=0.195 ps=1.9 w=0.65 l=0.15 sa=0.3 sb=0.3
X62 VB VB GND GND sky130_fd_pr__nfet_01v8 ad=0.126 pd=1.44 as=0.126 ps=1.44 w=0.42 l=0.15 sa=0.3 sb=0.3
X63 a_n48_382# a_n48_382# VB GND sky130_fd_pr__nfet_01v8 ad=0.3 pd=2.6 as=0.3 ps=2.6 w=1 l=1 sa=0.3 sb=0.3
X65 a_7130_n1632# VB a_7040_n2004# GND sky130_fd_pr__nfet_01v8 ad=0.126 pd=1.44 as=0.126 ps=1.44 w=0.42 l=0.15 sa=0.3 sb=0.3
X70 a_n2000_n1632# VB a_n2090_n1632# GND sky130_fd_pr__nfet_01v8 ad=0.126 pd=1.44 as=0.126 ps=1.44 w=0.42 l=0.15 sa=0.3 sb=0.3
X71 a_n2000_n1632# VB a_n2090_n1632# GND sky130_fd_pr__nfet_01v8 ad=0.126 pd=1.44 as=0.126 ps=1.44 w=0.42 l=0.15 sa=0.3 sb=0.3
X72 VB VB GND GND sky130_fd_pr__nfet_01v8 ad=0.126 pd=1.44 as=0.126 ps=1.44 w=0.42 l=0.15 sa=0.3 sb=0.3
X74 GND DUTB a_4500_n392# GND sky130_fd_pr__nfet_01v8 ad=0.252 pd=2.28 as=0.252 ps=2.28 w=0.84 l=0.15 sa=0.3 sb=0.3
X77 a_7130_n1632# VB a_7040_n2004# GND sky130_fd_pr__nfet_01v8 ad=0.126 pd=1.44 as=0.126 ps=1.44 w=0.42 l=0.15 sa=0.3 sb=0.3
X78 a_7130_n1632# VB XB GND sky130_fd_pr__nfet_01v8 ad=0.126 pd=1.44 as=0.126 ps=1.44 w=0.42 l=0.15 sa=0.3 sb=0.3
X79 a_7130_n1632# VB a_7040_n2004# GND sky130_fd_pr__nfet_01v8 ad=0.126 pd=1.44 as=0.126 ps=1.44 w=0.42 l=0.15 sa=0.3 sb=0.3
X80 VB VB GND GND sky130_fd_pr__nfet_01v8 ad=0.126 pd=1.44 as=0.126 ps=1.44 w=0.42 l=0.15 sa=0.3 sb=0.3
X82 XA VB a_n2090_n1632# GND sky130_fd_pr__nfet_01v8 ad=0.126 pd=1.44 as=0.126 ps=1.44 w=0.42 l=0.15 sa=0.3 sb=0.3
X83 XA VB a_n2090_n1632# GND sky130_fd_pr__nfet_01v8 ad=0.126 pd=1.44 as=0.126 ps=1.44 w=0.42 l=0.15 sa=0.3 sb=0.3
X84 VB VB GND GND sky130_fd_pr__nfet_01v8 ad=0.126 pd=1.44 as=0.126 ps=1.44 w=0.42 l=0.15 sa=0.3 sb=0.3
X86 GND DUTA a_3900_n392# GND sky130_fd_pr__nfet_01v8 ad=0.252 pd=2.28 as=0.252 ps=2.28 w=0.84 l=0.15 sa=0.3 sb=0.3
X87 a_7130_n1632# VB XB GND sky130_fd_pr__nfet_01v8 ad=0.126 pd=1.44 as=0.126 ps=1.44 w=0.42 l=0.15 sa=0.3 sb=0.3
X89 a_7130_n1632# VB XB GND sky130_fd_pr__nfet_01v8 ad=0.126 pd=1.44 as=0.126 ps=1.44 w=0.42 l=0.15 sa=0.3 sb=0.3
X90 C1 C1 a_n48_382# GND sky130_fd_pr__nfet_01v8 ad=0.3 pd=2.6 as=0.3 ps=2.6 w=1 l=1 sa=0.3 sb=0.3
X91 VB VB GND GND sky130_fd_pr__nfet_01v8 ad=0.126 pd=1.44 as=0.126 ps=1.44 w=0.42 l=0.15 sa=0.3 sb=0.3
X92 VBIAS VBIAS C1 GND sky130_fd_pr__nfet_01v8 ad=0.3 pd=2.6 as=0.3 ps=2.6 w=1 l=1 sa=0.3 sb=0.3
X93 a_n2000_n1632# VB a_n2090_n1632# GND sky130_fd_pr__nfet_01v8 ad=0.126 pd=1.44 as=0.126 ps=1.44 w=0.42 l=0.15 sa=0.3 sb=0.3
X96 VB VB GND GND sky130_fd_pr__nfet_01v8 ad=0.126 pd=1.44 as=0.126 ps=1.44 w=0.42 l=0.15 sa=0.3 sb=0.3
X97 a_n2000_n1632# VB a_n2090_n1632# GND sky130_fd_pr__nfet_01v8 ad=0.126 pd=1.44 as=0.126 ps=1.44 w=0.42 l=0.15 sa=0.3 sb=0.3
X98 XA VB a_n2090_n1632# GND sky130_fd_pr__nfet_01v8 ad=0.126 pd=1.44 as=0.126 ps=1.44 w=0.42 l=0.15 sa=0.3 sb=0.3
C0 XB VDD 0.47777f
C1 SA0B VDD 0.04538f
C2 PREA VDD 0.17043f
C3 VB VDD 0.35118f
C4 VB REFB 0.00642f
C5 SA0B a_n2270_n1236# 0.00126f
C6 a_n2270_n1236# VB 0.04724f
C7 XB a_7040_n2004# 0.00524f
C8 VB a_7040_n2004# 0.14965f
C9 VB a_3900_n392# 0.07228f
C10 SA0B a_n2000_n1632# 0
C11 a_n2233_n890# VDD 0.17403f
C12 VDD SB0B 0.04538f
C13 a_7650_n924# XB 0.07509f
C14 VB a_n2000_n1632# 0.14597f
C15 a_n2233_n890# a_n2270_n1236# 0.39422f
C16 VB a_7650_n924# 0.05379f
C17 a_4500_n392# DUTA 0
C18 SB0B a_7040_n2004# 0
C19 a_7370_n924# a_7090_n924# 0.00251f
C20 SA2B VDD 0.05775f
C21 a_n2233_n890# a_n2000_n1632# 0
C22 SA1B VDD 0.05165f
C23 a_7650_n924# SB0B 0
C24 VB a_n2090_n1632# 0.41783f
C25 SA2B a_n2270_n1236# 0.00382f
C26 VBIAS VDD 0.03241f
C27 SA1B a_n2270_n1236# 0.0076f
C28 a_7090_n924# SB1B 0
C29 SA2B a_n2000_n1632# 0
C30 a_n2233_n890# a_n2090_n1632# 0.03226f
C31 a_7130_n1632# XB 0.4496f
C32 XA PREB 0
C33 a_n48_382# VDD 0.04849f
C34 CALA CALB 0.00657f
C35 C1 XA 0.00739f
C36 VB a_7130_n1632# 0.42699f
C37 a_7370_n924# SB1B 0.0076f
C38 a_n950_n924# VDD 0.00372f
C39 XB XA 0.02337f
C40 SA0B XA 0.01894f
C41 a_n2270_n1236# a_n950_n924# 0.00251f
C42 VB REFA 0.00473f
C43 PREA XA 0.02146f
C44 VB XA 0.84518f
C45 a_4500_n392# VDD 0.00496f
C46 a_7090_n924# VDD 0.00372f
C47 SA2B a_n2090_n1632# 0.00149f
C48 SA1B a_n2090_n1632# 0.00131f
C49 XB XB_OUT 0.02746f
C50 VB XB_OUT 0
C51 a_n2233_n890# XA 0.07515f
C52 XA_OUT VDD 0.11304f
C53 a_7370_n924# VDD 0.03521f
C54 XB DUTB 0.01922f
C55 VDD DUTA 0
C56 a_n2270_n1236# XA_OUT 0
C57 VB DUTB 0.01701f
C58 a_7650_n924# a_7090_n924# 0
C59 VDD CALB 0
C60 a_7370_n924# a_7040_n2004# 0.00505f
C61 a_3900_n392# DUTA 0.00298f
C62 a_n2090_n1632# a_n950_n924# 0
C63 VDD SB1B 0.06992f
C64 a_3900_n392# CALA 0
C65 SA2B XA 0.01399f
C66 SA1B XA 0.01535f
C67 a_7650_n924# a_7370_n924# 0.39422f
C68 VBIAS XA 0.00599f
C69 XB PREB 0.0233f
C70 PREA PREB 0.00413f
C71 VB PREB 0.00674f
C72 C1 VB 0.00902f
C73 VB XB 0.97094f
C74 a_7650_n924# SB1B 0
C75 SA0B VB 0
C76 a_n48_382# XA 0.0082f
C77 PREA VB 0.00674f
C78 a_n2270_n1236# VDD 0.02958f
C79 a_7130_n1632# a_7090_n924# 0
C80 XA a_n950_n924# 0.05363f
C81 XB SB0B 0.01894f
C82 VDD a_7040_n2004# 0
C83 SA0B a_n2233_n890# 0
C84 REFB a_7040_n2004# 0.00982f
C85 a_3900_n392# VDD 0.00496f
C86 a_n2233_n890# VB 0.0538f
C87 VB SB0B 0.00204f
C88 a_7130_n1632# a_7370_n924# 0.12211f
C89 a_7650_n924# VDD 0.20852f
C90 a_n2270_n1236# a_n2000_n1632# 0.00505f
C91 XA XA_OUT 0.02816f
C92 XA DUTA 0.00921f
C93 VBIAS C1 0.05143f
C94 XA CALA 0.59636f
C95 a_4500_n392# DUTB 0.00298f
C96 a_7130_n1632# SB1B 0.00131f
C97 a_7650_n924# a_7040_n2004# 0
C98 SA0B SA1B 0.01827f
C99 SA2B VB 0
C100 SA1B VB 0.00283f
C101 XA CALB 0
C102 a_n2090_n1632# VDD 0.03533f
C103 VBIAS VB 0.00565f
C104 a_n2270_n1236# a_n2090_n1632# 0.12211f
C105 C1 a_n48_382# 0.05143f
C106 DUTA DUTB 0.00465f
C107 a_n2233_n890# SA2B 0.00793f
C108 SA1B a_n2233_n890# 0
C109 VB a_n48_382# 0.06216f
C110 a_n2090_n1632# a_n2000_n1632# 0.44072f
C111 a_7130_n1632# VDD 0.03763f
C112 a_7130_n1632# REFB 0
C113 DUTB CALB 0
C114 SA0B a_n950_n924# 0.00164f
C115 VB a_n950_n924# 0
C116 XB a_4500_n392# 0.05778f
C117 XB a_7090_n924# 0.05363f
C118 XA VDD 0.42521f
C119 VB a_4500_n392# 0.0654f
C120 a_7130_n1632# a_7040_n2004# 0.44072f
C121 VB a_7090_n924# 0
C122 a_n2270_n1236# XA 0.16867f
C123 SA1B SA2B 0.01827f
C124 a_n2233_n890# a_n950_n924# 0
C125 a_7650_n924# a_7130_n1632# 0.03226f
C126 XB a_7370_n924# 0.16864f
C127 PREB CALB 0
C128 XB DUTA 0
C129 XA a_3900_n392# 0.05981f
C130 XB_OUT VDD 0.1139f
C131 XB CALA 0
C132 VB XA_OUT 0
C133 VB a_7370_n924# 0.05164f
C134 a_n2000_n1632# REFA 0.00982f
C135 VB DUTA 0.01701f
C136 a_n2000_n1632# XA 0.00524f
C137 VB CALA 0.01075f
C138 a_7090_n924# SB0B 0.00164f
C139 VDD DUTB 0
C140 XB CALB 0.60923f
C141 VB CALB 0.01176f
C142 XB SB1B 0.01535f
C143 SA1B a_n950_n924# 0
C144 VB SB1B 0.00327f
C145 a_n2233_n890# XA_OUT 0
C146 a_7370_n924# SB0B 0.00126f
C147 a_7650_n924# XB_OUT 0
C148 a_n2090_n1632# REFA 0
C149 a_n2090_n1632# XA 0.4496f
C150 PREB VDD 0.17673f
C151 C1 VDD 0.04849f
C152 SB1B SB0B 0.01827f
C153 CALB GND 0.28251f
C154 CALA GND 0.29501f
C155 REFB GND 0.2066f
C156 REFA GND 0.20807f
C157 SB1B GND 0.12444f
C158 SB0B GND 0.1517f
C159 SA0B GND 0.15374f
C160 SA1B GND 0.12484f
C161 SA2B GND 0.14094f
C162 DUTB GND 0.21831f
C163 DUTA GND 0.21794f
C164 XB_OUT GND 0.13753f
C165 PREB GND 0.10876f
C166 PREA GND 0.11529f
C167 VB GND 0.15572p
C168 XA_OUT GND 0.13768f
C169 XB GND 6.59752f
C170 VBIAS GND 0.5422f
C171 C1 GND 0.59586f
C172 XA GND 6.78506f
C173 VDD GND 10.6227f
C174 a_7040_n2004# GND 0.72419f
C175 a_7130_n1632# GND 0.82893f
C176 a_7370_n924# GND 0.61536f
C177 a_7090_n924# GND 0.01561f
C178 a_7650_n924# GND 0.48433f
C179 a_n2000_n1632# GND 0.72782f
C180 a_n2090_n1632# GND 0.83958f
C181 a_n950_n924# GND 0.01596f
C182 a_n2270_n1236# GND 0.61977f
C183 a_n2233_n890# GND 0.49496f
C184 a_4500_n392# GND 0.20468f
C185 a_3900_n392# GND 0.19922f
C186 a_n48_382# GND 0.59697f
.ends
Vd vdd 0 1.8
Vh hi 0 1.8
Vpre pre 0 pwl(0 1.8 1e-06 1.8 1.001e-06 0)
* --- h00: core
Xh00_ienn hi 0 0 vdd vdd h00_enn sky130_fd_sc_hd__inv_1
Xh00_is1n 0 0 0 vdd vdd h00_s1n sky130_fd_sc_hd__inv_1
Xh00_is0n 0 0 0 vdd vdd h00_s0n sky130_fd_sc_hd__inv_1
Xh00_PREA pre h00_enn 0 0 vdd vdd h00_PREA sky130_fd_sc_hd__nor2_1
Xh00_PREB pre h00_enn 0 0 vdd vdd h00_PREB sky130_fd_sc_hd__nor2_1
Xh00_VBIAS hi 0 0 vdd vdd h00_VBIAS sky130_fd_sc_hd__buf_2
Xh00_C1 hi 0 0 vdd vdd h00_C1 sky130_fd_sc_hd__buf_2
Xh00_DUTA hi h00_s1n 0 0 0 vdd vdd h00_DUTA sky130_fd_sc_hd__and3_1
Xh00_DUTB hi h00_s1n 0 0 0 vdd vdd h00_DUTB sky130_fd_sc_hd__and3_1
Xh00_REFA hi 0 0 0 vdd vdd h00_REFA sky130_fd_sc_hd__and2_1
Xh00_REFB hi 0 0 0 vdd vdd h00_REFB sky130_fd_sc_hd__and2_1
Xh00_SA0B hi 0 0 0 0 vdd vdd h00_SA0B sky130_fd_sc_hd__nand3_1
Xh00_SA1B hi 0 0 0 vdd vdd h00_SA1B sky130_fd_sc_hd__nand2_1
Xh00_SA2B hi 0 h00_s0n 0 0 vdd vdd h00_SA2B sky130_fd_sc_hd__nand3_1
Xh00_SB0B hi 0 0 0 vdd vdd h00_SB0B sky130_fd_sc_hd__nand2_1
Xh00_SB1B hi 0 0 0 vdd vdd h00_SB1B sky130_fd_sc_hd__nand2_1
Xh00_M h00_ob h00_SB0B h00_SB1B h00_REFB h00_oa h00_SA0B h00_SA1B h00_SA2B h00_REFA vdd 0 h00_VBIAS h00_C1 h00_PREA h00_XA h00_DUTA h00_PREB h00_XB h00_DUTB h00_VB 0 0 core

* --- a16: core
Xa16_ienn hi 0 0 vdd vdd a16_enn sky130_fd_sc_hd__inv_1
Xa16_is1n 0 0 0 vdd vdd a16_s1n sky130_fd_sc_hd__inv_1
Xa16_is0n 0 0 0 vdd vdd a16_s0n sky130_fd_sc_hd__inv_1
Xa16_PREA pre a16_enn 0 0 vdd vdd a16_PREA sky130_fd_sc_hd__nor2_1
Xa16_PREB pre a16_enn 0 0 vdd vdd a16_PREB sky130_fd_sc_hd__nor2_1
Xa16_VBIAS hi 0 0 vdd vdd a16_VBIAS sky130_fd_sc_hd__buf_2
Xa16_C1 hi 0 0 vdd vdd a16_C1 sky130_fd_sc_hd__buf_2
Xa16_DUTA hi a16_s1n 0 0 0 vdd vdd a16_DUTA sky130_fd_sc_hd__and3_1
Xa16_DUTB hi a16_s1n 0 0 0 vdd vdd a16_DUTB sky130_fd_sc_hd__and3_1
Xa16_REFA hi 0 0 0 vdd vdd a16_REFA sky130_fd_sc_hd__and2_1
Xa16_REFB hi 0 0 0 vdd vdd a16_REFB sky130_fd_sc_hd__and2_1
Xa16_SA0B hi 0 0 0 0 vdd vdd a16_SA0B sky130_fd_sc_hd__nand3_1
Xa16_SA1B hi 0 0 0 vdd vdd a16_SA1B sky130_fd_sc_hd__nand2_1
Xa16_SA2B hi 0 a16_s0n 0 0 vdd vdd a16_SA2B sky130_fd_sc_hd__nand3_1
Xa16_SB0B hi 0 0 0 vdd vdd a16_SB0B sky130_fd_sc_hd__nand2_1
Xa16_SB1B hi 0 0 0 vdd vdd a16_SB1B sky130_fd_sc_hd__nand2_1
Xa16_M a16_ob a16_SB0B a16_SB1B a16_REFB a16_oa a16_SA0B a16_SA1B a16_SA2B a16_REFA vdd 0 a16_VBIAS a16_C1 a16_PREA a16_XA a16_DUTA a16_PREB a16_XB a16_DUTB a16_VB 0 0 core
Xa16edA0 a16_XA a16_VB a16_mA0 0 sky130_fd_pr__nfet_01v8 ad=0.126 pd=1.44 as=0.126 ps=1.44 w=0.42 l=0.15 sa=0.3 sb=0.3
Xa16esA0 0 0 a16_mA0 0 sky130_fd_pr__nfet_01v8 ad=0.252 pd=2.28 as=0.252 ps=2.28 w=0.84 l=0.15 sa=0.3 sb=0.3
Ca16eA0_0 a16_mA0 a16_VB 0.07228f
Ca16eA0_1 a16_mA0 0 0.00298f
Ca16eA0_2 a16_mA0 vdd 0.00496f
Ca16eA0_3 a16_mA0 a16_XA 0.05981f
Ca16eA0_4 a16_mA0 0 0.19922f
Xa16edA1 a16_XA a16_VB a16_mA1 0 sky130_fd_pr__nfet_01v8 ad=0.126 pd=1.44 as=0.126 ps=1.44 w=0.42 l=0.15 sa=0.3 sb=0.3
Xa16esA1 0 0 a16_mA1 0 sky130_fd_pr__nfet_01v8 ad=0.252 pd=2.28 as=0.252 ps=2.28 w=0.84 l=0.15 sa=0.3 sb=0.3
Ca16eA1_0 a16_mA1 a16_VB 0.07228f
Ca16eA1_1 a16_mA1 0 0.00298f
Ca16eA1_2 a16_mA1 vdd 0.00496f
Ca16eA1_3 a16_mA1 a16_XA 0.05981f
Ca16eA1_4 a16_mA1 0 0.19922f
Xa16edA2 a16_XA a16_VB a16_mA2 0 sky130_fd_pr__nfet_01v8 ad=0.126 pd=1.44 as=0.126 ps=1.44 w=0.42 l=0.15 sa=0.3 sb=0.3
Xa16esA2 0 0 a16_mA2 0 sky130_fd_pr__nfet_01v8 ad=0.252 pd=2.28 as=0.252 ps=2.28 w=0.84 l=0.15 sa=0.3 sb=0.3
Ca16eA2_0 a16_mA2 a16_VB 0.07228f
Ca16eA2_1 a16_mA2 0 0.00298f
Ca16eA2_2 a16_mA2 vdd 0.00496f
Ca16eA2_3 a16_mA2 a16_XA 0.05981f
Ca16eA2_4 a16_mA2 0 0.19922f
Xa16edA3 a16_XA a16_VB a16_mA3 0 sky130_fd_pr__nfet_01v8 ad=0.126 pd=1.44 as=0.126 ps=1.44 w=0.42 l=0.15 sa=0.3 sb=0.3
Xa16esA3 0 0 a16_mA3 0 sky130_fd_pr__nfet_01v8 ad=0.252 pd=2.28 as=0.252 ps=2.28 w=0.84 l=0.15 sa=0.3 sb=0.3
Ca16eA3_0 a16_mA3 a16_VB 0.07228f
Ca16eA3_1 a16_mA3 0 0.00298f
Ca16eA3_2 a16_mA3 vdd 0.00496f
Ca16eA3_3 a16_mA3 a16_XA 0.05981f
Ca16eA3_4 a16_mA3 0 0.19922f
Xa16edA4 a16_XA a16_VB a16_mA4 0 sky130_fd_pr__nfet_01v8 ad=0.126 pd=1.44 as=0.126 ps=1.44 w=0.42 l=0.15 sa=0.3 sb=0.3
Xa16esA4 0 0 a16_mA4 0 sky130_fd_pr__nfet_01v8 ad=0.252 pd=2.28 as=0.252 ps=2.28 w=0.84 l=0.15 sa=0.3 sb=0.3
Ca16eA4_0 a16_mA4 a16_VB 0.07228f
Ca16eA4_1 a16_mA4 0 0.00298f
Ca16eA4_2 a16_mA4 vdd 0.00496f
Ca16eA4_3 a16_mA4 a16_XA 0.05981f
Ca16eA4_4 a16_mA4 0 0.19922f
Xa16edA5 a16_XA a16_VB a16_mA5 0 sky130_fd_pr__nfet_01v8 ad=0.126 pd=1.44 as=0.126 ps=1.44 w=0.42 l=0.15 sa=0.3 sb=0.3
Xa16esA5 0 0 a16_mA5 0 sky130_fd_pr__nfet_01v8 ad=0.252 pd=2.28 as=0.252 ps=2.28 w=0.84 l=0.15 sa=0.3 sb=0.3
Ca16eA5_0 a16_mA5 a16_VB 0.07228f
Ca16eA5_1 a16_mA5 0 0.00298f
Ca16eA5_2 a16_mA5 vdd 0.00496f
Ca16eA5_3 a16_mA5 a16_XA 0.05981f
Ca16eA5_4 a16_mA5 0 0.19922f
Xa16edA6 a16_XA a16_VB a16_mA6 0 sky130_fd_pr__nfet_01v8 ad=0.126 pd=1.44 as=0.126 ps=1.44 w=0.42 l=0.15 sa=0.3 sb=0.3
Xa16esA6 0 0 a16_mA6 0 sky130_fd_pr__nfet_01v8 ad=0.252 pd=2.28 as=0.252 ps=2.28 w=0.84 l=0.15 sa=0.3 sb=0.3
Ca16eA6_0 a16_mA6 a16_VB 0.07228f
Ca16eA6_1 a16_mA6 0 0.00298f
Ca16eA6_2 a16_mA6 vdd 0.00496f
Ca16eA6_3 a16_mA6 a16_XA 0.05981f
Ca16eA6_4 a16_mA6 0 0.19922f
Xa16edA7 a16_XA a16_VB a16_mA7 0 sky130_fd_pr__nfet_01v8 ad=0.126 pd=1.44 as=0.126 ps=1.44 w=0.42 l=0.15 sa=0.3 sb=0.3
Xa16esA7 0 0 a16_mA7 0 sky130_fd_pr__nfet_01v8 ad=0.252 pd=2.28 as=0.252 ps=2.28 w=0.84 l=0.15 sa=0.3 sb=0.3
Ca16eA7_0 a16_mA7 a16_VB 0.07228f
Ca16eA7_1 a16_mA7 0 0.00298f
Ca16eA7_2 a16_mA7 vdd 0.00496f
Ca16eA7_3 a16_mA7 a16_XA 0.05981f
Ca16eA7_4 a16_mA7 0 0.19922f
Xa16edA8 a16_XA a16_VB a16_mA8 0 sky130_fd_pr__nfet_01v8 ad=0.126 pd=1.44 as=0.126 ps=1.44 w=0.42 l=0.15 sa=0.3 sb=0.3
Xa16esA8 0 0 a16_mA8 0 sky130_fd_pr__nfet_01v8 ad=0.252 pd=2.28 as=0.252 ps=2.28 w=0.84 l=0.15 sa=0.3 sb=0.3
Ca16eA8_0 a16_mA8 a16_VB 0.07228f
Ca16eA8_1 a16_mA8 0 0.00298f
Ca16eA8_2 a16_mA8 vdd 0.00496f
Ca16eA8_3 a16_mA8 a16_XA 0.05981f
Ca16eA8_4 a16_mA8 0 0.19922f
Xa16edA9 a16_XA a16_VB a16_mA9 0 sky130_fd_pr__nfet_01v8 ad=0.126 pd=1.44 as=0.126 ps=1.44 w=0.42 l=0.15 sa=0.3 sb=0.3
Xa16esA9 0 0 a16_mA9 0 sky130_fd_pr__nfet_01v8 ad=0.252 pd=2.28 as=0.252 ps=2.28 w=0.84 l=0.15 sa=0.3 sb=0.3
Ca16eA9_0 a16_mA9 a16_VB 0.07228f
Ca16eA9_1 a16_mA9 0 0.00298f
Ca16eA9_2 a16_mA9 vdd 0.00496f
Ca16eA9_3 a16_mA9 a16_XA 0.05981f
Ca16eA9_4 a16_mA9 0 0.19922f
Xa16edA10 a16_XA a16_VB a16_mA10 0 sky130_fd_pr__nfet_01v8 ad=0.126 pd=1.44 as=0.126 ps=1.44 w=0.42 l=0.15 sa=0.3 sb=0.3
Xa16esA10 0 0 a16_mA10 0 sky130_fd_pr__nfet_01v8 ad=0.252 pd=2.28 as=0.252 ps=2.28 w=0.84 l=0.15 sa=0.3 sb=0.3
Ca16eA10_0 a16_mA10 a16_VB 0.07228f
Ca16eA10_1 a16_mA10 0 0.00298f
Ca16eA10_2 a16_mA10 vdd 0.00496f
Ca16eA10_3 a16_mA10 a16_XA 0.05981f
Ca16eA10_4 a16_mA10 0 0.19922f
Xa16edA11 a16_XA a16_VB a16_mA11 0 sky130_fd_pr__nfet_01v8 ad=0.126 pd=1.44 as=0.126 ps=1.44 w=0.42 l=0.15 sa=0.3 sb=0.3
Xa16esA11 0 0 a16_mA11 0 sky130_fd_pr__nfet_01v8 ad=0.252 pd=2.28 as=0.252 ps=2.28 w=0.84 l=0.15 sa=0.3 sb=0.3
Ca16eA11_0 a16_mA11 a16_VB 0.07228f
Ca16eA11_1 a16_mA11 0 0.00298f
Ca16eA11_2 a16_mA11 vdd 0.00496f
Ca16eA11_3 a16_mA11 a16_XA 0.05981f
Ca16eA11_4 a16_mA11 0 0.19922f
Xa16edA12 a16_XA a16_VB a16_mA12 0 sky130_fd_pr__nfet_01v8 ad=0.126 pd=1.44 as=0.126 ps=1.44 w=0.42 l=0.15 sa=0.3 sb=0.3
Xa16esA12 0 0 a16_mA12 0 sky130_fd_pr__nfet_01v8 ad=0.252 pd=2.28 as=0.252 ps=2.28 w=0.84 l=0.15 sa=0.3 sb=0.3
Ca16eA12_0 a16_mA12 a16_VB 0.07228f
Ca16eA12_1 a16_mA12 0 0.00298f
Ca16eA12_2 a16_mA12 vdd 0.00496f
Ca16eA12_3 a16_mA12 a16_XA 0.05981f
Ca16eA12_4 a16_mA12 0 0.19922f
Xa16edA13 a16_XA a16_VB a16_mA13 0 sky130_fd_pr__nfet_01v8 ad=0.126 pd=1.44 as=0.126 ps=1.44 w=0.42 l=0.15 sa=0.3 sb=0.3
Xa16esA13 0 0 a16_mA13 0 sky130_fd_pr__nfet_01v8 ad=0.252 pd=2.28 as=0.252 ps=2.28 w=0.84 l=0.15 sa=0.3 sb=0.3
Ca16eA13_0 a16_mA13 a16_VB 0.07228f
Ca16eA13_1 a16_mA13 0 0.00298f
Ca16eA13_2 a16_mA13 vdd 0.00496f
Ca16eA13_3 a16_mA13 a16_XA 0.05981f
Ca16eA13_4 a16_mA13 0 0.19922f
Xa16edA14 a16_XA a16_VB a16_mA14 0 sky130_fd_pr__nfet_01v8 ad=0.126 pd=1.44 as=0.126 ps=1.44 w=0.42 l=0.15 sa=0.3 sb=0.3
Xa16esA14 0 0 a16_mA14 0 sky130_fd_pr__nfet_01v8 ad=0.252 pd=2.28 as=0.252 ps=2.28 w=0.84 l=0.15 sa=0.3 sb=0.3
Ca16eA14_0 a16_mA14 a16_VB 0.07228f
Ca16eA14_1 a16_mA14 0 0.00298f
Ca16eA14_2 a16_mA14 vdd 0.00496f
Ca16eA14_3 a16_mA14 a16_XA 0.05981f
Ca16eA14_4 a16_mA14 0 0.19922f
Xa16edB0 a16_XB a16_VB a16_mB0 0 sky130_fd_pr__nfet_01v8 ad=0.126 pd=1.44 as=0.126 ps=1.44 w=0.42 l=0.15 sa=0.3 sb=0.3
Xa16esB0 0 0 a16_mB0 0 sky130_fd_pr__nfet_01v8 ad=0.252 pd=2.28 as=0.252 ps=2.28 w=0.84 l=0.15 sa=0.3 sb=0.3
Ca16eB0_0 a16_mB0 vdd 0.00496f
Ca16eB0_1 a16_mB0 0 0.00298f
Ca16eB0_2 a16_mB0 a16_XB 0.05778f
Ca16eB0_3 a16_mB0 a16_VB 0.0654f
Ca16eB0_4 a16_mB0 0 0.20468f
Xa16edB1 a16_XB a16_VB a16_mB1 0 sky130_fd_pr__nfet_01v8 ad=0.126 pd=1.44 as=0.126 ps=1.44 w=0.42 l=0.15 sa=0.3 sb=0.3
Xa16esB1 0 0 a16_mB1 0 sky130_fd_pr__nfet_01v8 ad=0.252 pd=2.28 as=0.252 ps=2.28 w=0.84 l=0.15 sa=0.3 sb=0.3
Ca16eB1_0 a16_mB1 vdd 0.00496f
Ca16eB1_1 a16_mB1 0 0.00298f
Ca16eB1_2 a16_mB1 a16_XB 0.05778f
Ca16eB1_3 a16_mB1 a16_VB 0.0654f
Ca16eB1_4 a16_mB1 0 0.20468f
Xa16edB2 a16_XB a16_VB a16_mB2 0 sky130_fd_pr__nfet_01v8 ad=0.126 pd=1.44 as=0.126 ps=1.44 w=0.42 l=0.15 sa=0.3 sb=0.3
Xa16esB2 0 0 a16_mB2 0 sky130_fd_pr__nfet_01v8 ad=0.252 pd=2.28 as=0.252 ps=2.28 w=0.84 l=0.15 sa=0.3 sb=0.3
Ca16eB2_0 a16_mB2 vdd 0.00496f
Ca16eB2_1 a16_mB2 0 0.00298f
Ca16eB2_2 a16_mB2 a16_XB 0.05778f
Ca16eB2_3 a16_mB2 a16_VB 0.0654f
Ca16eB2_4 a16_mB2 0 0.20468f
Xa16edB3 a16_XB a16_VB a16_mB3 0 sky130_fd_pr__nfet_01v8 ad=0.126 pd=1.44 as=0.126 ps=1.44 w=0.42 l=0.15 sa=0.3 sb=0.3
Xa16esB3 0 0 a16_mB3 0 sky130_fd_pr__nfet_01v8 ad=0.252 pd=2.28 as=0.252 ps=2.28 w=0.84 l=0.15 sa=0.3 sb=0.3
Ca16eB3_0 a16_mB3 vdd 0.00496f
Ca16eB3_1 a16_mB3 0 0.00298f
Ca16eB3_2 a16_mB3 a16_XB 0.05778f
Ca16eB3_3 a16_mB3 a16_VB 0.0654f
Ca16eB3_4 a16_mB3 0 0.20468f
Xa16edB4 a16_XB a16_VB a16_mB4 0 sky130_fd_pr__nfet_01v8 ad=0.126 pd=1.44 as=0.126 ps=1.44 w=0.42 l=0.15 sa=0.3 sb=0.3
Xa16esB4 0 0 a16_mB4 0 sky130_fd_pr__nfet_01v8 ad=0.252 pd=2.28 as=0.252 ps=2.28 w=0.84 l=0.15 sa=0.3 sb=0.3
Ca16eB4_0 a16_mB4 vdd 0.00496f
Ca16eB4_1 a16_mB4 0 0.00298f
Ca16eB4_2 a16_mB4 a16_XB 0.05778f
Ca16eB4_3 a16_mB4 a16_VB 0.0654f
Ca16eB4_4 a16_mB4 0 0.20468f
Xa16edB5 a16_XB a16_VB a16_mB5 0 sky130_fd_pr__nfet_01v8 ad=0.126 pd=1.44 as=0.126 ps=1.44 w=0.42 l=0.15 sa=0.3 sb=0.3
Xa16esB5 0 0 a16_mB5 0 sky130_fd_pr__nfet_01v8 ad=0.252 pd=2.28 as=0.252 ps=2.28 w=0.84 l=0.15 sa=0.3 sb=0.3
Ca16eB5_0 a16_mB5 vdd 0.00496f
Ca16eB5_1 a16_mB5 0 0.00298f
Ca16eB5_2 a16_mB5 a16_XB 0.05778f
Ca16eB5_3 a16_mB5 a16_VB 0.0654f
Ca16eB5_4 a16_mB5 0 0.20468f
Xa16edB6 a16_XB a16_VB a16_mB6 0 sky130_fd_pr__nfet_01v8 ad=0.126 pd=1.44 as=0.126 ps=1.44 w=0.42 l=0.15 sa=0.3 sb=0.3
Xa16esB6 0 0 a16_mB6 0 sky130_fd_pr__nfet_01v8 ad=0.252 pd=2.28 as=0.252 ps=2.28 w=0.84 l=0.15 sa=0.3 sb=0.3
Ca16eB6_0 a16_mB6 vdd 0.00496f
Ca16eB6_1 a16_mB6 0 0.00298f
Ca16eB6_2 a16_mB6 a16_XB 0.05778f
Ca16eB6_3 a16_mB6 a16_VB 0.0654f
Ca16eB6_4 a16_mB6 0 0.20468f
Xa16edB7 a16_XB a16_VB a16_mB7 0 sky130_fd_pr__nfet_01v8 ad=0.126 pd=1.44 as=0.126 ps=1.44 w=0.42 l=0.15 sa=0.3 sb=0.3
Xa16esB7 0 0 a16_mB7 0 sky130_fd_pr__nfet_01v8 ad=0.252 pd=2.28 as=0.252 ps=2.28 w=0.84 l=0.15 sa=0.3 sb=0.3
Ca16eB7_0 a16_mB7 vdd 0.00496f
Ca16eB7_1 a16_mB7 0 0.00298f
Ca16eB7_2 a16_mB7 a16_XB 0.05778f
Ca16eB7_3 a16_mB7 a16_VB 0.0654f
Ca16eB7_4 a16_mB7 0 0.20468f
Xa16edB8 a16_XB a16_VB a16_mB8 0 sky130_fd_pr__nfet_01v8 ad=0.126 pd=1.44 as=0.126 ps=1.44 w=0.42 l=0.15 sa=0.3 sb=0.3
Xa16esB8 0 0 a16_mB8 0 sky130_fd_pr__nfet_01v8 ad=0.252 pd=2.28 as=0.252 ps=2.28 w=0.84 l=0.15 sa=0.3 sb=0.3
Ca16eB8_0 a16_mB8 vdd 0.00496f
Ca16eB8_1 a16_mB8 0 0.00298f
Ca16eB8_2 a16_mB8 a16_XB 0.05778f
Ca16eB8_3 a16_mB8 a16_VB 0.0654f
Ca16eB8_4 a16_mB8 0 0.20468f
Xa16edB9 a16_XB a16_VB a16_mB9 0 sky130_fd_pr__nfet_01v8 ad=0.126 pd=1.44 as=0.126 ps=1.44 w=0.42 l=0.15 sa=0.3 sb=0.3
Xa16esB9 0 0 a16_mB9 0 sky130_fd_pr__nfet_01v8 ad=0.252 pd=2.28 as=0.252 ps=2.28 w=0.84 l=0.15 sa=0.3 sb=0.3
Ca16eB9_0 a16_mB9 vdd 0.00496f
Ca16eB9_1 a16_mB9 0 0.00298f
Ca16eB9_2 a16_mB9 a16_XB 0.05778f
Ca16eB9_3 a16_mB9 a16_VB 0.0654f
Ca16eB9_4 a16_mB9 0 0.20468f
Xa16edB10 a16_XB a16_VB a16_mB10 0 sky130_fd_pr__nfet_01v8 ad=0.126 pd=1.44 as=0.126 ps=1.44 w=0.42 l=0.15 sa=0.3 sb=0.3
Xa16esB10 0 0 a16_mB10 0 sky130_fd_pr__nfet_01v8 ad=0.252 pd=2.28 as=0.252 ps=2.28 w=0.84 l=0.15 sa=0.3 sb=0.3
Ca16eB10_0 a16_mB10 vdd 0.00496f
Ca16eB10_1 a16_mB10 0 0.00298f
Ca16eB10_2 a16_mB10 a16_XB 0.05778f
Ca16eB10_3 a16_mB10 a16_VB 0.0654f
Ca16eB10_4 a16_mB10 0 0.20468f
Xa16edB11 a16_XB a16_VB a16_mB11 0 sky130_fd_pr__nfet_01v8 ad=0.126 pd=1.44 as=0.126 ps=1.44 w=0.42 l=0.15 sa=0.3 sb=0.3
Xa16esB11 0 0 a16_mB11 0 sky130_fd_pr__nfet_01v8 ad=0.252 pd=2.28 as=0.252 ps=2.28 w=0.84 l=0.15 sa=0.3 sb=0.3
Ca16eB11_0 a16_mB11 vdd 0.00496f
Ca16eB11_1 a16_mB11 0 0.00298f
Ca16eB11_2 a16_mB11 a16_XB 0.05778f
Ca16eB11_3 a16_mB11 a16_VB 0.0654f
Ca16eB11_4 a16_mB11 0 0.20468f
Xa16edB12 a16_XB a16_VB a16_mB12 0 sky130_fd_pr__nfet_01v8 ad=0.126 pd=1.44 as=0.126 ps=1.44 w=0.42 l=0.15 sa=0.3 sb=0.3
Xa16esB12 0 0 a16_mB12 0 sky130_fd_pr__nfet_01v8 ad=0.252 pd=2.28 as=0.252 ps=2.28 w=0.84 l=0.15 sa=0.3 sb=0.3
Ca16eB12_0 a16_mB12 vdd 0.00496f
Ca16eB12_1 a16_mB12 0 0.00298f
Ca16eB12_2 a16_mB12 a16_XB 0.05778f
Ca16eB12_3 a16_mB12 a16_VB 0.0654f
Ca16eB12_4 a16_mB12 0 0.20468f
Xa16edB13 a16_XB a16_VB a16_mB13 0 sky130_fd_pr__nfet_01v8 ad=0.126 pd=1.44 as=0.126 ps=1.44 w=0.42 l=0.15 sa=0.3 sb=0.3
Xa16esB13 0 0 a16_mB13 0 sky130_fd_pr__nfet_01v8 ad=0.252 pd=2.28 as=0.252 ps=2.28 w=0.84 l=0.15 sa=0.3 sb=0.3
Ca16eB13_0 a16_mB13 vdd 0.00496f
Ca16eB13_1 a16_mB13 0 0.00298f
Ca16eB13_2 a16_mB13 a16_XB 0.05778f
Ca16eB13_3 a16_mB13 a16_VB 0.0654f
Ca16eB13_4 a16_mB13 0 0.20468f
Xa16edB14 a16_XB a16_VB a16_mB14 0 sky130_fd_pr__nfet_01v8 ad=0.126 pd=1.44 as=0.126 ps=1.44 w=0.42 l=0.15 sa=0.3 sb=0.3
Xa16esB14 0 0 a16_mB14 0 sky130_fd_pr__nfet_01v8 ad=0.252 pd=2.28 as=0.252 ps=2.28 w=0.84 l=0.15 sa=0.3 sb=0.3
Ca16eB14_0 a16_mB14 vdd 0.00496f
Ca16eB14_1 a16_mB14 0 0.00298f
Ca16eB14_2 a16_mB14 a16_XB 0.05778f
Ca16eB14_3 a16_mB14 a16_VB 0.0654f
Ca16eB14_4 a16_mB14 0 0.20468f

.control
set noaskquit
save v(h00_XA) v(a16_XA) v(a16_XB) v(a16_oa) v(a16_ob)
tran 100n 1.4m 0 200n
meas tran h00_XA_min min v(h00_XA) from=1e-06 to=1.4m
echo LG ss 85 h00_XA_min $&h00_XA_min
meas tran a16_XA_min min v(a16_XA) from=1e-06 to=1.4m
echo LG ss 85 a16_XA_min $&a16_XA_min
meas tran a16_XB_min min v(a16_XB) from=1e-06 to=1.4m
echo LG ss 85 a16_XB_min $&a16_XB_min
meas tran a16_oa_max max v(a16_oa) from=1e-06 to=1.4m
echo LG ss 85 a16_oa_max $&a16_oa_max
meas tran a16_ob_max max v(a16_ob) from=1e-06 to=1.4m
echo LG ss 85 a16_ob_max $&a16_ob_max
quit
.endc
.end
