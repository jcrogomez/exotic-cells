* NGSPICE file created from xc14fg.ext - technology: sky130A

.subckt xc14fg SEL0 SEL1 SEL2 SEL3 SEL4 SEL5 SEL6 SEL7 SEL8 SEL9 SEL10 X VB GND CP1
+ CP2
X0 X a_3484_n26# a_3424_n392# GND sky130_fd_pr__nfet_g5v0d10v5 ad=0.126 pd=1.44 as=0.126 ps=1.44 w=0.42 l=0.5
X1 X a_766_n26# a_706_n392# GND sky130_fd_pr__nfet_g5v0d10v5 ad=0.126 pd=1.44 as=0.126 ps=1.44 w=0.42 l=0.5
X2 GND SEL9 a_7802_n392# GND sky130_fd_pr__nfet_01v8 ad=0.252 pd=2.28 as=0.252 ps=2.28 w=0.84 l=0.15
X3 X a_7002_n26# a_6942_n392# GND sky130_fd_pr__nfet_g5v0d10v5 ad=0.126 pd=1.44 as=0.126 ps=1.44 w=0.42 l=0.5
X4 X a_198_n26# a_138_n392# GND sky130_fd_pr__nfet_g5v0d10v5 ad=0.126 pd=1.44 as=0.126 ps=1.44 w=0.42 l=0.5
X5 GND SEL3 a_1566_n392# GND sky130_fd_pr__nfet_01v8 ad=0.252 pd=2.28 as=0.252 ps=2.28 w=0.84 l=0.15
X6 GND SEL2 a_706_n392# GND sky130_fd_pr__nfet_01v8 ad=0.252 pd=2.28 as=0.252 ps=2.28 w=0.84 l=0.15
X7 GND SEL5 a_3424_n392# GND sky130_fd_pr__nfet_01v8 ad=0.252 pd=2.28 as=0.252 ps=2.28 w=0.84 l=0.15
X8 GND SEL0 a_138_n392# GND sky130_fd_pr__nfet_01v8 ad=0.252 pd=2.28 as=0.252 ps=2.28 w=0.84 l=0.15
X9 X VB a_7802_n392# GND sky130_fd_pr__nfet_g5v0d10v5 ad=0.126 pd=1.44 as=0.126 ps=1.44 w=0.42 l=0.5
X10 X a_1626_n26# a_1566_n392# GND sky130_fd_pr__nfet_g5v0d10v5 ad=0.126 pd=1.44 as=0.126 ps=1.44 w=0.42 l=0.5
X11 X a_6142_n26# a_6082_n392# GND sky130_fd_pr__nfet_g5v0d10v5 ad=0.126 pd=1.44 as=0.126 ps=1.44 w=0.42 l=0.5
X12 GND SEL1 a_422_n392# GND sky130_fd_pr__nfet_01v8 ad=0.252 pd=2.28 as=0.252 ps=2.28 w=0.84 l=0.15
X13 GND SEL7 a_6082_n392# GND sky130_fd_pr__nfet_01v8 ad=0.252 pd=2.28 as=0.252 ps=2.28 w=0.84 l=0.15
X14 GND SEL10 a_8800_n392# GND sky130_fd_pr__nfet_01v8 ad=0.252 pd=2.28 as=0.252 ps=2.28 w=0.84 l=0.15
X15 GND a_7002_n26# sky130_fd_pr__diode_pw2nd_05v5 perim=1.8e+06 area=2.025e+11
X16 X a_482_n26# a_422_n392# GND sky130_fd_pr__nfet_g5v0d10v5 ad=0.126 pd=1.44 as=0.126 ps=1.44 w=0.42 l=0.5
X17 GND SEL6 a_4284_n392# GND sky130_fd_pr__nfet_01v8 ad=0.252 pd=2.28 as=0.252 ps=2.28 w=0.84 l=0.15
X18 GND SEL4 a_2564_n392# GND sky130_fd_pr__nfet_01v8 ad=0.252 pd=2.28 as=0.252 ps=2.28 w=0.84 l=0.15
X19 X a_4344_n26# a_4284_n392# GND sky130_fd_pr__nfet_g5v0d10v5 ad=0.126 pd=1.44 as=0.126 ps=1.44 w=0.42 l=0.5
X20 GND a_6142_n26# sky130_fd_pr__diode_pw2nd_05v5 perim=1.8e+06 area=2.025e+11
X21 X a_8841_344# a_8800_n392# GND sky130_fd_pr__nfet_01v8 ad=0.126 pd=1.44 as=0.126 ps=1.44 w=0.42 l=0.15
X22 GND SEL8 a_6942_n392# GND sky130_fd_pr__nfet_01v8 ad=0.252 pd=2.28 as=0.252 ps=2.28 w=0.84 l=0.15
X23 X a_2624_n26# a_2564_n392# GND sky130_fd_pr__nfet_g5v0d10v5 ad=0.126 pd=1.44 as=0.126 ps=1.44 w=0.42 l=0.5
C0 a_766_n26# a_1566_n392# 0
C1 a_6082_n392# a_6942_n392# 0.00645f
C2 SEL4 SEL5 0.02034f
C3 X VB 1.70915f
C4 CP2 CP1 50.2364f
C5 VB SEL7 0.00233f
C6 a_3424_n392# a_2564_n392# 0.00645f
C7 a_2564_n392# SEL3 0
C8 a_706_n392# a_482_n26# 0.00116f
C9 VB CP1 1.67424f
C10 VB a_7802_n392# 0.07469f
C11 X a_1626_n26# 0.0487f
C12 a_198_n26# SEL0 0.00741f
C13 a_2564_n392# a_1566_n392# 0.00555f
C14 a_766_n26# a_482_n26# 0.06153f
C15 SEL4 SEL3 0.01746f
C16 SEL4 a_3424_n392# 0
C17 VB CP2 1.68126f
C18 X SEL0 0
C19 CP1 a_1626_n26# 0.98909f
C20 a_3424_n392# SEL5 0.0031f
C21 X a_4284_n392# 0.02463f
C22 a_8800_n392# SEL9 0
C23 X a_2624_n26# 0.04885f
C24 a_706_n392# SEL2 0.0031f
C25 CP1 SEL0 0.00488f
C26 a_422_n392# a_482_n26# 0.007f
C27 CP2 a_1626_n26# 0.84269f
C28 X a_6142_n26# 0.05465f
C29 X a_706_n392# 0.04316f
C30 X a_8800_n392# 0.03486f
C31 SEL6 SEL5 0.02034f
C32 CP1 a_4284_n392# 0.00253f
C33 X a_4344_n26# 0.04934f
C34 X a_3484_n26# 0.04877f
C35 a_766_n26# SEL2 0.00746f
C36 a_6142_n26# SEL7 0.00749f
C37 CP1 a_2624_n26# 1.63443f
C38 a_766_n26# X 0.05026f
C39 CP2 SEL0 0
C40 VB a_1626_n26# 0.00968f
C41 a_6142_n26# CP1 1.6276f
C42 a_706_n392# CP1 0.00262f
C43 a_8800_n392# CP1 0.00253f
C44 CP1 a_4344_n26# 3.14104f
C45 CP1 a_3484_n26# 1.59682f
C46 a_8800_n392# a_7802_n392# 0.00386f
C47 CP2 a_2624_n26# 1.69065f
C48 a_766_n26# CP1 0.99521f
C49 a_198_n26# a_422_n392# 0.00116f
C50 VB SEL0 0.00233f
C51 X a_8841_344# 0.02729f
C52 a_6142_n26# CP2 1.68024f
C53 a_706_n392# CP2 0
C54 SEL8 SEL9 0.02034f
C55 VB a_4284_n392# 0.03941f
C56 X a_422_n392# 0.04316f
C57 CP2 a_4344_n26# 3.25629f
C58 CP2 a_3484_n26# 1.65079f
C59 SEL3 a_1566_n392# 0.0031f
C60 a_482_n26# SEL1 0.00741f
C61 VB a_2624_n26# 0.00968f
C62 X a_2564_n392# 0.02405f
C63 X a_7002_n26# 0.05436f
C64 a_8841_344# CP1 1.6462f
C65 a_766_n26# CP2 0.84833f
C66 X SEL8 0
C67 VB a_706_n392# 0.03761f
C68 VB a_6142_n26# 0.00994f
C69 SEL10 SEL9 0.01746f
C70 VB a_8800_n392# 0.04127f
C71 VB a_4344_n26# 0.00968f
C72 a_422_n392# CP1 0.00285f
C73 VB a_3484_n26# 0.00968f
C74 SEL8 SEL7 0.02034f
C75 CP1 a_2564_n392# 0.00253f
C76 CP1 a_7002_n26# 1.59692f
C77 a_766_n26# VB 0.00968f
C78 X SEL10 0.00115f
C79 a_1626_n26# a_2624_n26# 0.09953f
C80 X a_6942_n392# 0.02463f
C81 CP1 SEL8 0.00484f
C82 a_7002_n26# a_7802_n392# 0
C83 CP2 a_8841_344# 1.74207f
C84 a_198_n26# a_138_n392# 0.007f
C85 X SEL4 0
C86 SEL8 a_7802_n392# 0
C87 a_6942_n392# SEL7 0
C88 a_422_n392# CP2 0
C89 X a_138_n392# 0.02118f
C90 X SEL5 0
C91 SEL2 SEL1 0.06585f
C92 X a_6082_n392# 0.02263f
C93 CP2 a_7002_n26# 1.65079f
C94 CP1 SEL10 0.00484f
C95 CP1 a_6942_n392# 0.00253f
C96 VB a_8841_344# 0.1916f
C97 CP1 SEL4 0.00484f
C98 X SEL1 0
C99 a_766_n26# a_1626_n26# 0.21441f
C100 a_6082_n392# SEL7 0.0031f
C101 a_6942_n392# a_7802_n392# 0.00645f
C102 VB a_422_n392# 0.03612f
C103 a_138_n392# CP1 0.00285f
C104 CP1 SEL5 0.00484f
C105 CP1 a_6082_n392# 0.00253f
C106 VB a_2564_n392# 0.03918f
C107 VB a_7002_n26# 0.42485f
C108 a_4344_n26# a_4284_n392# 0.0077f
C109 CP1 SEL1 0.00488f
C110 VB SEL8 0.00233f
C111 a_3484_n26# a_4284_n392# 0
C112 a_3484_n26# a_2624_n26# 0.41441f
C113 SEL3 SEL2 0.02034f
C114 CP2 a_138_n392# 0
C115 a_6142_n26# a_4344_n26# 0.1807f
C116 X SEL3 0
C117 VB SEL10 0.00233f
C118 X a_3424_n392# 0.02463f
C119 VB a_6942_n392# 0.03912f
C120 a_1626_n26# a_2564_n392# 0
C121 a_4344_n26# a_3484_n26# 0.41441f
C122 VB SEL4 0.00233f
C123 CP2 SEL1 0
C124 a_766_n26# a_706_n392# 0.00752f
C125 SEL2 a_1566_n392# 0
C126 a_422_n392# SEL0 0
C127 VB a_138_n392# 0.03482f
C128 VB SEL5 0.00233f
C129 VB a_6082_n392# 0.03941f
C130 CP1 a_3424_n392# 0.00253f
C131 CP1 SEL3 0.00485f
C132 X a_1566_n392# 0.02463f
C133 X SEL6 0
C134 VB SEL1 0.00233f
C135 a_8800_n392# a_8841_344# 0.0041f
C136 a_2624_n26# a_2564_n392# 0.0077f
C137 a_706_n392# a_422_n392# 0.01981f
C138 CP1 a_1566_n392# 0.00262f
C139 CP1 SEL6 0.00484f
C140 CP2 SEL3 0
C141 a_6142_n26# a_7002_n26# 0.41492f
C142 a_198_n26# a_482_n26# 0.06153f
C143 a_138_n392# SEL0 0.0031f
C144 X a_482_n26# 0.04608f
C145 VB SEL3 0.00233f
C146 VB a_3424_n392# 0.03909f
C147 CP2 a_1566_n392# 0
C148 a_2624_n26# SEL4 0.00749f
C149 SEL1 SEL0 0.06585f
C150 a_4284_n392# SEL5 0
C151 a_6142_n26# a_6942_n392# 0
C152 a_8800_n392# SEL10 0.0031f
C153 CP1 a_482_n26# 0.08765f
C154 VB a_1566_n392# 0.03918f
C155 VB SEL6 0.00233f
C156 a_6142_n26# a_6082_n392# 0.0077f
C157 a_1626_n26# SEL3 0.00746f
C158 a_3484_n26# SEL5 0.00749f
C159 X SEL9 0
C160 a_706_n392# SEL1 0
C161 X a_198_n26# 0.04186f
C162 CP2 a_482_n26# 0.03091f
C163 X SEL2 0
C164 a_7002_n26# SEL8 0.00749f
C165 a_1626_n26# a_1566_n392# 0.00752f
C166 a_8841_344# SEL10 0.00536f
C167 CP1 SEL9 0.00484f
C168 a_4284_n392# a_3424_n392# 0.00645f
C169 a_198_n26# CP1 0.09188f
C170 X SEL7 0
C171 a_7802_n392# SEL9 0.0031f
C172 VB a_482_n26# 0.00968f
C173 CP1 SEL2 0.00485f
C174 a_2624_n26# a_3424_n392# 0
C175 a_7002_n26# a_6942_n392# 0.0077f
C176 SEL4 a_2564_n392# 0.0031f
C177 X CP1 0.45166f
C178 a_422_n392# a_138_n392# 0.01981f
C179 SEL8 a_6942_n392# 0.0031f
C180 a_4284_n392# SEL6 0.0031f
C181 X a_7802_n392# 0.02463f
C182 CP1 SEL7 0.00484f
C183 a_3484_n26# a_3424_n392# 0.0077f
C184 a_422_n392# SEL1 0.0031f
C185 a_198_n26# CP2 0.03091f
C186 CP2 SEL2 0
C187 a_706_n392# a_1566_n392# 0.00645f
C188 X CP2 0.00173f
C189 VB SEL9 0.01644f
C190 CP1 a_7802_n392# 0.00253f
C191 a_4344_n26# SEL6 0.00749f
C192 VB a_198_n26# 0.00968f
C193 VB SEL2 0.00233f
C194 CP2 GND 2.687f
C195 CP1 GND 2.71592f
C196 SEL10 GND 0.36043f
C197 SEL9 GND 0.32888f
C198 SEL8 GND 0.32985f
C199 SEL7 GND 0.3551f
C200 SEL6 GND 0.3551f
C201 SEL5 GND 0.32985f
C202 SEL4 GND 0.33305f
C203 SEL3 GND 0.33305f
C204 SEL2 GND 0.29806f
C205 SEL1 GND 0.26622f
C206 SEL0 GND 0.32386f
C207 X GND 7.30222f
C208 VB GND 5.26714f
C209 a_8800_n392# GND 0.23072f
C210 a_7802_n392# GND 0.20382f
C211 a_6942_n392# GND 0.21458f
C212 a_6082_n392# GND 0.23397f
C213 a_4284_n392# GND 0.22343f
C214 a_3424_n392# GND 0.21458f
C215 a_2564_n392# GND 0.2234f
C216 a_1566_n392# GND 0.21578f
C217 a_706_n392# GND 0.19256f
C218 a_422_n392# GND 0.17891f
C219 a_138_n392# GND 0.22809f
C220 a_8841_344# GND 1.59848f
C221 a_7002_n26# GND 1.5347f
C222 a_6142_n26# GND 1.58758f
C223 a_4344_n26# GND 2.5574f
C224 a_3484_n26# GND 1.48035f
C225 a_2624_n26# GND 1.5941f
C226 a_1626_n26# GND 1.22492f
C227 a_766_n26# GND 1.25299f
C228 a_482_n26# GND 0.48106f
C229 a_198_n26# GND 0.53747f
.ends
