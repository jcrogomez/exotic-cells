* NGSPICE file created from xc14fg.ext - technology: sky130A

.subckt xc14fg SEL0 SEL1 SEL2 SEL3 SEL4 SEL5 SEL6 SEL7 SEL8 SEL9 SEL10 X VB GND CP1
+ CP2
X0 X a_3484_n26# a_3424_n392# GND sky130_fd_pr__nfet_g5v0d10v5 ad=0.126 pd=1.44 as=0.126 ps=1.44 w=0.42 l=0.5
X1 X a_766_n26# a_706_n392# GND sky130_fd_pr__nfet_g5v0d10v5 ad=0.126 pd=1.44 as=0.126 ps=1.44 w=0.42 l=0.5
X2 GND SEL9 a_7802_n392# GND sky130_fd_pr__nfet_01v8 ad=0.252 pd=2.28 as=0.252 ps=2.28 w=0.84 l=0.15
X3 X a_7002_n26# a_6942_n392# GND sky130_fd_pr__nfet_g5v0d10v5 ad=0.126 pd=1.44 as=0.126 ps=1.44 w=0.42 l=0.5
X4 X a_198_n26# a_138_n392# GND sky130_fd_pr__nfet_g5v0d10v5 ad=0.126 pd=1.44 as=0.126 ps=1.44 w=0.42 l=0.5
X5 GND SEL3 a_1566_n392# GND sky130_fd_pr__nfet_01v8 ad=0.252 pd=2.28 as=0.252 ps=2.28 w=0.84 l=0.15
X6 GND SEL2 a_706_n392# GND sky130_fd_pr__nfet_01v8 ad=0.252 pd=2.28 as=0.252 ps=2.28 w=0.84 l=0.15
X7 GND SEL5 a_3424_n392# GND sky130_fd_pr__nfet_01v8 ad=0.252 pd=2.28 as=0.252 ps=2.28 w=0.84 l=0.15
X8 GND SEL0 a_138_n392# GND sky130_fd_pr__nfet_01v8 ad=0.252 pd=2.28 as=0.252 ps=2.28 w=0.84 l=0.15
X9 X VB a_7802_n392# GND sky130_fd_pr__nfet_g5v0d10v5 ad=0.126 pd=1.44 as=0.126 ps=1.44 w=0.42 l=0.5
X10 X a_1626_n26# a_1566_n392# GND sky130_fd_pr__nfet_g5v0d10v5 ad=0.126 pd=1.44 as=0.126 ps=1.44 w=0.42 l=0.5
X11 X a_6142_n26# a_6082_n392# GND sky130_fd_pr__nfet_g5v0d10v5 ad=0.126 pd=1.44 as=0.126 ps=1.44 w=0.42 l=0.5
X12 GND SEL1 a_422_n392# GND sky130_fd_pr__nfet_01v8 ad=0.252 pd=2.28 as=0.252 ps=2.28 w=0.84 l=0.15
X13 GND SEL7 a_6082_n392# GND sky130_fd_pr__nfet_01v8 ad=0.252 pd=2.28 as=0.252 ps=2.28 w=0.84 l=0.15
X14 GND SEL10 a_8800_n392# GND sky130_fd_pr__nfet_01v8 ad=0.252 pd=2.28 as=0.252 ps=2.28 w=0.84 l=0.15
X15 X a_482_n26# a_422_n392# GND sky130_fd_pr__nfet_g5v0d10v5 ad=0.126 pd=1.44 as=0.126 ps=1.44 w=0.42 l=0.5
X16 GND SEL6 a_4284_n392# GND sky130_fd_pr__nfet_01v8 ad=0.252 pd=2.28 as=0.252 ps=2.28 w=0.84 l=0.15
X17 GND a_7002_n26# sky130_fd_pr__diode_pw2nd_05v5 perim=1.8e+06 area=2.025e+11
X18 GND SEL4 a_2564_n392# GND sky130_fd_pr__nfet_01v8 ad=0.252 pd=2.28 as=0.252 ps=2.28 w=0.84 l=0.15
X19 X a_4344_n26# a_4284_n392# GND sky130_fd_pr__nfet_g5v0d10v5 ad=0.126 pd=1.44 as=0.126 ps=1.44 w=0.42 l=0.5
X20 X a_8841_292# a_8800_n392# GND sky130_fd_pr__nfet_01v8 ad=0.126 pd=1.44 as=0.126 ps=1.44 w=0.42 l=0.15
X21 GND SEL8 a_6942_n392# GND sky130_fd_pr__nfet_01v8 ad=0.252 pd=2.28 as=0.252 ps=2.28 w=0.84 l=0.15
X22 X a_2624_n26# a_2564_n392# GND sky130_fd_pr__nfet_g5v0d10v5 ad=0.126 pd=1.44 as=0.126 ps=1.44 w=0.42 l=0.5
X23 GND a_6142_n26# sky130_fd_pr__diode_pw2nd_05v5 perim=1.8e+06 area=2.025e+11
C0 a_8841_292# SEL10 0.00546f
C1 SEL3 X 0
C2 a_1626_n26# CP1 0.9888f
C3 CP1 a_706_n392# 0.00307f
C4 CP1 a_8800_n392# 0.00297f
C5 CP2 a_482_n26# 0.03091f
C6 a_766_n26# CP2 0.84833f
C7 a_198_n26# a_482_n26# 0.05701f
C8 a_138_n392# CP1 0.00334f
C9 SEL7 a_6942_n392# 0
C10 X VB 2.03277f
C11 a_422_n392# SEL1 0.0031f
C12 a_4344_n26# SEL6 0.00738f
C13 SEL10 SEL9 0.01746f
C14 SEL5 X 0
C15 CP1 CP2 50.2364f
C16 a_1626_n26# CP2 0.84269f
C17 a_4284_n392# VB 0.03941f
C18 a_706_n392# CP2 0
C19 SEL8 VB 0.00233f
C20 CP1 a_198_n26# 0.09159f
C21 a_4284_n392# SEL5 0
C22 a_2624_n26# a_3424_n392# 0
C23 CP1 a_6942_n392# 0.00297f
C24 SEL2 SEL3 0.02034f
C25 a_138_n392# CP2 0
C26 a_7002_n26# a_7802_n392# 0
C27 SEL7 X 0
C28 a_482_n26# X 0.11266f
C29 a_2564_n392# SEL4 0.0031f
C30 a_138_n392# a_198_n26# 0.00715f
C31 a_766_n26# X 0.37385f
C32 SEL2 VB 0.00233f
C33 SEL8 SEL7 0.02034f
C34 a_198_n26# CP2 0.03091f
C35 a_3484_n26# VB 0.0097f
C36 CP1 X 0.93259f
C37 a_1626_n26# X 0.37228f
C38 a_3484_n26# SEL5 0.00738f
C39 SEL4 SEL3 0.01746f
C40 a_706_n392# X 0.04316f
C41 a_8800_n392# X 0.03486f
C42 CP1 a_4284_n392# 0.00297f
C43 CP1 SEL8 0.00519f
C44 a_138_n392# X 0.02118f
C45 a_6142_n26# a_7002_n26# 0.41382f
C46 SEL4 VB 0.00233f
C47 a_766_n26# SEL2 0.00736f
C48 CP2 X 0.04297f
C49 SEL4 SEL5 0.02034f
C50 SEL0 VB 0.00233f
C51 a_198_n26# X 0.10844f
C52 a_6942_n392# X 0.02463f
C53 CP1 SEL2 0.00521f
C54 a_706_n392# SEL2 0.0031f
C55 CP1 a_3484_n26# 1.59653f
C56 a_4344_n26# a_6142_n26# 0.1807f
C57 SEL8 a_6942_n392# 0.0031f
C58 CP2 SEL2 0
C59 CP1 SEL4 0.00519f
C60 CP2 a_3484_n26# 1.65079f
C61 CP1 SEL0 0.00524f
C62 a_4284_n392# X 0.02463f
C63 SEL6 VB 0.00233f
C64 SEL8 X 0
C65 SEL5 SEL6 0.02034f
C66 a_422_n392# VB 0.03612f
C67 a_8841_292# VB 0.19072f
C68 a_138_n392# SEL0 0.0031f
C69 CP2 SEL0 0
C70 SEL2 X 0
C71 a_2564_n392# a_3424_n392# 0.00645f
C72 a_198_n26# SEL0 0.0073f
C73 SEL9 VB 0.01633f
C74 a_3484_n26# X 0.37238f
C75 a_422_n392# a_482_n26# 0.00715f
C76 a_2564_n392# a_2624_n26# 0.00801f
C77 a_4284_n392# a_3484_n26# 0
C78 CP1 SEL6 0.00519f
C79 a_422_n392# CP1 0.00334f
C80 CP1 a_8841_292# 1.64611f
C81 a_2564_n392# a_1566_n392# 0.00555f
C82 a_422_n392# a_706_n392# 0.01981f
C83 a_7802_n392# VB 0.07499f
C84 a_8800_n392# a_8841_292# 0.00443f
C85 SEL4 X 0
C86 a_6142_n26# a_6082_n392# 0.00801f
C87 SEL0 X 0
C88 a_422_n392# a_138_n392# 0.01981f
C89 a_3424_n392# VB 0.03909f
C90 SEL5 a_3424_n392# 0.0031f
C91 a_1566_n392# SEL3 0.0031f
C92 a_2624_n26# VB 0.0097f
C93 a_422_n392# CP2 0
C94 CP1 SEL9 0.00519f
C95 CP2 a_8841_292# 1.74207f
C96 a_8800_n392# SEL9 0
C97 a_422_n392# a_198_n26# 0.00116f
C98 a_6142_n26# VB 0.01003f
C99 a_1566_n392# VB 0.03918f
C100 a_7002_n26# VB 0.42385f
C101 SEL10 VB 0.00233f
C102 CP1 a_7802_n392# 0.00297f
C103 a_8800_n392# a_7802_n392# 0.00386f
C104 SEL6 X 0
C105 a_422_n392# X 0.04316f
C106 a_8841_292# X 0.34961f
C107 CP1 a_3424_n392# 0.00297f
C108 SEL7 a_6142_n26# 0.00738f
C109 CP1 a_2624_n26# 1.63414f
C110 a_1626_n26# a_2624_n26# 0.09861f
C111 a_4284_n392# SEL6 0.0031f
C112 SEL1 VB 0.00233f
C113 a_766_n26# a_1566_n392# 0
C114 a_4344_n26# VB 0.0097f
C115 CP1 a_6142_n26# 1.62731f
C116 a_6942_n392# a_7802_n392# 0.00645f
C117 CP1 a_1566_n392# 0.00307f
C118 SEL9 X 0
C119 a_1626_n26# a_1566_n392# 0.00781f
C120 CP1 a_7002_n26# 1.59663f
C121 a_1566_n392# a_706_n392# 0.00645f
C122 CP1 SEL10 0.00519f
C123 CP2 a_2624_n26# 1.69065f
C124 a_8800_n392# SEL10 0.0031f
C125 SEL1 a_482_n26# 0.0073f
C126 SEL8 SEL9 0.02034f
C127 CP2 a_6142_n26# 1.68024f
C128 a_1566_n392# CP2 0
C129 a_7802_n392# X 0.02463f
C130 CP2 a_7002_n26# 1.65079f
C131 CP1 SEL1 0.00524f
C132 a_6142_n26# a_6942_n392# 0
C133 CP1 a_4344_n26# 3.14075f
C134 a_706_n392# SEL1 0
C135 a_7002_n26# a_6942_n392# 0.00801f
C136 a_3424_n392# X 0.02463f
C137 SEL8 a_7802_n392# 0
C138 a_2624_n26# X 0.37246f
C139 a_422_n392# SEL0 0
C140 a_2564_n392# SEL3 0
C141 a_4284_n392# a_3424_n392# 0.00645f
C142 CP2 SEL1 0
C143 CP2 a_4344_n26# 3.25629f
C144 a_6142_n26# X 0.38102f
C145 a_1566_n392# X 0.02463f
C146 a_7002_n26# X 0.38073f
C147 a_2564_n392# VB 0.03918f
C148 SEL10 X 0.00115f
C149 a_6082_n392# VB 0.03941f
C150 SEL8 a_7002_n26# 0.00738f
C151 a_3484_n26# a_3424_n392# 0.00801f
C152 a_3484_n26# a_2624_n26# 0.41332f
C153 SEL3 VB 0.00233f
C154 SEL1 X 0
C155 a_4344_n26# X 0.69296f
C156 a_1566_n392# SEL2 0
C157 SEL7 a_6082_n392# 0.0031f
C158 SEL4 a_3424_n392# 0
C159 a_4344_n26# a_4284_n392# 0.00801f
C160 SEL4 a_2624_n26# 0.00738f
C161 CP1 a_2564_n392# 0.00297f
C162 SEL5 VB 0.00233f
C163 a_1626_n26# a_2564_n392# 0
C164 CP1 a_6082_n392# 0.00297f
C165 SEL1 SEL2 0.06585f
C166 CP1 SEL3 0.00521f
C167 SEL7 VB 0.00233f
C168 a_1626_n26# SEL3 0.00736f
C169 a_482_n26# VB 0.0097f
C170 a_4344_n26# a_3484_n26# 0.41332f
C171 a_766_n26# VB 0.0097f
C172 CP1 VB 1.6873f
C173 a_1626_n26# VB 0.0097f
C174 a_6082_n392# a_6942_n392# 0.00645f
C175 CP1 SEL5 0.00519f
C176 a_706_n392# VB 0.03761f
C177 a_8800_n392# VB 0.04127f
C178 CP2 SEL3 0
C179 SEL1 SEL0 0.06585f
C180 a_138_n392# VB 0.03482f
C181 a_766_n26# a_482_n26# 0.05701f
C182 a_2564_n392# X 0.02405f
C183 a_7802_n392# SEL9 0.0031f
C184 CP2 VB 1.68126f
C185 CP1 SEL7 0.00519f
C186 CP1 a_482_n26# 0.08736f
C187 a_6082_n392# X 0.02263f
C188 a_706_n392# a_482_n26# 0.00116f
C189 a_766_n26# CP1 0.99492f
C190 a_198_n26# VB 0.0097f
C191 a_1626_n26# a_766_n26# 0.21332f
C192 a_6942_n392# VB 0.03912f
C193 a_766_n26# a_706_n392# 0.00781f
C194 CP2 GND 2.64495f
C195 CP1 GND 2.21515f
C196 SEL10 GND 0.36022f
C197 SEL9 GND 0.32881f
C198 SEL8 GND 0.32981f
C199 SEL7 GND 0.35505f
C200 SEL6 GND 0.35506f
C201 SEL5 GND 0.32981f
C202 SEL4 GND 0.33301f
C203 SEL3 GND 0.33301f
C204 SEL2 GND 0.29792f
C205 SEL1 GND 0.26598f
C206 SEL0 GND 0.32312f
C207 X GND 2.1287f
C208 VB GND 4.86982f
C209 a_8800_n392# GND 0.23047f
C210 a_7802_n392# GND 0.20358f
C211 a_6942_n392# GND 0.21433f
C212 a_6082_n392# GND 0.23373f
C213 a_4284_n392# GND 0.22318f
C214 a_3424_n392# GND 0.21433f
C215 a_2564_n392# GND 0.22315f
C216 a_1566_n392# GND 0.21553f
C217 a_706_n392# GND 0.19187f
C218 a_422_n392# GND 0.17765f
C219 a_138_n392# GND 0.22151f
C220 a_8841_292# GND 1.22824f
C221 a_7002_n26# GND 1.14773f
C222 a_6142_n26# GND 1.19927f
C223 a_4344_n26# GND 1.84067f
C224 a_3484_n26# GND 1.096f
C225 a_2624_n26# GND 1.20951f
C226 a_1626_n26# GND 0.84033f
C227 a_766_n26# GND 0.87192f
C228 a_482_n26# GND 0.36805f
C229 a_198_n26# GND 0.41578f
.ends
