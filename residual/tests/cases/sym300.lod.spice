* NGSPICE file created from sym300.ext - technology: sky130A

.subckt sym300
X0 a_630_0# a_600_n26# a_0_0# VSUBS sky130_fd_pr__nfet_01v8 ad=1.26 pd=6.84 as=1.26 ps=6.84 w=0.42 l=0.15 sa=3 sb=3
.ends
