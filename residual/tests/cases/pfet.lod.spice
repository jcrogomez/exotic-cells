* NGSPICE file created from pfet.ext - technology: sky130A

.subckt pfet
X0 a_90_0# a_60_n26# a_0_0# w_n100_n100# sky130_fd_pr__pfet_01v8 ad=0.252 pd=2.04 as=0.126 ps=1.44 w=0.42 l=0.15 sa=0.3 sb=0.6
.ends
