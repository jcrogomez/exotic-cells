* NGSPICE file created from twofinger.ext - technology: sky130A

.subckt twofinger
X0 a_110_0# a_80_n26# a_0_0# VSUBS sky130_fd_pr__nfet_01v8 ad=0.084 pd=0.82 as=0.168 ps=1.64 w=0.42 l=0.15
X1 a_220_0# a_190_n26# a_110_0# VSUBS sky130_fd_pr__nfet_01v8 ad=0.168 pd=1.64 as=0.084 ps=0.82 w=0.42 l=0.15
.ends
