* NGSPICE file created from twins.ext - technology: sky130A

.subckt twins
X0 a_90_0# a_60_n26# a_n140_200# VSUBS sky130_fd_pr__nfet_01v8 ad=0.42 pd=2.84 as=0.42 ps=2.84 w=0.42 l=0.15
X1 a_90_0# a_60_n26# a_n140_200# VSUBS sky130_fd_pr__nfet_01v8 ad=0.126 pd=1.44 as=0.126 ps=1.44 w=0.42 l=0.15
.ends
