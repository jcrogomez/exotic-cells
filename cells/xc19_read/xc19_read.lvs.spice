* NGSPICE file created from xc19_read.ext - technology: sky130A

.subckt xc19_read VB PRE X VDD GND
X0 X VB GND GND sky130_fd_pr__nfet_01v8 ad=0.126 pd=1.44 as=0.126 ps=1.44 w=0.42 l=0.15
X1 X PRE VDD VDD sky130_fd_pr__pfet_01v8_hvt ad=0.126 pd=1.44 as=0.126 ps=1.44 w=0.42 l=0.5
.ends
