* xc19_slot_core (enmienda 2: inversor hvt + unidad MOS): esquematico de referencia para LVS, escrito a mano desde el diseño (prerregistro MISFIT-03 + enmienda 1),
* no desde la extraccion. Placas (S1, S2, CAL) son capacidades de metal: no entran en el LVS.
.subckt xc19_slot_core XB_OUT REFB SB0B SB1B XA_OUT REFA SA0B SA1B SA2B VDD GND VBIAS C1 PREA XA DUTA PREB XB DUTB VB CALA CALB
X0 VBIAS VBIAS C1 GND sky130_fd_pr__nfet_01v8 w=1 l=1
X1 C1 C1 C2 GND sky130_fd_pr__nfet_01v8 w=1 l=1
X2 C2 C2 VB GND sky130_fd_pr__nfet_01v8 w=1 l=1
X3 VB VB GND GND sky130_fd_pr__nfet_01v8 w=0.42 l=0.15
X4 VB VB GND GND sky130_fd_pr__nfet_01v8 w=0.42 l=0.15
X5 VB VB GND GND sky130_fd_pr__nfet_01v8 w=0.42 l=0.15
X6 VB VB GND GND sky130_fd_pr__nfet_01v8 w=0.42 l=0.15
X7 VB VB GND GND sky130_fd_pr__nfet_01v8 w=0.42 l=0.15
X8 VB VB GND GND sky130_fd_pr__nfet_01v8 w=0.42 l=0.15
X9 VB VB GND GND sky130_fd_pr__nfet_01v8 w=0.42 l=0.15
X10 VB VB GND GND sky130_fd_pr__nfet_01v8 w=0.42 l=0.15
X11 VB VB GND GND sky130_fd_pr__nfet_01v8 w=0.42 l=0.15
X12 VB VB GND GND sky130_fd_pr__nfet_01v8 w=0.42 l=0.15
X13 VB VB GND GND sky130_fd_pr__nfet_01v8 w=0.42 l=0.15
X14 VB VB GND GND sky130_fd_pr__nfet_01v8 w=0.42 l=0.15
X15 VB VB GND GND sky130_fd_pr__nfet_01v8 w=0.42 l=0.15
X16 VB VB GND GND sky130_fd_pr__nfet_01v8 w=0.42 l=0.15
X17 VB VB GND GND sky130_fd_pr__nfet_01v8 w=0.42 l=0.15
X18 VB VB GND GND sky130_fd_pr__nfet_01v8 w=0.42 l=0.15
X19 GND VB GND GND sky130_fd_pr__nfet_01v8 w=5.5 l=10
X20 GND VB GND GND sky130_fd_pr__nfet_01v8 w=5.5 l=10
X21 GND VB GND GND sky130_fd_pr__nfet_01v8 w=5.5 l=10
X22 GND VB GND GND sky130_fd_pr__nfet_01v8 w=5.5 l=10
X23 GND VB GND GND sky130_fd_pr__nfet_01v8 w=5.5 l=10
X24 GND VB GND GND sky130_fd_pr__nfet_01v8 w=5.5 l=10
X25 GND VB GND GND sky130_fd_pr__nfet_01v8 w=5.5 l=10
X26 GND VB GND GND sky130_fd_pr__nfet_01v8 w=5.5 l=10
X27 GND VB GND GND sky130_fd_pr__nfet_01v8 w=5.5 l=10
X28 GND VB GND GND sky130_fd_pr__nfet_01v8 w=5.5 l=10
X29 GND VB GND GND sky130_fd_pr__nfet_01v8 w=5.5 l=10
X30 GND VB GND GND sky130_fd_pr__nfet_01v8 w=5.5 l=10
X31 GND VB GND GND sky130_fd_pr__nfet_01v8 w=5.5 l=10
X32 GND VB GND GND sky130_fd_pr__nfet_01v8 w=5.5 l=10
X33 GND VB GND GND sky130_fd_pr__nfet_01v8 w=5.5 l=10
X34 GND VB GND GND sky130_fd_pr__nfet_01v8 w=5.5 l=10
X35 GND VB GND GND sky130_fd_pr__nfet_01v8 w=5.5 l=10
X36 GND VB GND GND sky130_fd_pr__nfet_01v8 w=5.5 l=10
X37 GND VB GND GND sky130_fd_pr__nfet_01v8 w=5.5 l=10
X38 GND VB GND GND sky130_fd_pr__nfet_01v8 w=5.5 l=10
X39 GND VB GND GND sky130_fd_pr__nfet_01v8 w=5.5 l=10
X40 GND VB GND GND sky130_fd_pr__nfet_01v8 w=5.5 l=10
X41 GND VB GND GND sky130_fd_pr__nfet_01v8 w=5.5 l=10
X42 GND VB GND GND sky130_fd_pr__nfet_01v8 w=5.5 l=10
X43 GND VB GND GND sky130_fd_pr__nfet_01v8 w=5.5 l=10
X44 GND VB GND GND sky130_fd_pr__nfet_01v8 w=5.5 l=10
X45 GND VB GND GND sky130_fd_pr__nfet_01v8 w=5.5 l=10
X46 GND VB GND GND sky130_fd_pr__nfet_01v8 w=5.5 l=10
X47 GND VB GND GND sky130_fd_pr__nfet_01v8 w=5.5 l=10
X48 GND VB GND GND sky130_fd_pr__nfet_01v8 w=5.5 l=10
X49 GND VB GND GND sky130_fd_pr__nfet_01v8 w=5.5 l=10
X50 GND VB GND GND sky130_fd_pr__nfet_01v8 w=5.5 l=10
X51 GND VB GND GND sky130_fd_pr__nfet_01v8 w=5.5 l=10
X52 XA PREA VDD VDD sky130_fd_pr__pfet_01v8_hvt w=0.42 l=0.5
X53 XA VB S_A GND sky130_fd_pr__nfet_01v8 w=0.42 l=0.15
X54 S_A DUTA GND GND sky130_fd_pr__nfet_01v8 w=0.84 l=0.15
X55 GND XA GND GND sky130_fd_pr__nfet_01v8 w=4.3 l=4
X56 XA VB M_A GND sky130_fd_pr__nfet_01v8 w=0.42 l=0.15
X57 M_A VB SR_A GND sky130_fd_pr__nfet_01v8 w=0.42 l=0.15
X58 XA VB M_A GND sky130_fd_pr__nfet_01v8 w=0.42 l=0.15
X59 M_A VB SR_A GND sky130_fd_pr__nfet_01v8 w=0.42 l=0.15
X60 XA VB M_A GND sky130_fd_pr__nfet_01v8 w=0.42 l=0.15
X61 M_A VB SR_A GND sky130_fd_pr__nfet_01v8 w=0.42 l=0.15
X62 XA VB M_A GND sky130_fd_pr__nfet_01v8 w=0.42 l=0.15
X63 M_A VB SR_A GND sky130_fd_pr__nfet_01v8 w=0.42 l=0.15
X64 XA VB M_A GND sky130_fd_pr__nfet_01v8 w=0.42 l=0.15
X65 M_A VB SR_A GND sky130_fd_pr__nfet_01v8 w=0.42 l=0.15
X66 XA VB M_A GND sky130_fd_pr__nfet_01v8 w=0.42 l=0.15
X67 M_A VB SR_A GND sky130_fd_pr__nfet_01v8 w=0.42 l=0.15
X68 SR_A REFA GND GND sky130_fd_pr__nfet_01v8 w=0.84 l=0.15
X69 XA SA0B P0_A VDD sky130_fd_pr__pfet_01v8 w=0.42 l=0.15
X70 XA SA1B P1_A VDD sky130_fd_pr__pfet_01v8 w=0.42 l=0.15
X71 XA SA2B P2_A VDD sky130_fd_pr__pfet_01v8 w=0.42 l=0.15
X72 XA_OUT XA GND GND sky130_fd_pr__nfet_01v8 w=0.65 l=0.15
X73 XA_OUT XA VDD VDD sky130_fd_pr__pfet_01v8_hvt w=1 l=0.15
X74 XB PREB VDD VDD sky130_fd_pr__pfet_01v8_hvt w=0.42 l=0.5
X75 XB VB S_B GND sky130_fd_pr__nfet_01v8 w=0.42 l=0.15
X76 S_B DUTB GND GND sky130_fd_pr__nfet_01v8 w=0.84 l=0.15
X77 GND XB GND GND sky130_fd_pr__nfet_01v8 w=4.3 l=4
X78 XB VB M_B GND sky130_fd_pr__nfet_01v8 w=0.42 l=0.15
X79 M_B VB SR_B GND sky130_fd_pr__nfet_01v8 w=0.42 l=0.15
X80 XB VB M_B GND sky130_fd_pr__nfet_01v8 w=0.42 l=0.15
X81 M_B VB SR_B GND sky130_fd_pr__nfet_01v8 w=0.42 l=0.15
X82 XB VB M_B GND sky130_fd_pr__nfet_01v8 w=0.42 l=0.15
X83 M_B VB SR_B GND sky130_fd_pr__nfet_01v8 w=0.42 l=0.15
X84 XB VB M_B GND sky130_fd_pr__nfet_01v8 w=0.42 l=0.15
X85 M_B VB SR_B GND sky130_fd_pr__nfet_01v8 w=0.42 l=0.15
X86 XB VB M_B GND sky130_fd_pr__nfet_01v8 w=0.42 l=0.15
X87 M_B VB SR_B GND sky130_fd_pr__nfet_01v8 w=0.42 l=0.15
X88 XB VB M_B GND sky130_fd_pr__nfet_01v8 w=0.42 l=0.15
X89 M_B VB SR_B GND sky130_fd_pr__nfet_01v8 w=0.42 l=0.15
X90 SR_B REFB GND GND sky130_fd_pr__nfet_01v8 w=0.84 l=0.15
X91 XB SB0B P0_B VDD sky130_fd_pr__pfet_01v8 w=0.42 l=0.15
X92 XB SB1B P1_B VDD sky130_fd_pr__pfet_01v8 w=0.42 l=0.15
X93 XB VDD P2_B VDD sky130_fd_pr__pfet_01v8 w=0.42 l=0.15
X94 XB_OUT XB GND GND sky130_fd_pr__nfet_01v8 w=0.65 l=0.15
X95 XB_OUT XB VDD VDD sky130_fd_pr__pfet_01v8_hvt w=1 l=0.15
* MISFIT-03 enmienda 2: unidad MOS en cada nodo de placa (S1, S2 de A y de B)
XMUP1_A GND P1_A GND GND sky130_fd_pr__nfet_01v8 w=0.42 l=0.3
XMUP2_A GND P2_A GND GND sky130_fd_pr__nfet_01v8 w=0.42 l=0.3
XMUP1_B GND P1_B GND GND sky130_fd_pr__nfet_01v8 w=0.42 l=0.3
XMUP2_B GND P2_B GND GND sky130_fd_pr__nfet_01v8 w=0.42 l=0.3
.ends
